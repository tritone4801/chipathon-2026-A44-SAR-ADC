* A44_A mixed-signal LVS: analog circuits and top-level connections.
* SAR_LOGIC_ACTUAL_RTL_SS is supplied by ../verilog/SAR_LOGIC_ACTUAL_RTL_SS.pnl.v.
* Standard-cell transistor definitions are supplied by the included PDK LVS configuration.
* XSAR order: CLKS CMPCK DCMPN DCMPP VDD VSS DCTRLN[7:1] DCTRLP[7:1] DOUT[7:0].

.subckt A44_Comparator_StrongARM CLK DCMPP VINP DCMPN VINN VDD GND

*.ipin CLK
*.ipin VINP
*.ipin VINN
*.opin DCMPP
*.opin DCMPN
*.iopin VDD
*.iopin GND
XCOMP_TAIL net1 CLK GND GND nfet_03v3 L=0.28u W=1.56u nf=1 ad='int((nf+1)/2) * W/nf * 0.18u' as='int((nf+2)/2) * W/nf * 0.18u' pd='2*int((nf+1)/2) * (W/nf + 0.18u)'
+ ps='2*int((nf+2)/2) * (W/nf + 0.18u)' nrd='0.18u / W' nrs='0.18u / W' sa=0 sb=0 sd=0 m=8
XCOMP_RESET_L_BOT XP CLK VDD VDD pfet_03v3 L=0.28u W=1.56u nf=1 ad='int((nf+1)/2) * W/nf * 0.18u' as='int((nf+2)/2) * W/nf * 0.18u'
+ pd='2*int((nf+1)/2) * (W/nf + 0.18u)' ps='2*int((nf+2)/2) * (W/nf + 0.18u)' nrd='0.18u / W' nrs='0.18u / W' sa=0 sb=0 sd=0
XCOMP_INPUT_P XP VINP net1 GND nfet_03v3 L=0.28u W=55.8u nf=1 ad='int((nf+1)/2) * W/nf * 0.18u' as='int((nf+2)/2) * W/nf * 0.18u' pd='2*int((nf+1)/2) * (W/nf + 0.18u)'
+ ps='2*int((nf+2)/2) * (W/nf + 0.18u)' nrd='0.18u / W' nrs='0.18u / W' sa=0 sb=0 sd=0 m=4
XCOMP_INPUT_N net1 VINN XN GND nfet_03v3 L=0.28u W=55.8u nf=1 ad='int((nf+1)/2) * W/nf * 0.18u' as='int((nf+2)/2) * W/nf * 0.18u' pd='2*int((nf+1)/2) * (W/nf + 0.18u)'
+ ps='2*int((nf+2)/2) * (W/nf + 0.18u)' nrd='0.18u / W' nrs='0.18u / W' sa=0 sb=0 sd=0 m=4
XCOMP_LATCH_L_BOT XP LN LP GND nfet_03v3 L=0.28u W=8.2524u nf=1 ad='int((nf+1)/2) * W/nf * 0.18u' as='int((nf+2)/2) * W/nf * 0.18u'
+ pd='2*int((nf+1)/2) * (W/nf + 0.18u)' ps='2*int((nf+2)/2) * (W/nf + 0.18u)' nrd='0.18u / W' nrs='0.18u / W' sa=0 sb=0 sd=0
XCOMP_LATCH_R_BOT LN LP XN GND nfet_03v3 L=0.28u W=8.2524u nf=1 ad='int((nf+1)/2) * W/nf * 0.18u' as='int((nf+2)/2) * W/nf * 0.18u'
+ pd='2*int((nf+1)/2) * (W/nf + 0.18u)' ps='2*int((nf+2)/2) * (W/nf + 0.18u)' nrd='0.18u / W' nrs='0.18u / W' sa=0 sb=0 sd=0
XCOMP_RESET_L_UP LP CLK VDD VDD pfet_03v3 L=0.28u W=16.8587u nf=1 ad='int((nf+1)/2) * W/nf * 0.18u' as='int((nf+2)/2) * W/nf * 0.18u'
+ pd='2*int((nf+1)/2) * (W/nf + 0.18u)' ps='2*int((nf+2)/2) * (W/nf + 0.18u)' nrd='0.18u / W' nrs='0.18u / W' sa=0 sb=0 sd=0
XCOMP_LATCH_L_UP VDD LN LP VDD pfet_03v3 L=0.28u W=4.67u nf=1 ad='int((nf+1)/2) * W/nf * 0.18u' as='int((nf+2)/2) * W/nf * 0.18u' pd='2*int((nf+1)/2) * (W/nf + 0.18u)'
+ ps='2*int((nf+2)/2) * (W/nf + 0.18u)' nrd='0.18u / W' nrs='0.18u / W' sa=0 sb=0 sd=0
XCOMP_LATCH_R_UP LN LP VDD VDD pfet_03v3 L=0.28u W=4.67u nf=1 ad='int((nf+1)/2) * W/nf * 0.18u' as='int((nf+2)/2) * W/nf * 0.18u' pd='2*int((nf+1)/2) * (W/nf + 0.18u)'
+ ps='2*int((nf+2)/2) * (W/nf + 0.18u)' nrd='0.18u / W' nrs='0.18u / W' sa=0 sb=0 sd=0
XCOMP_RESET_R_BOT VDD CLK XN VDD pfet_03v3 L=0.28u W=1.56u nf=1 ad='int((nf+1)/2) * W/nf * 0.18u' as='int((nf+2)/2) * W/nf * 0.18u'
+ pd='2*int((nf+1)/2) * (W/nf + 0.18u)' ps='2*int((nf+2)/2) * (W/nf + 0.18u)' nrd='0.18u / W' nrs='0.18u / W' sa=0 sb=0 sd=0
XCOMP_RESET_R_UP VDD CLK LN VDD pfet_03v3 L=0.28u W=16.8587u nf=1 ad='int((nf+1)/2) * W/nf * 0.18u' as='int((nf+2)/2) * W/nf * 0.18u'
+ pd='2*int((nf+1)/2) * (W/nf + 0.18u)' ps='2*int((nf+2)/2) * (W/nf + 0.18u)' nrd='0.18u / W' nrs='0.18u / W' sa=0 sb=0 sd=0
XCOMP_LN_INV_PMOS DCMPN LN VDD VDD pfet_03v3 L=0.28u W=4.67u nf=1 ad='int((nf+1)/2) * W/nf * 0.18u' as='int((nf+2)/2) * W/nf * 0.18u'
+ pd='2*int((nf+1)/2) * (W/nf + 0.18u)' ps='2*int((nf+2)/2) * (W/nf + 0.18u)' nrd='0.18u / W' nrs='0.18u / W' sa=0 sb=0 sd=0
XCOMP_LN_INV_NMOS DCMPN LN GND GND nfet_03v3 L=0.28u W=1.56u nf=1 ad='int((nf+1)/2) * W/nf * 0.18u' as='int((nf+2)/2) * W/nf * 0.18u'
+ pd='2*int((nf+1)/2) * (W/nf + 0.18u)' ps='2*int((nf+2)/2) * (W/nf + 0.18u)' nrd='0.18u / W' nrs='0.18u / W' sa=0 sb=0 sd=0
XCOMP_LP_INV_PMOS DCMPP LP VDD VDD pfet_03v3 L=0.28u W=4.67u nf=1 ad='int((nf+1)/2) * W/nf * 0.18u' as='int((nf+2)/2) * W/nf * 0.18u'
+ pd='2*int((nf+1)/2) * (W/nf + 0.18u)' ps='2*int((nf+2)/2) * (W/nf + 0.18u)' nrd='0.18u / W' nrs='0.18u / W' sa=0 sb=0 sd=0
XCOMP_LP_INV_NMOS DCMPP LP GND GND nfet_03v3 L=0.28u W=1.56u nf=1 ad='int((nf+1)/2) * W/nf * 0.18u' as='int((nf+2)/2) * W/nf * 0.18u'
+ pd='2*int((nf+1)/2) * (W/nf + 0.18u)' ps='2*int((nf+2)/2) * (W/nf + 0.18u)' nrd='0.18u / W' nrs='0.18u / W' sa=0 sb=0 sd=0
.ends

.subckt A44_CDAC_UNIT_TRANS_DRIVER VIN CLKS VTOP DCTRL[7] DCTRL[6] DCTRL[5] DCTRL[4] DCTRL[3] DCTRL[2] DCTRL[1] VREFP VDD GND
+ VREFN

*.ipin VIN
*.ipin CLKS
*.iopin VDD
*.iopin GND
*.iopin VREFP
*.iopin VREFN
*.iopin VTOP
*.ipin DCTRL[7],DCTRL[6],DCTRL[5],DCTRL[4],DCTRL[3],DCTRL[2],DCTRL[1]
XC8 VTOP GND cap_mim_2f0_m4m5_noshield c_width=6.855e-6 c_length=6.855e-6 m=6
x2 VREFN VREFP VDD GND VTOP DCTRL_DRV[1] A44_C1_SWITCH
x3 VREFN VREFP VDD GND VTOP DCTRL_DRV[2] A44_C2_SWITCH
x4 VREFN VREFP VDD GND VTOP DCTRL_DRV[3] A44_C4_SWITCH
x5 VREFN VREFP VDD GND VTOP DCTRL_DRV[4] A44_C8_SWITCH
x6 VREFN VREFP VDD GND VTOP DCTRL_DRV[5] A44_C16_SWITCH
x8 VREFN VREFP VDD GND VTOP DCTRL_DRV[7] A44_C64_SWITCH
xsample CLKS VDD GND VTOP VIN A44_SWITCH_TRANS_TG8
x1 VREFN VREFP VDD GND VTOP DCTRL_DRV[6] A44_C32_SWITCH
xdrv DCTRL[1] DCTRL_DRV[1] VDD GND DCTRL[2] DCTRL_DRV[2] DCTRL_DRV[3] DCTRL[3] DCTRL_DRV[4] DCTRL[4] DCTRL_DRV[5] DCTRL[5]
+ DCTRL_DRV[6] DCTRL[6] DCTRL_DRV[7] DCTRL[7] A44_CONVERSION_BUFFER
.ends

.subckt A44_CLKS_BUFFER VDD GND CLKS_CORE PAD_CLK

*.ipin PAD_CLK
*.opin CLKS_CORE
*.iopin VDD
*.iopin GND
XCLK_INV1_NMOS INTER_PAD PAD_CLK GND GND nfet_03v3 L=0.28u W=0.78u nf=1 ad='int((nf+1)/2) * W/nf * 0.18u' as='int((nf+2)/2) * W/nf * 0.18u'
+ pd='2*int((nf+1)/2) * (W/nf + 0.18u)' ps='2*int((nf+2)/2) * (W/nf + 0.18u)' nrd='0.18u / W' nrs='0.18u / W' sa=0 sb=0 sd=0
XCLK_INV1_PMOS INTER_PAD PAD_CLK VDD VDD pfet_03v3 L=0.28u W=1.56u nf=1 ad='int((nf+1)/2) * W/nf * 0.18u' as='int((nf+2)/2) * W/nf * 0.18u'
+ pd='2*int((nf+1)/2) * (W/nf + 0.18u)' ps='2*int((nf+2)/2) * (W/nf + 0.18u)' nrd='0.18u / W' nrs='0.18u / W' sa=0 sb=0 sd=0
XCLK_INV2_NMOS CLKS_CORE INTER_PAD GND GND nfet_03v3 L=0.28u W=3.11u nf=1 ad='int((nf+1)/2) * W/nf * 0.18u' as='int((nf+2)/2) * W/nf * 0.18u'
+ pd='2*int((nf+1)/2) * (W/nf + 0.18u)' ps='2*int((nf+2)/2) * (W/nf + 0.18u)' nrd='0.18u / W' nrs='0.18u / W' sa=0 sb=0 sd=0
XCLK_INV2_PMOS CLKS_CORE INTER_PAD VDD VDD pfet_03v3 L=0.28u W=6.22u nf=1 ad='int((nf+1)/2) * W/nf * 0.18u' as='int((nf+2)/2) * W/nf * 0.18u'
+ pd='2*int((nf+1)/2) * (W/nf + 0.18u)' ps='2*int((nf+2)/2) * (W/nf + 0.18u)' nrd='0.18u / W' nrs='0.18u / W' sa=0 sb=0 sd=0
.ends

.subckt A44_C1_SWITCH REF_N REF_P VDD GND UNIT_OUT CTRL
*.iopin REF_N
*.iopin REF_P
*.iopin VDD
*.iopin GND
*.ipin CTRL
*.opin UNIT_OUT
x1 REF_P REF_N CTRL V_BOT VDD GND A44_CAP_SWITCH
XC1 UNIT_OUT V_BOT cap_mim_2f0_m4m5_noshield c_width=6.855e-6 c_length=6.855e-6 m=6
.ends

.subckt A44_C2_SWITCH REF_N REF_P VDD GND UNIT_OUT CTRL
*.iopin REF_N
*.iopin REF_P
*.iopin VDD
*.iopin GND
*.ipin CTRL
*.opin UNIT_OUT
x1 REF_N REF_P VDD GND UNIT_OUT CTRL A44_C1_SWITCH
x2 REF_N REF_P VDD GND UNIT_OUT CTRL A44_C1_SWITCH
.ends

.subckt A44_C4_SWITCH REF_N REF_P VDD GND UNIT_OUT CTRL
*.iopin REF_N
*.iopin REF_P
*.iopin VDD
*.iopin GND
*.ipin CTRL
*.opin UNIT_OUT
x1 REF_N REF_P VDD GND UNIT_OUT CTRL A44_C1_SWITCH
x2 REF_N REF_P VDD GND UNIT_OUT CTRL A44_C1_SWITCH
x3 REF_N REF_P VDD GND UNIT_OUT CTRL A44_C1_SWITCH
x4 REF_N REF_P VDD GND UNIT_OUT CTRL A44_C1_SWITCH
.ends

.subckt A44_C8_SWITCH REF_N REF_P VDD GND UNIT_OUT CTRL
*.iopin REF_N
*.iopin REF_P
*.iopin VDD
*.iopin GND
*.ipin CTRL
*.opin UNIT_OUT
x1 REF_N REF_P VDD GND UNIT_OUT CTRL A44_C1_SWITCH
x2 REF_N REF_P VDD GND UNIT_OUT CTRL A44_C1_SWITCH
x3 REF_N REF_P VDD GND UNIT_OUT CTRL A44_C1_SWITCH
x4 REF_N REF_P VDD GND UNIT_OUT CTRL A44_C1_SWITCH
x5 REF_N REF_P VDD GND UNIT_OUT CTRL A44_C1_SWITCH
x6 REF_N REF_P VDD GND UNIT_OUT CTRL A44_C1_SWITCH
x7 REF_N REF_P VDD GND UNIT_OUT CTRL A44_C1_SWITCH
x8 REF_N REF_P VDD GND UNIT_OUT CTRL A44_C1_SWITCH
.ends

.subckt A44_C16_SWITCH REF_N REF_P VDD GND UNIT_OUT CTRL
*.iopin REF_N
*.iopin REF_P
*.iopin VDD
*.iopin GND
*.ipin CTRL
*.opin UNIT_OUT
x1 REF_N REF_P VDD GND UNIT_OUT CTRL A44_C1_SWITCH
x2 REF_N REF_P VDD GND UNIT_OUT CTRL A44_C1_SWITCH
x3 REF_N REF_P VDD GND UNIT_OUT CTRL A44_C1_SWITCH
x4 REF_N REF_P VDD GND UNIT_OUT CTRL A44_C1_SWITCH
x5 REF_N REF_P VDD GND UNIT_OUT CTRL A44_C1_SWITCH
x6 REF_N REF_P VDD GND UNIT_OUT CTRL A44_C1_SWITCH
x7 REF_N REF_P VDD GND UNIT_OUT CTRL A44_C1_SWITCH
x8 REF_N REF_P VDD GND UNIT_OUT CTRL A44_C1_SWITCH
x9 REF_N REF_P VDD GND UNIT_OUT CTRL A44_C1_SWITCH
x10 REF_N REF_P VDD GND UNIT_OUT CTRL A44_C1_SWITCH
x11 REF_N REF_P VDD GND UNIT_OUT CTRL A44_C1_SWITCH
x12 REF_N REF_P VDD GND UNIT_OUT CTRL A44_C1_SWITCH
x13 REF_N REF_P VDD GND UNIT_OUT CTRL A44_C1_SWITCH
x14 REF_N REF_P VDD GND UNIT_OUT CTRL A44_C1_SWITCH
x15 REF_N REF_P VDD GND UNIT_OUT CTRL A44_C1_SWITCH
x16 REF_N REF_P VDD GND UNIT_OUT CTRL A44_C1_SWITCH
.ends

.subckt A44_C64_SWITCH REF_N REF_P VDD GND UNIT_OUT CTRL
*.iopin REF_N
*.iopin REF_P
*.iopin VDD
*.iopin GND
*.ipin CTRL
*.opin UNIT_OUT
x1 REF_N REF_P VDD GND UNIT_OUT CTRL A44_C1_SWITCH
x2 REF_N REF_P VDD GND UNIT_OUT CTRL A44_C1_SWITCH
x3 REF_N REF_P VDD GND UNIT_OUT CTRL A44_C1_SWITCH
x4 REF_N REF_P VDD GND UNIT_OUT CTRL A44_C1_SWITCH
x5 REF_N REF_P VDD GND UNIT_OUT CTRL A44_C1_SWITCH
x6 REF_N REF_P VDD GND UNIT_OUT CTRL A44_C1_SWITCH
x7 REF_N REF_P VDD GND UNIT_OUT CTRL A44_C1_SWITCH
x8 REF_N REF_P VDD GND UNIT_OUT CTRL A44_C1_SWITCH
x9 REF_N REF_P VDD GND UNIT_OUT CTRL A44_C1_SWITCH
x10 REF_N REF_P VDD GND UNIT_OUT CTRL A44_C1_SWITCH
x11 REF_N REF_P VDD GND UNIT_OUT CTRL A44_C1_SWITCH
x12 REF_N REF_P VDD GND UNIT_OUT CTRL A44_C1_SWITCH
x13 REF_N REF_P VDD GND UNIT_OUT CTRL A44_C1_SWITCH
x14 REF_N REF_P VDD GND UNIT_OUT CTRL A44_C1_SWITCH
x15 REF_N REF_P VDD GND UNIT_OUT CTRL A44_C1_SWITCH
x16 REF_N REF_P VDD GND UNIT_OUT CTRL A44_C1_SWITCH
x17 REF_N REF_P VDD GND UNIT_OUT CTRL A44_C1_SWITCH
x18 REF_N REF_P VDD GND UNIT_OUT CTRL A44_C1_SWITCH
x19 REF_N REF_P VDD GND UNIT_OUT CTRL A44_C1_SWITCH
x20 REF_N REF_P VDD GND UNIT_OUT CTRL A44_C1_SWITCH
x21 REF_N REF_P VDD GND UNIT_OUT CTRL A44_C1_SWITCH
x22 REF_N REF_P VDD GND UNIT_OUT CTRL A44_C1_SWITCH
x23 REF_N REF_P VDD GND UNIT_OUT CTRL A44_C1_SWITCH
x24 REF_N REF_P VDD GND UNIT_OUT CTRL A44_C1_SWITCH
x25 REF_N REF_P VDD GND UNIT_OUT CTRL A44_C1_SWITCH
x26 REF_N REF_P VDD GND UNIT_OUT CTRL A44_C1_SWITCH
x27 REF_N REF_P VDD GND UNIT_OUT CTRL A44_C1_SWITCH
x28 REF_N REF_P VDD GND UNIT_OUT CTRL A44_C1_SWITCH
x29 REF_N REF_P VDD GND UNIT_OUT CTRL A44_C1_SWITCH
x30 REF_N REF_P VDD GND UNIT_OUT CTRL A44_C1_SWITCH
x31 REF_N REF_P VDD GND UNIT_OUT CTRL A44_C1_SWITCH
x32 REF_N REF_P VDD GND UNIT_OUT CTRL A44_C1_SWITCH
x33 REF_N REF_P VDD GND UNIT_OUT CTRL A44_C1_SWITCH
x34 REF_N REF_P VDD GND UNIT_OUT CTRL A44_C1_SWITCH
x35 REF_N REF_P VDD GND UNIT_OUT CTRL A44_C1_SWITCH
x36 REF_N REF_P VDD GND UNIT_OUT CTRL A44_C1_SWITCH
x37 REF_N REF_P VDD GND UNIT_OUT CTRL A44_C1_SWITCH
x38 REF_N REF_P VDD GND UNIT_OUT CTRL A44_C1_SWITCH
x39 REF_N REF_P VDD GND UNIT_OUT CTRL A44_C1_SWITCH
x40 REF_N REF_P VDD GND UNIT_OUT CTRL A44_C1_SWITCH
x41 REF_N REF_P VDD GND UNIT_OUT CTRL A44_C1_SWITCH
x42 REF_N REF_P VDD GND UNIT_OUT CTRL A44_C1_SWITCH
x43 REF_N REF_P VDD GND UNIT_OUT CTRL A44_C1_SWITCH
x44 REF_N REF_P VDD GND UNIT_OUT CTRL A44_C1_SWITCH
x45 REF_N REF_P VDD GND UNIT_OUT CTRL A44_C1_SWITCH
x46 REF_N REF_P VDD GND UNIT_OUT CTRL A44_C1_SWITCH
x47 REF_N REF_P VDD GND UNIT_OUT CTRL A44_C1_SWITCH
x48 REF_N REF_P VDD GND UNIT_OUT CTRL A44_C1_SWITCH
x49 REF_N REF_P VDD GND UNIT_OUT CTRL A44_C1_SWITCH
x50 REF_N REF_P VDD GND UNIT_OUT CTRL A44_C1_SWITCH
x51 REF_N REF_P VDD GND UNIT_OUT CTRL A44_C1_SWITCH
x52 REF_N REF_P VDD GND UNIT_OUT CTRL A44_C1_SWITCH
x53 REF_N REF_P VDD GND UNIT_OUT CTRL A44_C1_SWITCH
x54 REF_N REF_P VDD GND UNIT_OUT CTRL A44_C1_SWITCH
x55 REF_N REF_P VDD GND UNIT_OUT CTRL A44_C1_SWITCH
x56 REF_N REF_P VDD GND UNIT_OUT CTRL A44_C1_SWITCH
x57 REF_N REF_P VDD GND UNIT_OUT CTRL A44_C1_SWITCH
x58 REF_N REF_P VDD GND UNIT_OUT CTRL A44_C1_SWITCH
x59 REF_N REF_P VDD GND UNIT_OUT CTRL A44_C1_SWITCH
x60 REF_N REF_P VDD GND UNIT_OUT CTRL A44_C1_SWITCH
x61 REF_N REF_P VDD GND UNIT_OUT CTRL A44_C1_SWITCH
x62 REF_N REF_P VDD GND UNIT_OUT CTRL A44_C1_SWITCH
x63 REF_N REF_P VDD GND UNIT_OUT CTRL A44_C1_SWITCH
x64 REF_N REF_P VDD GND UNIT_OUT CTRL A44_C1_SWITCH
.ends

.subckt A44_C32_SWITCH REF_N REF_P VDD GND UNIT_OUT CTRL
*.iopin REF_N
*.iopin REF_P
*.iopin VDD
*.iopin GND
*.ipin CTRL
*.opin UNIT_OUT
x1 REF_N REF_P VDD GND UNIT_OUT CTRL A44_C1_SWITCH
x2 REF_N REF_P VDD GND UNIT_OUT CTRL A44_C1_SWITCH
x3 REF_N REF_P VDD GND UNIT_OUT CTRL A44_C1_SWITCH
x4 REF_N REF_P VDD GND UNIT_OUT CTRL A44_C1_SWITCH
x5 REF_N REF_P VDD GND UNIT_OUT CTRL A44_C1_SWITCH
x6 REF_N REF_P VDD GND UNIT_OUT CTRL A44_C1_SWITCH
x7 REF_N REF_P VDD GND UNIT_OUT CTRL A44_C1_SWITCH
x8 REF_N REF_P VDD GND UNIT_OUT CTRL A44_C1_SWITCH
x9 REF_N REF_P VDD GND UNIT_OUT CTRL A44_C1_SWITCH
x10 REF_N REF_P VDD GND UNIT_OUT CTRL A44_C1_SWITCH
x11 REF_N REF_P VDD GND UNIT_OUT CTRL A44_C1_SWITCH
x12 REF_N REF_P VDD GND UNIT_OUT CTRL A44_C1_SWITCH
x13 REF_N REF_P VDD GND UNIT_OUT CTRL A44_C1_SWITCH
x14 REF_N REF_P VDD GND UNIT_OUT CTRL A44_C1_SWITCH
x15 REF_N REF_P VDD GND UNIT_OUT CTRL A44_C1_SWITCH
x16 REF_N REF_P VDD GND UNIT_OUT CTRL A44_C1_SWITCH
x17 REF_N REF_P VDD GND UNIT_OUT CTRL A44_C1_SWITCH
x18 REF_N REF_P VDD GND UNIT_OUT CTRL A44_C1_SWITCH
x19 REF_N REF_P VDD GND UNIT_OUT CTRL A44_C1_SWITCH
x20 REF_N REF_P VDD GND UNIT_OUT CTRL A44_C1_SWITCH
x21 REF_N REF_P VDD GND UNIT_OUT CTRL A44_C1_SWITCH
x22 REF_N REF_P VDD GND UNIT_OUT CTRL A44_C1_SWITCH
x23 REF_N REF_P VDD GND UNIT_OUT CTRL A44_C1_SWITCH
x24 REF_N REF_P VDD GND UNIT_OUT CTRL A44_C1_SWITCH
x25 REF_N REF_P VDD GND UNIT_OUT CTRL A44_C1_SWITCH
x26 REF_N REF_P VDD GND UNIT_OUT CTRL A44_C1_SWITCH
x27 REF_N REF_P VDD GND UNIT_OUT CTRL A44_C1_SWITCH
x28 REF_N REF_P VDD GND UNIT_OUT CTRL A44_C1_SWITCH
x29 REF_N REF_P VDD GND UNIT_OUT CTRL A44_C1_SWITCH
x30 REF_N REF_P VDD GND UNIT_OUT CTRL A44_C1_SWITCH
x31 REF_N REF_P VDD GND UNIT_OUT CTRL A44_C1_SWITCH
x32 REF_N REF_P VDD GND UNIT_OUT CTRL A44_C1_SWITCH
.ends

.subckt A44_CONVERSION_BUFFER CTRL_IN[1] CTRL_OUT[1] VDD GND CTRL_IN[2] CTRL_OUT[2] CTRL_OUT[3] CTRL_IN[3] CTRL_OUT[4] CTRL_IN[4]
+ CTRL_OUT[5] CTRL_IN[5] CTRL_OUT[6] CTRL_IN[6] CTRL_OUT[7] CTRL_IN[7]
*.ipin CTRL_IN[2]
*.opin CTRL_OUT[2]
*.iopin VDD
*.iopin GND
*.ipin CTRL_IN[1]
*.opin CTRL_OUT[1]
*.ipin CTRL_IN[4]
*.opin CTRL_OUT[4]
*.ipin CTRL_IN[3]
*.opin CTRL_OUT[3]
*.ipin CTRL_IN[6]
*.opin CTRL_OUT[6]
*.ipin CTRL_IN[5]
*.opin CTRL_OUT[5]
*.ipin CTRL_IN[7]
*.opin CTRL_OUT[7]
XDCTRL_CH2_INV1_NMOS net1 CTRL_IN[2] GND GND nfet_03v3 L=0.28u W=2.34u nf=1 ad='int((nf+1)/2) * W/nf * 0.18u' as='int((nf+2)/2) * W/nf * 0.18u'
+ pd='2*int((nf+1)/2) * (W/nf + 0.18u)' ps='2*int((nf+2)/2) * (W/nf + 0.18u)' nrd='0.18u / W' nrs='0.18u / W' sa=0 sb=0 sd=0
XDCTRL_CH2_INV1_PMOS net1 CTRL_IN[2] VDD VDD pfet_03v3 L=0.28u W=4.67u nf=1 ad='int((nf+1)/2) * W/nf * 0.18u' as='int((nf+2)/2) * W/nf * 0.18u'
+ pd='2*int((nf+1)/2) * (W/nf + 0.18u)' ps='2*int((nf+2)/2) * (W/nf + 0.18u)' nrd='0.18u / W' nrs='0.18u / W' sa=0 sb=0 sd=0
XDCTRL_CH2_INV2_NMOS CTRL_OUT[2] net1 GND GND nfet_03v3 L=0.28u W=6.22u nf=1 ad='int((nf+1)/2) * W/nf * 0.18u' as='int((nf+2)/2) * W/nf * 0.18u'
+ pd='2*int((nf+1)/2) * (W/nf + 0.18u)' ps='2*int((nf+2)/2) * (W/nf + 0.18u)' nrd='0.18u / W' nrs='0.18u / W' sa=0 sb=0 sd=0
XDCTRL_CH2_INV2_PMOS CTRL_OUT[2] net1 VDD VDD pfet_03v3 L=0.28u W=12.44u nf=1 ad='int((nf+1)/2) * W/nf * 0.18u' as='int((nf+2)/2) * W/nf * 0.18u'
+ pd='2*int((nf+1)/2) * (W/nf + 0.18u)' ps='2*int((nf+2)/2) * (W/nf + 0.18u)' nrd='0.18u / W' nrs='0.18u / W' sa=0 sb=0 sd=0
XDCTRL_CH1_INV1_NMOS net2 CTRL_IN[1] GND GND nfet_03v3 L=0.28u W=2.34u nf=1 ad='int((nf+1)/2) * W/nf * 0.18u' as='int((nf+2)/2) * W/nf * 0.18u'
+ pd='2*int((nf+1)/2) * (W/nf + 0.18u)' ps='2*int((nf+2)/2) * (W/nf + 0.18u)' nrd='0.18u / W' nrs='0.18u / W' sa=0 sb=0 sd=0
XDCTRL_CH1_INV1_PMOS net2 CTRL_IN[1] VDD VDD pfet_03v3 L=0.28u W=4.67u nf=1 ad='int((nf+1)/2) * W/nf * 0.18u' as='int((nf+2)/2) * W/nf * 0.18u'
+ pd='2*int((nf+1)/2) * (W/nf + 0.18u)' ps='2*int((nf+2)/2) * (W/nf + 0.18u)' nrd='0.18u / W' nrs='0.18u / W' sa=0 sb=0 sd=0
XDCTRL_CH1_INV2_NMOS CTRL_OUT[1] net2 GND GND nfet_03v3 L=0.28u W=6.22u nf=1 ad='int((nf+1)/2) * W/nf * 0.18u' as='int((nf+2)/2) * W/nf * 0.18u'
+ pd='2*int((nf+1)/2) * (W/nf + 0.18u)' ps='2*int((nf+2)/2) * (W/nf + 0.18u)' nrd='0.18u / W' nrs='0.18u / W' sa=0 sb=0 sd=0
XDCTRL_CH1_INV2_PMOS CTRL_OUT[1] net2 VDD VDD pfet_03v3 L=0.28u W=12.44u nf=1 ad='int((nf+1)/2) * W/nf * 0.18u' as='int((nf+2)/2) * W/nf * 0.18u'
+ pd='2*int((nf+1)/2) * (W/nf + 0.18u)' ps='2*int((nf+2)/2) * (W/nf + 0.18u)' nrd='0.18u / W' nrs='0.18u / W' sa=0 sb=0 sd=0
XDCTRL_CH4_INV1_NMOS net3 CTRL_IN[4] GND GND nfet_03v3 L=0.28u W=2.34u nf=1 ad='int((nf+1)/2) * W/nf * 0.18u' as='int((nf+2)/2) * W/nf * 0.18u'
+ pd='2*int((nf+1)/2) * (W/nf + 0.18u)' ps='2*int((nf+2)/2) * (W/nf + 0.18u)' nrd='0.18u / W' nrs='0.18u / W' sa=0 sb=0 sd=0
XDCTRL_CH4_INV1_PMOS net3 CTRL_IN[4] VDD VDD pfet_03v3 L=0.28u W=4.67u nf=1 ad='int((nf+1)/2) * W/nf * 0.18u' as='int((nf+2)/2) * W/nf * 0.18u'
+ pd='2*int((nf+1)/2) * (W/nf + 0.18u)' ps='2*int((nf+2)/2) * (W/nf + 0.18u)' nrd='0.18u / W' nrs='0.18u / W' sa=0 sb=0 sd=0
XDCTRL_CH4_INV2_NMOS CTRL_OUT[4] net3 GND GND nfet_03v3 L=0.28u W=6.22u nf=1 ad='int((nf+1)/2) * W/nf * 0.18u' as='int((nf+2)/2) * W/nf * 0.18u'
+ pd='2*int((nf+1)/2) * (W/nf + 0.18u)' ps='2*int((nf+2)/2) * (W/nf + 0.18u)' nrd='0.18u / W' nrs='0.18u / W' sa=0 sb=0 sd=0
XDCTRL_CH4_INV2_PMOS CTRL_OUT[4] net3 VDD VDD pfet_03v3 L=0.28u W=12.44u nf=1 ad='int((nf+1)/2) * W/nf * 0.18u' as='int((nf+2)/2) * W/nf * 0.18u'
+ pd='2*int((nf+1)/2) * (W/nf + 0.18u)' ps='2*int((nf+2)/2) * (W/nf + 0.18u)' nrd='0.18u / W' nrs='0.18u / W' sa=0 sb=0 sd=0
XDCTRL_CH3_INV1_NMOS net4 CTRL_IN[3] GND GND nfet_03v3 L=0.28u W=2.34u nf=1 ad='int((nf+1)/2) * W/nf * 0.18u' as='int((nf+2)/2) * W/nf * 0.18u'
+ pd='2*int((nf+1)/2) * (W/nf + 0.18u)' ps='2*int((nf+2)/2) * (W/nf + 0.18u)' nrd='0.18u / W' nrs='0.18u / W' sa=0 sb=0 sd=0
XDCTRL_CH3_INV1_PMOS net4 CTRL_IN[3] VDD VDD pfet_03v3 L=0.28u W=4.67u nf=1 ad='int((nf+1)/2) * W/nf * 0.18u' as='int((nf+2)/2) * W/nf * 0.18u'
+ pd='2*int((nf+1)/2) * (W/nf + 0.18u)' ps='2*int((nf+2)/2) * (W/nf + 0.18u)' nrd='0.18u / W' nrs='0.18u / W' sa=0 sb=0 sd=0
XDCTRL_CH3_INV2_NMOS CTRL_OUT[3] net4 GND GND nfet_03v3 L=0.28u W=6.22u nf=1 ad='int((nf+1)/2) * W/nf * 0.18u' as='int((nf+2)/2) * W/nf * 0.18u'
+ pd='2*int((nf+1)/2) * (W/nf + 0.18u)' ps='2*int((nf+2)/2) * (W/nf + 0.18u)' nrd='0.18u / W' nrs='0.18u / W' sa=0 sb=0 sd=0
XDCTRL_CH3_INV2_PMOS CTRL_OUT[3] net4 VDD VDD pfet_03v3 L=0.28u W=12.44u nf=1 ad='int((nf+1)/2) * W/nf * 0.18u' as='int((nf+2)/2) * W/nf * 0.18u'
+ pd='2*int((nf+1)/2) * (W/nf + 0.18u)' ps='2*int((nf+2)/2) * (W/nf + 0.18u)' nrd='0.18u / W' nrs='0.18u / W' sa=0 sb=0 sd=0
XDCTRL_CH6_INV1_NMOS net5 CTRL_IN[6] GND GND nfet_03v3 L=0.28u W=2.34u nf=1 ad='int((nf+1)/2) * W/nf * 0.18u' as='int((nf+2)/2) * W/nf * 0.18u'
+ pd='2*int((nf+1)/2) * (W/nf + 0.18u)' ps='2*int((nf+2)/2) * (W/nf + 0.18u)' nrd='0.18u / W' nrs='0.18u / W' sa=0 sb=0 sd=0
XDCTRL_CH6_INV1_PMOS net5 CTRL_IN[6] VDD VDD pfet_03v3 L=0.28u W=4.67u nf=1 ad='int((nf+1)/2) * W/nf * 0.18u' as='int((nf+2)/2) * W/nf * 0.18u'
+ pd='2*int((nf+1)/2) * (W/nf + 0.18u)' ps='2*int((nf+2)/2) * (W/nf + 0.18u)' nrd='0.18u / W' nrs='0.18u / W' sa=0 sb=0 sd=0
XDCTRL_CH6_INV2_NMOS CTRL_OUT[6] net5 GND GND nfet_03v3 L=0.28u W=6.22u nf=1 ad='int((nf+1)/2) * W/nf * 0.18u' as='int((nf+2)/2) * W/nf * 0.18u'
+ pd='2*int((nf+1)/2) * (W/nf + 0.18u)' ps='2*int((nf+2)/2) * (W/nf + 0.18u)' nrd='0.18u / W' nrs='0.18u / W' sa=0 sb=0 sd=0
XDCTRL_CH6_INV2_PMOS CTRL_OUT[6] net5 VDD VDD pfet_03v3 L=0.28u W=12.44u nf=1 ad='int((nf+1)/2) * W/nf * 0.18u' as='int((nf+2)/2) * W/nf * 0.18u'
+ pd='2*int((nf+1)/2) * (W/nf + 0.18u)' ps='2*int((nf+2)/2) * (W/nf + 0.18u)' nrd='0.18u / W' nrs='0.18u / W' sa=0 sb=0 sd=0
XDCTRL_CH5_INV1_NMOS net6 CTRL_IN[5] GND GND nfet_03v3 L=0.28u W=2.34u nf=1 ad='int((nf+1)/2) * W/nf * 0.18u' as='int((nf+2)/2) * W/nf * 0.18u'
+ pd='2*int((nf+1)/2) * (W/nf + 0.18u)' ps='2*int((nf+2)/2) * (W/nf + 0.18u)' nrd='0.18u / W' nrs='0.18u / W' sa=0 sb=0 sd=0
XDCTRL_CH5_INV1_PMOS net6 CTRL_IN[5] VDD VDD pfet_03v3 L=0.28u W=4.67u nf=1 ad='int((nf+1)/2) * W/nf * 0.18u' as='int((nf+2)/2) * W/nf * 0.18u'
+ pd='2*int((nf+1)/2) * (W/nf + 0.18u)' ps='2*int((nf+2)/2) * (W/nf + 0.18u)' nrd='0.18u / W' nrs='0.18u / W' sa=0 sb=0 sd=0
XDCTRL_CH5_INV2_NMOS CTRL_OUT[5] net6 GND GND nfet_03v3 L=0.28u W=6.22u nf=1 ad='int((nf+1)/2) * W/nf * 0.18u' as='int((nf+2)/2) * W/nf * 0.18u'
+ pd='2*int((nf+1)/2) * (W/nf + 0.18u)' ps='2*int((nf+2)/2) * (W/nf + 0.18u)' nrd='0.18u / W' nrs='0.18u / W' sa=0 sb=0 sd=0
XDCTRL_CH5_INV2_PMOS CTRL_OUT[5] net6 VDD VDD pfet_03v3 L=0.28u W=12.44u nf=1 ad='int((nf+1)/2) * W/nf * 0.18u' as='int((nf+2)/2) * W/nf * 0.18u'
+ pd='2*int((nf+1)/2) * (W/nf + 0.18u)' ps='2*int((nf+2)/2) * (W/nf + 0.18u)' nrd='0.18u / W' nrs='0.18u / W' sa=0 sb=0 sd=0
XDCTRL_CH7_INV1_NMOS net7 CTRL_IN[7] GND GND nfet_03v3 L=0.28u W=2.34u nf=1 ad='int((nf+1)/2) * W/nf * 0.18u' as='int((nf+2)/2) * W/nf * 0.18u'
+ pd='2*int((nf+1)/2) * (W/nf + 0.18u)' ps='2*int((nf+2)/2) * (W/nf + 0.18u)' nrd='0.18u / W' nrs='0.18u / W' sa=0 sb=0 sd=0
XDCTRL_CH7_INV1_PMOS net7 CTRL_IN[7] VDD VDD pfet_03v3 L=0.28u W=4.67u nf=1 ad='int((nf+1)/2) * W/nf * 0.18u' as='int((nf+2)/2) * W/nf * 0.18u'
+ pd='2*int((nf+1)/2) * (W/nf + 0.18u)' ps='2*int((nf+2)/2) * (W/nf + 0.18u)' nrd='0.18u / W' nrs='0.18u / W' sa=0 sb=0 sd=0
XDCTRL_CH7_INV2_NMOS CTRL_OUT[7] net7 GND GND nfet_03v3 L=0.28u W=6.22u nf=1 ad='int((nf+1)/2) * W/nf * 0.18u' as='int((nf+2)/2) * W/nf * 0.18u'
+ pd='2*int((nf+1)/2) * (W/nf + 0.18u)' ps='2*int((nf+2)/2) * (W/nf + 0.18u)' nrd='0.18u / W' nrs='0.18u / W' sa=0 sb=0 sd=0
XDCTRL_CH7_INV2_PMOS CTRL_OUT[7] net7 VDD VDD pfet_03v3 L=0.28u W=12.44u nf=1 ad='int((nf+1)/2) * W/nf * 0.18u' as='int((nf+2)/2) * W/nf * 0.18u'
+ pd='2*int((nf+1)/2) * (W/nf + 0.18u)' ps='2*int((nf+2)/2) * (W/nf + 0.18u)' nrd='0.18u / W' nrs='0.18u / W' sa=0 sb=0 sd=0
.ends

.subckt A44_SWITCH_TRANS_TG8 CLKS VDD GND VOUT VIN

*.iopin VDD
*.iopin GND
*.ipin VIN
*.ipin CLKS
*.opin VOUT
XTG_CLK_INV1_NMOS net1 CLKS GND GND nfet_03v3 L=0.28u W=1.56u nf=2 ad='int((nf+1)/2) * W/nf * 0.18u' as='int((nf+2)/2) * W/nf * 0.18u'
+ pd='2*int((nf+1)/2) * (W/nf + 0.18u)' ps='2*int((nf+2)/2) * (W/nf + 0.18u)' nrd='0.18u / W' nrs='0.18u / W' sa=0 sb=0 sd=0 m=1
XTG_CLK_INV1_PMOS net1 CLKS VDD VDD pfet_03v3 L=0.28u W=3.12u nf=2 ad='int((nf+1)/2) * W/nf * 0.18u' as='int((nf+2)/2) * W/nf * 0.18u'
+ pd='2*int((nf+1)/2) * (W/nf + 0.18u)' ps='2*int((nf+2)/2) * (W/nf + 0.18u)' nrd='0.18u / W' nrs='0.18u / W' sa=0 sb=0 sd=0 m=1
XTG_CLK_INV2_NMOS net2 net1 GND GND nfet_03v3 L=0.28u W=2.34u nf=3 ad='int((nf+1)/2) * W/nf * 0.18u' as='int((nf+2)/2) * W/nf * 0.18u'
+ pd='2*int((nf+1)/2) * (W/nf + 0.18u)' ps='2*int((nf+2)/2) * (W/nf + 0.18u)' nrd='0.18u / W' nrs='0.18u / W' sa=0 sb=0 sd=0 m=1
XTG_CLK_INV2_PMOS net2 net1 VDD VDD pfet_03v3 L=0.28u W=4.68u nf=3 ad='int((nf+1)/2) * W/nf * 0.18u' as='int((nf+2)/2) * W/nf * 0.18u'
+ pd='2*int((nf+1)/2) * (W/nf + 0.18u)' ps='2*int((nf+2)/2) * (W/nf + 0.18u)' nrd='0.18u / W' nrs='0.18u / W' sa=0 sb=0 sd=0 m=1
XTG_CLK_INV3_NMOS net3 net2 GND GND nfet_03v3 L=0.28u W=3.12u nf=4 ad='int((nf+1)/2) * W/nf * 0.18u' as='int((nf+2)/2) * W/nf * 0.18u'
+ pd='2*int((nf+1)/2) * (W/nf + 0.18u)' ps='2*int((nf+2)/2) * (W/nf + 0.18u)' nrd='0.18u / W' nrs='0.18u / W' sa=0 sb=0 sd=0 m=1
XTG_CLK_INV3_PMOS net3 net2 VDD VDD pfet_03v3 L=0.28u W=6.24u nf=4 ad='int((nf+1)/2) * W/nf * 0.18u' as='int((nf+2)/2) * W/nf * 0.18u'
+ pd='2*int((nf+1)/2) * (W/nf + 0.18u)' ps='2*int((nf+2)/2) * (W/nf + 0.18u)' nrd='0.18u / W' nrs='0.18u / W' sa=0 sb=0 sd=0 m=1
XTG_CLK_INV4_NMOS N_CLK net3 GND GND nfet_03v3 L=0.28u W=4.68u nf=6 ad='int((nf+1)/2) * W/nf * 0.18u' as='int((nf+2)/2) * W/nf * 0.18u'
+ pd='2*int((nf+1)/2) * (W/nf + 0.18u)' ps='2*int((nf+2)/2) * (W/nf + 0.18u)' nrd='0.18u / W' nrs='0.18u / W' sa=0 sb=0 sd=0 m=1
XTG_CLK_INV4_PMOS N_CLK net3 VDD VDD pfet_03v3 L=0.28u W=9.36u nf=6 ad='int((nf+1)/2) * W/nf * 0.18u' as='int((nf+2)/2) * W/nf * 0.18u'
+ pd='2*int((nf+1)/2) * (W/nf + 0.18u)' ps='2*int((nf+2)/2) * (W/nf + 0.18u)' nrd='0.18u / W' nrs='0.18u / W' sa=0 sb=0 sd=0 m=1
XTG_PCLK_INV1_NMOS net4 CLKS GND GND nfet_03v3 L=0.28u W=1.56u nf=2 ad='int((nf+1)/2) * W/nf * 0.18u' as='int((nf+2)/2) * W/nf * 0.18u'
+ pd='2*int((nf+1)/2) * (W/nf + 0.18u)' ps='2*int((nf+2)/2) * (W/nf + 0.18u)' nrd='0.18u / W' nrs='0.18u / W' sa=0 sb=0 sd=0 m=1
XTG_PCLK_INV1_PMOS net4 CLKS VDD VDD pfet_03v3 L=0.28u W=3.12u nf=2 ad='int((nf+1)/2) * W/nf * 0.18u' as='int((nf+2)/2) * W/nf * 0.18u'
+ pd='2*int((nf+1)/2) * (W/nf + 0.18u)' ps='2*int((nf+2)/2) * (W/nf + 0.18u)' nrd='0.18u / W' nrs='0.18u / W' sa=0 sb=0 sd=0 m=1
XTG_PCLK_INV2_NMOS net5 net4 GND GND nfet_03v3 L=0.28u W=3.12u nf=4 ad='int((nf+1)/2) * W/nf * 0.18u' as='int((nf+2)/2) * W/nf * 0.18u'
+ pd='2*int((nf+1)/2) * (W/nf + 0.18u)' ps='2*int((nf+2)/2) * (W/nf + 0.18u)' nrd='0.18u / W' nrs='0.18u / W' sa=0 sb=0 sd=0 m=1
XTG_PCLK_INV2_PMOS net5 net4 VDD VDD pfet_03v3 L=0.28u W=6.24u nf=4 ad='int((nf+1)/2) * W/nf * 0.18u' as='int((nf+2)/2) * W/nf * 0.18u'
+ pd='2*int((nf+1)/2) * (W/nf + 0.18u)' ps='2*int((nf+2)/2) * (W/nf + 0.18u)' nrd='0.18u / W' nrs='0.18u / W' sa=0 sb=0 sd=0 m=1
XTG_PCLK_INV3_NMOS P_CLK net5 GND GND nfet_03v3 L=0.28u W=6.24u nf=8 ad='int((nf+1)/2) * W/nf * 0.18u' as='int((nf+2)/2) * W/nf * 0.18u'
+ pd='2*int((nf+1)/2) * (W/nf + 0.18u)' ps='2*int((nf+2)/2) * (W/nf + 0.18u)' nrd='0.18u / W' nrs='0.18u / W' sa=0 sb=0 sd=0 m=1
XTG_PCLK_INV3_PMOS P_CLK net5 VDD VDD pfet_03v3 L=0.28u W=12.48u nf=8 ad='int((nf+1)/2) * W/nf * 0.18u' as='int((nf+2)/2) * W/nf * 0.18u'
+ pd='2*int((nf+1)/2) * (W/nf + 0.18u)' ps='2*int((nf+2)/2) * (W/nf + 0.18u)' nrd='0.18u / W' nrs='0.18u / W' sa=0 sb=0 sd=0 m=1
XTG_TRANS_NMOS VIN N_CLK VOUT GND nfet_03v3 L=0.28u W=3.11u nf=1 ad='int((nf+1)/2) * W/nf * 0.18u' as='int((nf+2)/2) * W/nf * 0.18u'
+ pd='2*int((nf+1)/2) * (W/nf + 0.18u)' ps='2*int((nf+2)/2) * (W/nf + 0.18u)' nrd='0.18u / W' nrs='0.18u / W' sa=0 sb=0 sd=0 m=8
XTG_TRANS_PMOS VIN P_CLK VOUT VDD pfet_03v3 L=0.28u W=6.22u nf=1 ad='int((nf+1)/2) * W/nf * 0.18u' as='int((nf+2)/2) * W/nf * 0.18u'
+ pd='2*int((nf+1)/2) * (W/nf + 0.18u)' ps='2*int((nf+2)/2) * (W/nf + 0.18u)' nrd='0.18u / W' nrs='0.18u / W' sa=0 sb=0 sd=0 m=8
.ends

.subckt A44_CAP_SWITCH VREFP VREFN CTRL CAP_BOTTOM VDD GND
*.iopin VREFP
*.iopin VREFN
*.ipin CTRL
*.opin CAP_BOTTOM
*.iopin VDD
*.iopin GND
XCAP_REFN_SWITCH_NMOS CAP_BOTTOM CTRL VREFN GND nfet_03v3 L=0.28u W=1.56u nf=1 ad='int((nf+1)/2) * W/nf * 0.18u' as='int((nf+2)/2) * W/nf * 0.18u'
+ pd='2*int((nf+1)/2) * (W/nf + 0.18u)' ps='2*int((nf+2)/2) * (W/nf + 0.18u)' nrd='0.18u / W' nrs='0.18u / W' sa=0 sb=0 sd=0 m=18
XCAP_REFP_SWITCH_PMOS CAP_BOTTOM CTRL VREFP VDD pfet_03v3 L=0.28u W=1.56u nf=1 ad='int((nf+1)/2) * W/nf * 0.18u' as='int((nf+2)/2) * W/nf * 0.18u'
+ pd='2*int((nf+1)/2) * (W/nf + 0.18u)' ps='2*int((nf+2)/2) * (W/nf + 0.18u)' nrd='0.18u / W' nrs='0.18u / W' sa=0 sb=0 sd=0 m=18
.ends

.subckt A44_SAR_ADC_CORE_1000_R3_DUMMY_FILL_REPAIR VDD GND VREFP VREFN VINP VINN CLKS DOUT[7] DOUT[6] DOUT[5] DOUT[4] DOUT[3] DOUT[2] DOUT[1] DOUT[0]
XCLKS VDD GND CLKS_CORE CLKS A44_CLKS_BUFFER
XCDAC_P VINP CLKS_CORE VFOP DCTRLP[7] DCTRLP[6] DCTRLP[5] DCTRLP[4] DCTRLP[3] DCTRLP[2] DCTRLP[1] VREFP VDD GND VREFN A44_CDAC_UNIT_TRANS_DRIVER
XCDAC_N VINN CLKS_CORE VFON DCTRLN[7] DCTRLN[6] DCTRLN[5] DCTRLN[4] DCTRLN[3] DCTRLN[2] DCTRLN[1] VREFP VDD GND VREFN A44_CDAC_UNIT_TRANS_DRIVER
XCOMP CMPCK DCMPP VFOP DCMPN VFON VDD GND A44_Comparator_StrongARM
XSAR CLKS_CORE CMPCK DCMPN DCMPP VDD GND DCTRLN[7] DCTRLN[6] DCTRLN[5] DCTRLN[4] DCTRLN[3] DCTRLN[2] DCTRLN[1] DCTRLP[7] DCTRLP[6] DCTRLP[5] DCTRLP[4] DCTRLP[3] DCTRLP[2] DCTRLP[1] DOUT[7] DOUT[6] DOUT[5] DOUT[4] DOUT[3] DOUT[2] DOUT[1] DOUT[0] SAR_LOGIC_ACTUAL_RTL_SS
.ends A44_SAR_ADC_CORE_1000_R3_DUMMY_FILL_REPAIR

.subckt A44_Q2_BASE_REF GND VDD CLKS_PU CLKS_PD CLKS DOUT_CS[7] DOUT_SL[7] DOUT_IE[7]
+ DOUT_OE[7] DOUT_PU[7] DOUT_PD[7] DOUT_OUT[7] DOUT_PDRV0[7] DOUT_PDRV1[7] DOUT_IN[7] DOUT_CS[6]
+ DOUT_SL[6] DOUT_IE[6] DOUT_OE[6] DOUT_PU[6] DOUT_PD[6] DOUT_OUT[6] DOUT_PDRV0[6] DOUT_PDRV1[6]
+ DOUT_IN[6] DOUT_CS[5] DOUT_SL[5] DOUT_IE[5] DOUT_OE[5] DOUT_PU[5] DOUT_PD[5] DOUT_OUT[5]
+ DOUT_PDRV0[5] DOUT_PDRV1[5] DOUT_IN[5] DOUT_CS[4] DOUT_SL[4] DOUT_IE[4] DOUT_OE[4] DOUT_PU[4]
+ DOUT_PD[4] DOUT_OUT[4] DOUT_PDRV0[4] DOUT_PDRV1[4] DOUT_IN[4] DOUT_CS[3] DOUT_SL[3] DOUT_IE[3]
+ DOUT_OE[3] DOUT_PU[3] DOUT_PD[3] DOUT_OUT[3] DOUT_PDRV0[3] DOUT_PDRV1[3] DOUT_IN[3] DOUT_CS[2]
+ DOUT_SL[2] DOUT_IE[2] DOUT_OE[2] DOUT_PU[2] DOUT_PD[2] DOUT_OUT[2] DOUT_PDRV0[2] DOUT_PDRV1[2]
+ DOUT_IN[2] DOUT_CS[1] DOUT_SL[1] DOUT_IE[1] DOUT_OE[1] DOUT_PU[1] DOUT_PD[1] DOUT_OUT[1]
+ DOUT_PDRV0[1] DOUT_PDRV1[1] DOUT_IN[1] DOUT_CS[0] DOUT_SL[0] DOUT_IE[0] DOUT_OE[0] DOUT_PU[0]
+ DOUT_PD[0] DOUT_OUT[0] DOUT_PDRV0[0] DOUT_PDRV1[0] DOUT_IN[0] VREFN VINN VINP
+ VREFP
XCORE VDD GND VREFP VREFN VINP VINN CLKS
+ DOUT_OUT[7] DOUT_OUT[6] DOUT_OUT[5] DOUT_OUT[4] DOUT_OUT[3] DOUT_OUT[2] DOUT_OUT[1] DOUT_OUT[0]
+ A44_SAR_ADC_CORE_1000_R3_DUMMY_FILL_REPAIR
XCLKS_CTRL_END_L VDD VDD GND GND gf180mcu_fd_sc_mcu7t5v0__endcap
XCLKS_CTRL_TAP VDD GND gf180mcu_fd_sc_mcu7t5v0__filltie
XTIE_CLKS_PU CLKS_PU VDD VDD GND GND gf180mcu_fd_sc_mcu7t5v0__tiel
XTIE_CLKS_PD CLKS_PD VDD VDD GND GND gf180mcu_fd_sc_mcu7t5v0__tiel
XCLKS_CTRL_END_R VDD VDD GND GND gf180mcu_fd_sc_mcu7t5v0__endcap
XDOUT7_LOW_END_L VDD VDD GND GND gf180mcu_fd_sc_mcu7t5v0__endcap
XDOUT7_LOW_TAP VDD GND gf180mcu_fd_sc_mcu7t5v0__filltie
XTIE_DOUT_SL_7 DOUT_SL[7] VDD VDD GND GND gf180mcu_fd_sc_mcu7t5v0__tiel
XTIE_DOUT_OE_7 DOUT_OE[7] VDD VDD GND GND gf180mcu_fd_sc_mcu7t5v0__tieh
XDOUT7_LOW_END_R VDD VDD GND GND gf180mcu_fd_sc_mcu7t5v0__endcap
XDOUT7_HIGH_END_L VDD VDD GND GND gf180mcu_fd_sc_mcu7t5v0__endcap
XDOUT7_HIGH_TAP VDD GND gf180mcu_fd_sc_mcu7t5v0__filltie
XTIE_DOUT_CS_7 DOUT_CS[7] VDD VDD GND GND gf180mcu_fd_sc_mcu7t5v0__tiel
XTIE_DOUT_IE_7 DOUT_IE[7] VDD VDD GND GND gf180mcu_fd_sc_mcu7t5v0__tiel
XTIE_DOUT_PU_7 DOUT_PU[7] VDD VDD GND GND gf180mcu_fd_sc_mcu7t5v0__tiel
XTIE_DOUT_PD_7 DOUT_PD[7] VDD VDD GND GND gf180mcu_fd_sc_mcu7t5v0__tiel
XTIE_DOUT_PDRV0_7 DOUT_PDRV0[7] VDD VDD GND GND gf180mcu_fd_sc_mcu7t5v0__tiel
XTIE_DOUT_PDRV1_7 DOUT_PDRV1[7] VDD VDD GND GND gf180mcu_fd_sc_mcu7t5v0__tiel
XDOUT7_HIGH_END_R VDD VDD GND GND gf180mcu_fd_sc_mcu7t5v0__endcap
XDOUT6_LOW_END_L VDD VDD GND GND gf180mcu_fd_sc_mcu7t5v0__endcap
XDOUT6_LOW_TAP VDD GND gf180mcu_fd_sc_mcu7t5v0__filltie
XTIE_DOUT_SL_6 DOUT_SL[6] VDD VDD GND GND gf180mcu_fd_sc_mcu7t5v0__tiel
XTIE_DOUT_OE_6 DOUT_OE[6] VDD VDD GND GND gf180mcu_fd_sc_mcu7t5v0__tieh
XDOUT6_LOW_END_R VDD VDD GND GND gf180mcu_fd_sc_mcu7t5v0__endcap
XDOUT6_HIGH_END_L VDD VDD GND GND gf180mcu_fd_sc_mcu7t5v0__endcap
XDOUT6_HIGH_TAP VDD GND gf180mcu_fd_sc_mcu7t5v0__filltie
XTIE_DOUT_CS_6 DOUT_CS[6] VDD VDD GND GND gf180mcu_fd_sc_mcu7t5v0__tiel
XTIE_DOUT_IE_6 DOUT_IE[6] VDD VDD GND GND gf180mcu_fd_sc_mcu7t5v0__tiel
XTIE_DOUT_PU_6 DOUT_PU[6] VDD VDD GND GND gf180mcu_fd_sc_mcu7t5v0__tiel
XTIE_DOUT_PD_6 DOUT_PD[6] VDD VDD GND GND gf180mcu_fd_sc_mcu7t5v0__tiel
XTIE_DOUT_PDRV0_6 DOUT_PDRV0[6] VDD VDD GND GND gf180mcu_fd_sc_mcu7t5v0__tiel
XTIE_DOUT_PDRV1_6 DOUT_PDRV1[6] VDD VDD GND GND gf180mcu_fd_sc_mcu7t5v0__tiel
XDOUT6_HIGH_END_R VDD VDD GND GND gf180mcu_fd_sc_mcu7t5v0__endcap
XDOUT5_LOW_END_L VDD VDD GND GND gf180mcu_fd_sc_mcu7t5v0__endcap
XDOUT5_LOW_TAP VDD GND gf180mcu_fd_sc_mcu7t5v0__filltie
XTIE_DOUT_SL_5 DOUT_SL[5] VDD VDD GND GND gf180mcu_fd_sc_mcu7t5v0__tiel
XTIE_DOUT_OE_5 DOUT_OE[5] VDD VDD GND GND gf180mcu_fd_sc_mcu7t5v0__tieh
XDOUT5_LOW_END_R VDD VDD GND GND gf180mcu_fd_sc_mcu7t5v0__endcap
XDOUT5_HIGH_END_L VDD VDD GND GND gf180mcu_fd_sc_mcu7t5v0__endcap
XDOUT5_HIGH_TAP VDD GND gf180mcu_fd_sc_mcu7t5v0__filltie
XTIE_DOUT_CS_5 DOUT_CS[5] VDD VDD GND GND gf180mcu_fd_sc_mcu7t5v0__tiel
XTIE_DOUT_IE_5 DOUT_IE[5] VDD VDD GND GND gf180mcu_fd_sc_mcu7t5v0__tiel
XTIE_DOUT_PU_5 DOUT_PU[5] VDD VDD GND GND gf180mcu_fd_sc_mcu7t5v0__tiel
XTIE_DOUT_PD_5 DOUT_PD[5] VDD VDD GND GND gf180mcu_fd_sc_mcu7t5v0__tiel
XTIE_DOUT_PDRV0_5 DOUT_PDRV0[5] VDD VDD GND GND gf180mcu_fd_sc_mcu7t5v0__tiel
XTIE_DOUT_PDRV1_5 DOUT_PDRV1[5] VDD VDD GND GND gf180mcu_fd_sc_mcu7t5v0__tiel
XDOUT5_HIGH_END_R VDD VDD GND GND gf180mcu_fd_sc_mcu7t5v0__endcap
XDOUT4_LOW_END_L VDD VDD GND GND gf180mcu_fd_sc_mcu7t5v0__endcap
XDOUT4_LOW_TAP VDD GND gf180mcu_fd_sc_mcu7t5v0__filltie
XTIE_DOUT_SL_4 DOUT_SL[4] VDD VDD GND GND gf180mcu_fd_sc_mcu7t5v0__tiel
XTIE_DOUT_OE_4 DOUT_OE[4] VDD VDD GND GND gf180mcu_fd_sc_mcu7t5v0__tieh
XDOUT4_LOW_END_R VDD VDD GND GND gf180mcu_fd_sc_mcu7t5v0__endcap
XDOUT4_HIGH_END_L VDD VDD GND GND gf180mcu_fd_sc_mcu7t5v0__endcap
XDOUT4_HIGH_TAP VDD GND gf180mcu_fd_sc_mcu7t5v0__filltie
XTIE_DOUT_CS_4 DOUT_CS[4] VDD VDD GND GND gf180mcu_fd_sc_mcu7t5v0__tiel
XTIE_DOUT_IE_4 DOUT_IE[4] VDD VDD GND GND gf180mcu_fd_sc_mcu7t5v0__tiel
XTIE_DOUT_PU_4 DOUT_PU[4] VDD VDD GND GND gf180mcu_fd_sc_mcu7t5v0__tiel
XTIE_DOUT_PD_4 DOUT_PD[4] VDD VDD GND GND gf180mcu_fd_sc_mcu7t5v0__tiel
XTIE_DOUT_PDRV0_4 DOUT_PDRV0[4] VDD VDD GND GND gf180mcu_fd_sc_mcu7t5v0__tiel
XTIE_DOUT_PDRV1_4 DOUT_PDRV1[4] VDD VDD GND GND gf180mcu_fd_sc_mcu7t5v0__tiel
XDOUT4_HIGH_END_R VDD VDD GND GND gf180mcu_fd_sc_mcu7t5v0__endcap
XDOUT3_LOW_END_L VDD VDD GND GND gf180mcu_fd_sc_mcu7t5v0__endcap
XDOUT3_LOW_TAP VDD GND gf180mcu_fd_sc_mcu7t5v0__filltie
XTIE_DOUT_SL_3 DOUT_SL[3] VDD VDD GND GND gf180mcu_fd_sc_mcu7t5v0__tiel
XTIE_DOUT_OE_3 DOUT_OE[3] VDD VDD GND GND gf180mcu_fd_sc_mcu7t5v0__tieh
XDOUT3_LOW_END_R VDD VDD GND GND gf180mcu_fd_sc_mcu7t5v0__endcap
XDOUT3_HIGH_END_L VDD VDD GND GND gf180mcu_fd_sc_mcu7t5v0__endcap
XDOUT3_HIGH_TAP VDD GND gf180mcu_fd_sc_mcu7t5v0__filltie
XTIE_DOUT_CS_3 DOUT_CS[3] VDD VDD GND GND gf180mcu_fd_sc_mcu7t5v0__tiel
XTIE_DOUT_IE_3 DOUT_IE[3] VDD VDD GND GND gf180mcu_fd_sc_mcu7t5v0__tiel
XTIE_DOUT_PU_3 DOUT_PU[3] VDD VDD GND GND gf180mcu_fd_sc_mcu7t5v0__tiel
XTIE_DOUT_PD_3 DOUT_PD[3] VDD VDD GND GND gf180mcu_fd_sc_mcu7t5v0__tiel
XTIE_DOUT_PDRV0_3 DOUT_PDRV0[3] VDD VDD GND GND gf180mcu_fd_sc_mcu7t5v0__tiel
XTIE_DOUT_PDRV1_3 DOUT_PDRV1[3] VDD VDD GND GND gf180mcu_fd_sc_mcu7t5v0__tiel
XDOUT3_HIGH_END_R VDD VDD GND GND gf180mcu_fd_sc_mcu7t5v0__endcap
XDOUT2_LOW_END_L VDD VDD GND GND gf180mcu_fd_sc_mcu7t5v0__endcap
XDOUT2_LOW_TAP VDD GND gf180mcu_fd_sc_mcu7t5v0__filltie
XTIE_DOUT_SL_2 DOUT_SL[2] VDD VDD GND GND gf180mcu_fd_sc_mcu7t5v0__tiel
XTIE_DOUT_OE_2 DOUT_OE[2] VDD VDD GND GND gf180mcu_fd_sc_mcu7t5v0__tieh
XDOUT2_LOW_END_R VDD VDD GND GND gf180mcu_fd_sc_mcu7t5v0__endcap
XDOUT2_HIGH_END_L VDD VDD GND GND gf180mcu_fd_sc_mcu7t5v0__endcap
XDOUT2_HIGH_TAP VDD GND gf180mcu_fd_sc_mcu7t5v0__filltie
XTIE_DOUT_CS_2 DOUT_CS[2] VDD VDD GND GND gf180mcu_fd_sc_mcu7t5v0__tiel
XTIE_DOUT_IE_2 DOUT_IE[2] VDD VDD GND GND gf180mcu_fd_sc_mcu7t5v0__tiel
XTIE_DOUT_PU_2 DOUT_PU[2] VDD VDD GND GND gf180mcu_fd_sc_mcu7t5v0__tiel
XTIE_DOUT_PD_2 DOUT_PD[2] VDD VDD GND GND gf180mcu_fd_sc_mcu7t5v0__tiel
XTIE_DOUT_PDRV0_2 DOUT_PDRV0[2] VDD VDD GND GND gf180mcu_fd_sc_mcu7t5v0__tiel
XTIE_DOUT_PDRV1_2 DOUT_PDRV1[2] VDD VDD GND GND gf180mcu_fd_sc_mcu7t5v0__tiel
XDOUT2_HIGH_END_R VDD VDD GND GND gf180mcu_fd_sc_mcu7t5v0__endcap
XDOUT1_LOW_END_L VDD VDD GND GND gf180mcu_fd_sc_mcu7t5v0__endcap
XDOUT1_LOW_TAP VDD GND gf180mcu_fd_sc_mcu7t5v0__filltie
XTIE_DOUT_SL_1 DOUT_SL[1] VDD VDD GND GND gf180mcu_fd_sc_mcu7t5v0__tiel
XTIE_DOUT_OE_1 DOUT_OE[1] VDD VDD GND GND gf180mcu_fd_sc_mcu7t5v0__tieh
XDOUT1_LOW_END_R VDD VDD GND GND gf180mcu_fd_sc_mcu7t5v0__endcap
XDOUT1_HIGH_END_L VDD VDD GND GND gf180mcu_fd_sc_mcu7t5v0__endcap
XDOUT1_HIGH_TAP VDD GND gf180mcu_fd_sc_mcu7t5v0__filltie
XTIE_DOUT_CS_1 DOUT_CS[1] VDD VDD GND GND gf180mcu_fd_sc_mcu7t5v0__tiel
XTIE_DOUT_IE_1 DOUT_IE[1] VDD VDD GND GND gf180mcu_fd_sc_mcu7t5v0__tiel
XTIE_DOUT_PU_1 DOUT_PU[1] VDD VDD GND GND gf180mcu_fd_sc_mcu7t5v0__tiel
XTIE_DOUT_PD_1 DOUT_PD[1] VDD VDD GND GND gf180mcu_fd_sc_mcu7t5v0__tiel
XTIE_DOUT_PDRV0_1 DOUT_PDRV0[1] VDD VDD GND GND gf180mcu_fd_sc_mcu7t5v0__tiel
XTIE_DOUT_PDRV1_1 DOUT_PDRV1[1] VDD VDD GND GND gf180mcu_fd_sc_mcu7t5v0__tiel
XDOUT1_HIGH_END_R VDD VDD GND GND gf180mcu_fd_sc_mcu7t5v0__endcap
XDOUT0_LOW_END_L VDD VDD GND GND gf180mcu_fd_sc_mcu7t5v0__endcap
XDOUT0_LOW_TAP VDD GND gf180mcu_fd_sc_mcu7t5v0__filltie
XTIE_DOUT_SL_0 DOUT_SL[0] VDD VDD GND GND gf180mcu_fd_sc_mcu7t5v0__tiel
XTIE_DOUT_OE_0 DOUT_OE[0] VDD VDD GND GND gf180mcu_fd_sc_mcu7t5v0__tieh
XDOUT0_LOW_END_R VDD VDD GND GND gf180mcu_fd_sc_mcu7t5v0__endcap
XDOUT0_HIGH_END_L VDD VDD GND GND gf180mcu_fd_sc_mcu7t5v0__endcap
XDOUT0_HIGH_TAP VDD GND gf180mcu_fd_sc_mcu7t5v0__filltie
XTIE_DOUT_CS_0 DOUT_CS[0] VDD VDD GND GND gf180mcu_fd_sc_mcu7t5v0__tiel
XTIE_DOUT_IE_0 DOUT_IE[0] VDD VDD GND GND gf180mcu_fd_sc_mcu7t5v0__tiel
XTIE_DOUT_PU_0 DOUT_PU[0] VDD VDD GND GND gf180mcu_fd_sc_mcu7t5v0__tiel
XTIE_DOUT_PD_0 DOUT_PD[0] VDD VDD GND GND gf180mcu_fd_sc_mcu7t5v0__tiel
XTIE_DOUT_PDRV0_0 DOUT_PDRV0[0] VDD VDD GND GND gf180mcu_fd_sc_mcu7t5v0__tiel
XTIE_DOUT_PDRV1_0 DOUT_PDRV1[0] VDD VDD GND GND gf180mcu_fd_sc_mcu7t5v0__tiel
XDOUT0_HIGH_END_R VDD VDD GND GND gf180mcu_fd_sc_mcu7t5v0__endcap
.ends A44_Q2_BASE_REF

.subckt A44_SECONDARY_ESD_M2_SCHEM PAD CORE VDD VSS
XR_CDM CORE PAD VDD ppolyf_u r_width=40u r_length=10u
DP0 CORE VDD diode_pd2nw_06v0 area=100p pj=40u
DN0 VSS CORE diode_nd2ps_06v0 area=100p pj=40u
DP1 CORE VDD diode_pd2nw_06v0 area=100p pj=40u
DN1 VSS CORE diode_nd2ps_06v0 area=100p pj=40u
DP2 CORE VDD diode_pd2nw_06v0 area=100p pj=40u
DN2 VSS CORE diode_nd2ps_06v0 area=100p pj=40u
DP3 CORE VDD diode_pd2nw_06v0 area=100p pj=40u
DN3 VSS CORE diode_nd2ps_06v0 area=100p pj=40u
.ends A44_SECONDARY_ESD_M2_SCHEM

.subckt A44_A GND VDD CLKS_PU CLKS_PD CLKS DOUT_CS[7] DOUT_SL[7] DOUT_IE[7] DOUT_OE[7] DOUT_PU[7] DOUT_PD[7] DOUT_OUT[7] DOUT_PDRV0[7] DOUT_PDRV1[7] DOUT_IN[7] DOUT_CS[6] DOUT_SL[6] DOUT_IE[6] DOUT_OE[6] DOUT_PU[6] DOUT_PD[6] DOUT_OUT[6] DOUT_PDRV0[6] DOUT_PDRV1[6] DOUT_IN[6] DOUT_CS[5] DOUT_SL[5] DOUT_IE[5] DOUT_OE[5] DOUT_PU[5] DOUT_PD[5] DOUT_OUT[5] DOUT_PDRV0[5] DOUT_PDRV1[5] DOUT_IN[5] DOUT_CS[4] DOUT_SL[4] DOUT_IE[4] DOUT_OE[4] DOUT_PU[4] DOUT_PD[4] DOUT_OUT[4] DOUT_PDRV0[4] DOUT_PDRV1[4] DOUT_IN[4] DOUT_CS[3] DOUT_SL[3] DOUT_IE[3] DOUT_OE[3] DOUT_PU[3] DOUT_PD[3] DOUT_OUT[3] DOUT_PDRV0[3] DOUT_PDRV1[3] DOUT_IN[3] DOUT_CS[2] DOUT_SL[2] DOUT_IE[2] DOUT_OE[2] DOUT_PU[2] DOUT_PD[2] DOUT_OUT[2] DOUT_PDRV0[2] DOUT_PDRV1[2] DOUT_IN[2] DOUT_CS[1] DOUT_SL[1] DOUT_IE[1] DOUT_OE[1] DOUT_PU[1] DOUT_PD[1] DOUT_OUT[1] DOUT_PDRV0[1] DOUT_PDRV1[1] DOUT_IN[1] DOUT_CS[0] DOUT_SL[0] DOUT_IE[0] DOUT_OE[0] DOUT_PU[0] DOUT_PD[0] DOUT_OUT[0] DOUT_PDRV0[0] DOUT_PDRV1[0] DOUT_IN[0] VREFN VINN VINP VREFP
XBASE GND VDD CLKS_PU CLKS_PD CLKS DOUT_CS[7] DOUT_SL[7] DOUT_IE[7] DOUT_OE[7] DOUT_PU[7] DOUT_PD[7] DOUT_OUT[7] DOUT_PDRV0[7] DOUT_PDRV1[7] DOUT_IN[7] DOUT_CS[6] DOUT_SL[6] DOUT_IE[6] DOUT_OE[6] DOUT_PU[6] DOUT_PD[6] DOUT_OUT[6] DOUT_PDRV0[6] DOUT_PDRV1[6] DOUT_IN[6] DOUT_CS[5] DOUT_SL[5] DOUT_IE[5] DOUT_OE[5] DOUT_PU[5] DOUT_PD[5] DOUT_OUT[5] DOUT_PDRV0[5] DOUT_PDRV1[5] DOUT_IN[5] DOUT_CS[4] DOUT_SL[4] DOUT_IE[4] DOUT_OE[4] DOUT_PU[4] DOUT_PD[4] DOUT_OUT[4] DOUT_PDRV0[4] DOUT_PDRV1[4] DOUT_IN[4] DOUT_CS[3] DOUT_SL[3] DOUT_IE[3] DOUT_OE[3] DOUT_PU[3] DOUT_PD[3] DOUT_OUT[3] DOUT_PDRV0[3] DOUT_PDRV1[3] DOUT_IN[3] DOUT_CS[2] DOUT_SL[2] DOUT_IE[2] DOUT_OE[2] DOUT_PU[2] DOUT_PD[2] DOUT_OUT[2] DOUT_PDRV0[2] DOUT_PDRV1[2] DOUT_IN[2] DOUT_CS[1] DOUT_SL[1] DOUT_IE[1] DOUT_OE[1] DOUT_PU[1] DOUT_PD[1] DOUT_OUT[1] DOUT_PDRV0[1] DOUT_PDRV1[1] DOUT_IN[1] DOUT_CS[0] DOUT_SL[0] DOUT_IE[0] DOUT_OE[0] DOUT_PU[0] DOUT_PD[0] DOUT_OUT[0] DOUT_PDRV0[0] DOUT_PDRV1[0] DOUT_IN[0] VREFN_CORE VINN_CORE VINP_CORE VREFP_CORE A44_Q2_BASE_REF
XESD_VREFN VREFN VREFN_CORE VDD GND A44_SECONDARY_ESD_M2_SCHEM
XESD_VINN VINN VINN_CORE VDD GND A44_SECONDARY_ESD_M2_SCHEM
XESD_VINP VINP VINP_CORE VDD GND A44_SECONDARY_ESD_M2_SCHEM
XESD_VREFP VREFP VREFP_CORE VDD GND A44_SECONDARY_ESD_M2_SCHEM
.ends A44_A
