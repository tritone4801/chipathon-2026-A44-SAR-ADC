* A44 actual analog core with fixed TT timed behavioral SAR control.
* T2_EVENT_NOISE FAST64_V2 noise_seed=100012 sample_sigma_v=6.4681023031999999e-05 comparator_sigma_v=0.0015 solver_profile=ROBUST_GEAR
.options method=gear reltol=3e-4 abstol=3e-13 vntol=3e-7 trtol=10 chgtol=1e-14 rshunt=1e10 gmin=1e-12 itl1=500 itl4=1000
.include /foss/pdks/gf180mcuD/libs.tech/ngspice/design.ngspice
.option seed=12
.param sw_stat_global=0 sw_stat_mismatch=1 mc_skew=3 res_mc_skew=3 cap_mc_skew=3 fnoicor=0
* PVT3 contract: deterministic process corner plus local MOS mismatch.
* Do not replace this with the statistical section: that would collapse
* TT/SS/FF MOS process binding to the statistical nominal model.
.lib /foss/pdks/gf180mcuD/libs.tech/ngspice/sm141064.ngspice typical
.lib /foss/pdks/gf180mcuD/libs.tech/ngspice/sm141064.ngspice mimcap_typical
* Preserve the established MC seed mapping by consuming the 19 global
* agauss draws present in the legacy statistical section before fets_mm.
RLEGACY_RNG_BURN_01 legacy_rng_burn_01 0 r='1+0*agauss(0,1,3)'
RLEGACY_RNG_BURN_02 legacy_rng_burn_02 0 r='1+0*agauss(0,1,3)'
RLEGACY_RNG_BURN_03 legacy_rng_burn_03 0 r='1+0*agauss(0,1,3)'
RLEGACY_RNG_BURN_04 legacy_rng_burn_04 0 r='1+0*agauss(0,1,3)'
RLEGACY_RNG_BURN_05 legacy_rng_burn_05 0 r='1+0*agauss(0,1,3)'
RLEGACY_RNG_BURN_06 legacy_rng_burn_06 0 r='1+0*agauss(0,1,3)'
RLEGACY_RNG_BURN_07 legacy_rng_burn_07 0 r='1+0*agauss(0,1,3)'
RLEGACY_RNG_BURN_08 legacy_rng_burn_08 0 r='1+0*agauss(0,1,3)'
RLEGACY_RNG_BURN_09 legacy_rng_burn_09 0 r='1+0*agauss(0,1,3)'
RLEGACY_RNG_BURN_10 legacy_rng_burn_10 0 r='1+0*agauss(0,1,3)'
RLEGACY_RNG_BURN_11 legacy_rng_burn_11 0 r='1+0*agauss(0,1,3)'
RLEGACY_RNG_BURN_12 legacy_rng_burn_12 0 r='1+0*agauss(0,1,3)'
RLEGACY_RNG_BURN_13 legacy_rng_burn_13 0 r='1+0*agauss(0,1,3)'
RLEGACY_RNG_BURN_14 legacy_rng_burn_14 0 r='1+0*agauss(0,1,3)'
RLEGACY_RNG_BURN_15 legacy_rng_burn_15 0 r='1+0*agauss(0,1,3)'
RLEGACY_RNG_BURN_16 legacy_rng_burn_16 0 r='1+0*agauss(0,1,3)'
RLEGACY_RNG_BURN_17 legacy_rng_burn_17 0 r='1+0*agauss(0,1,3)'
RLEGACY_RNG_BURN_18 legacy_rng_burn_18 0 r='1+0*agauss(0,1,3)'
RLEGACY_RNG_BURN_19 legacy_rng_burn_19 0 r='1+0*agauss(0,1,3)'
.include /foss/designs/A44_CMP_XM5_XM6_W8P2524_XM7_XM11_W16P8587_MC200_PVT_FULLSTATIC_20260728_R1/02_PVT3_MC20_LOW_W4/netlists/core/subckts/SWITCH_BOOT_SP_native_extracted.subckt.spice
.include /foss/designs/A44_CMP_XM5_XM6_W8P2524_XM7_XM11_W16P8587_MC200_PVT_FULLSTATIC_20260728_R1/02_PVT3_MC20_LOW_W4/netlists/core/subckts/Comparator_StrongARM_extracted.subckt.spice
.include /foss/designs/A44_CMP_XM5_XM6_W8P2524_XM7_XM11_W16P8587_MC200_PVT_FULLSTATIC_20260728_R1/02_PVT3_MC20_LOW_W4/models/no_r6_equivalent_loads.inc
.subckt CDAC_P_S012 VIN CLKS VTOP DCTRL7 DCTRL6 DCTRL5 DCTRL4 DCTRL3 DCTRL2 DCTRL1 VREFP VDD GND VREFN
XM1 VBOT1 DCTRL1 VREFN GND nfet_03v3 L=0.28u W=1.56u nf=1 ad='int((nf+1)/2) * W/nf * 0.18u' as='int((nf+2)/2) * W/nf * 0.18u' pd='2*int((nf+1)/2) * (W/nf + 0.18u)'
+ ps='2*int((nf+2)/2) * (W/nf + 0.18u)' nrd='0.18u / W' nrs='0.18u / W' sa=0 sb=0 sd=0 m=2
XM2 VBOT1 DCTRL1 VREFP VDD pfet_03v3 L=0.28u W=1.56u nf=1 ad='int((nf+1)/2) * W/nf * 0.18u' as='int((nf+2)/2) * W/nf * 0.18u' pd='2*int((nf+1)/2) * (W/nf + 0.18u)'
+ ps='2*int((nf+2)/2) * (W/nf + 0.18u)' nrd='0.18u / W' nrs='0.18u / W' sa=0 sb=0 sd=0 m=2
XC1 VTOP VBOT1 cap_mim_2f0_m4m5_noshield c_width=6.855e-6 c_length=6.855e-6 m=1.0037896102708745
XM3 VBOT2 DCTRL2 VREFN GND nfet_03v3 L=0.28u W=1.56u nf=1 ad='int((nf+1)/2) * W/nf * 0.18u' as='int((nf+2)/2) * W/nf * 0.18u' pd='2*int((nf+1)/2) * (W/nf + 0.18u)'
+ ps='2*int((nf+2)/2) * (W/nf + 0.18u)' nrd='0.18u / W' nrs='0.18u / W' sa=0 sb=0 sd=0 m=4
XM4 VBOT2 DCTRL2 VREFP VDD pfet_03v3 L=0.28u W=1.56u nf=1 ad='int((nf+1)/2) * W/nf * 0.18u' as='int((nf+2)/2) * W/nf * 0.18u' pd='2*int((nf+1)/2) * (W/nf + 0.18u)'
+ ps='2*int((nf+2)/2) * (W/nf + 0.18u)' nrd='0.18u / W' nrs='0.18u / W' sa=0 sb=0 sd=0 m=4
XC2 VTOP VBOT2 cap_mim_2f0_m4m5_noshield c_width=6.855e-6 c_length=6.855e-6 m=2.0062973434530011
XM5 VBOT3 DCTRL3 VREFN GND nfet_03v3 L=0.28u W=1.56u nf=1 ad='int((nf+1)/2) * W/nf * 0.18u' as='int((nf+2)/2) * W/nf * 0.18u' pd='2*int((nf+1)/2) * (W/nf + 0.18u)'
+ ps='2*int((nf+2)/2) * (W/nf + 0.18u)' nrd='0.18u / W' nrs='0.18u / W' sa=0 sb=0 sd=0 m=8
XM6 VBOT3 DCTRL3 VREFP VDD pfet_03v3 L=0.28u W=1.56u nf=1 ad='int((nf+1)/2) * W/nf * 0.18u' as='int((nf+2)/2) * W/nf * 0.18u' pd='2*int((nf+1)/2) * (W/nf + 0.18u)'
+ ps='2*int((nf+2)/2) * (W/nf + 0.18u)' nrd='0.18u / W' nrs='0.18u / W' sa=0 sb=0 sd=0 m=8
XC3 VTOP VBOT3 cap_mim_2f0_m4m5_noshield c_width=6.855e-6 c_length=6.855e-6 m=3.9886936143850296
XM7 VBOT4 DCTRL4 VREFN GND nfet_03v3 L=0.28u W=1.56u nf=1 ad='int((nf+1)/2) * W/nf * 0.18u' as='int((nf+2)/2) * W/nf * 0.18u' pd='2*int((nf+1)/2) * (W/nf + 0.18u)'
+ ps='2*int((nf+2)/2) * (W/nf + 0.18u)' nrd='0.18u / W' nrs='0.18u / W' sa=0 sb=0 sd=0 m=16
XM8 VBOT4 DCTRL4 VREFP VDD pfet_03v3 L=0.28u W=1.56u nf=1 ad='int((nf+1)/2) * W/nf * 0.18u' as='int((nf+2)/2) * W/nf * 0.18u' pd='2*int((nf+1)/2) * (W/nf + 0.18u)'
+ ps='2*int((nf+2)/2) * (W/nf + 0.18u)' nrd='0.18u / W' nrs='0.18u / W' sa=0 sb=0 sd=0 m=16
XC4 VTOP VBOT4 cap_mim_2f0_m4m5_noshield c_width=6.855e-6 c_length=6.855e-6 m=7.9886175295008108
XM9 VBOT5 DCTRL5 VREFN GND nfet_03v3 L=0.28u W=1.56u nf=1 ad='int((nf+1)/2) * W/nf * 0.18u' as='int((nf+2)/2) * W/nf * 0.18u' pd='2*int((nf+1)/2) * (W/nf + 0.18u)'
+ ps='2*int((nf+2)/2) * (W/nf + 0.18u)' nrd='0.18u / W' nrs='0.18u / W' sa=0 sb=0 sd=0 m=32
XM10 VBOT5 DCTRL5 VREFP VDD pfet_03v3 L=0.28u W=1.56u nf=1 ad='int((nf+1)/2) * W/nf * 0.18u' as='int((nf+2)/2) * W/nf * 0.18u'
+ pd='2*int((nf+1)/2) * (W/nf + 0.18u)' ps='2*int((nf+2)/2) * (W/nf + 0.18u)' nrd='0.18u / W' nrs='0.18u / W' sa=0 sb=0 sd=0 m=32
XC5 VTOP VBOT5 cap_mim_2f0_m4m5_noshield c_width=6.855e-6 c_length=6.855e-6 m=16.024050911411695
XM11 VBOT6 DCTRL6 VREFN GND nfet_03v3 L=0.28u W=1.56u nf=1 ad='int((nf+1)/2) * W/nf * 0.18u' as='int((nf+2)/2) * W/nf * 0.18u'
+ pd='2*int((nf+1)/2) * (W/nf + 0.18u)' ps='2*int((nf+2)/2) * (W/nf + 0.18u)' nrd='0.18u / W' nrs='0.18u / W' sa=0 sb=0 sd=0 m=64
XM12 VBOT6 DCTRL6 VREFP VDD pfet_03v3 L=0.28u W=1.56u nf=1 ad='int((nf+1)/2) * W/nf * 0.18u' as='int((nf+2)/2) * W/nf * 0.18u'
+ pd='2*int((nf+1)/2) * (W/nf + 0.18u)' ps='2*int((nf+2)/2) * (W/nf + 0.18u)' nrd='0.18u / W' nrs='0.18u / W' sa=0 sb=0 sd=0 m=64
XC6 VTOP VBOT6 cap_mim_2f0_m4m5_noshield c_width=6.855e-6 c_length=6.855e-6 m=31.95126817497211
XM13 VBOT7 DCTRL7 VREFN GND nfet_03v3 L=0.28u W=1.56u nf=1 ad='int((nf+1)/2) * W/nf * 0.18u' as='int((nf+2)/2) * W/nf * 0.18u'
+ pd='2*int((nf+1)/2) * (W/nf + 0.18u)' ps='2*int((nf+2)/2) * (W/nf + 0.18u)' nrd='0.18u / W' nrs='0.18u / W' sa=0 sb=0 sd=0 m=128
XM14 VBOT7 DCTRL7 VREFP VDD pfet_03v3 L=0.28u W=1.56u nf=1 ad='int((nf+1)/2) * W/nf * 0.18u' as='int((nf+2)/2) * W/nf * 0.18u'
+ pd='2*int((nf+1)/2) * (W/nf + 0.18u)' ps='2*int((nf+2)/2) * (W/nf + 0.18u)' nrd='0.18u / W' nrs='0.18u / W' sa=0 sb=0 sd=0 m=128
XC7 VTOP VBOT7 cap_mim_2f0_m4m5_noshield c_width=6.855e-6 c_length=6.855e-6 m=64.042153577555823
XC8 VTOP GND cap_mim_2f0_m4m5_noshield c_width=6.855e-6 c_length=6.855e-6 m=0.9911635762663269
x1 CLKS VDD GND VTOP VIN SWITCH_BOOT_SP
.ends CDAC_P_S012
.subckt CDAC_N_S012 VIN CLKS VTOP DCTRL7 DCTRL6 DCTRL5 DCTRL4 DCTRL3 DCTRL2 DCTRL1 VREFP VDD GND VREFN
XM1 VBOT1 DCTRL1 VREFN GND nfet_03v3 L=0.28u W=1.56u nf=1 ad='int((nf+1)/2) * W/nf * 0.18u' as='int((nf+2)/2) * W/nf * 0.18u' pd='2*int((nf+1)/2) * (W/nf + 0.18u)'
+ ps='2*int((nf+2)/2) * (W/nf + 0.18u)' nrd='0.18u / W' nrs='0.18u / W' sa=0 sb=0 sd=0 m=2
XM2 VBOT1 DCTRL1 VREFP VDD pfet_03v3 L=0.28u W=1.56u nf=1 ad='int((nf+1)/2) * W/nf * 0.18u' as='int((nf+2)/2) * W/nf * 0.18u' pd='2*int((nf+1)/2) * (W/nf + 0.18u)'
+ ps='2*int((nf+2)/2) * (W/nf + 0.18u)' nrd='0.18u / W' nrs='0.18u / W' sa=0 sb=0 sd=0 m=2
XC1 VTOP VBOT1 cap_mim_2f0_m4m5_noshield c_width=6.855e-6 c_length=6.855e-6 m=1.0245326294431989
XM3 VBOT2 DCTRL2 VREFN GND nfet_03v3 L=0.28u W=1.56u nf=1 ad='int((nf+1)/2) * W/nf * 0.18u' as='int((nf+2)/2) * W/nf * 0.18u' pd='2*int((nf+1)/2) * (W/nf + 0.18u)'
+ ps='2*int((nf+2)/2) * (W/nf + 0.18u)' nrd='0.18u / W' nrs='0.18u / W' sa=0 sb=0 sd=0 m=4
XM4 VBOT2 DCTRL2 VREFP VDD pfet_03v3 L=0.28u W=1.56u nf=1 ad='int((nf+1)/2) * W/nf * 0.18u' as='int((nf+2)/2) * W/nf * 0.18u' pd='2*int((nf+1)/2) * (W/nf + 0.18u)'
+ ps='2*int((nf+2)/2) * (W/nf + 0.18u)' nrd='0.18u / W' nrs='0.18u / W' sa=0 sb=0 sd=0 m=4
XC2 VTOP VBOT2 cap_mim_2f0_m4m5_noshield c_width=6.855e-6 c_length=6.855e-6 m=1.9852553612250894
XM5 VBOT3 DCTRL3 VREFN GND nfet_03v3 L=0.28u W=1.56u nf=1 ad='int((nf+1)/2) * W/nf * 0.18u' as='int((nf+2)/2) * W/nf * 0.18u' pd='2*int((nf+1)/2) * (W/nf + 0.18u)'
+ ps='2*int((nf+2)/2) * (W/nf + 0.18u)' nrd='0.18u / W' nrs='0.18u / W' sa=0 sb=0 sd=0 m=8
XM6 VBOT3 DCTRL3 VREFP VDD pfet_03v3 L=0.28u W=1.56u nf=1 ad='int((nf+1)/2) * W/nf * 0.18u' as='int((nf+2)/2) * W/nf * 0.18u' pd='2*int((nf+1)/2) * (W/nf + 0.18u)'
+ ps='2*int((nf+2)/2) * (W/nf + 0.18u)' nrd='0.18u / W' nrs='0.18u / W' sa=0 sb=0 sd=0 m=8
XC3 VTOP VBOT3 cap_mim_2f0_m4m5_noshield c_width=6.855e-6 c_length=6.855e-6 m=3.9967849843192127
XM7 VBOT4 DCTRL4 VREFN GND nfet_03v3 L=0.28u W=1.56u nf=1 ad='int((nf+1)/2) * W/nf * 0.18u' as='int((nf+2)/2) * W/nf * 0.18u' pd='2*int((nf+1)/2) * (W/nf + 0.18u)'
+ ps='2*int((nf+2)/2) * (W/nf + 0.18u)' nrd='0.18u / W' nrs='0.18u / W' sa=0 sb=0 sd=0 m=16
XM8 VBOT4 DCTRL4 VREFP VDD pfet_03v3 L=0.28u W=1.56u nf=1 ad='int((nf+1)/2) * W/nf * 0.18u' as='int((nf+2)/2) * W/nf * 0.18u' pd='2*int((nf+1)/2) * (W/nf + 0.18u)'
+ ps='2*int((nf+2)/2) * (W/nf + 0.18u)' nrd='0.18u / W' nrs='0.18u / W' sa=0 sb=0 sd=0 m=16
XC4 VTOP VBOT4 cap_mim_2f0_m4m5_noshield c_width=6.855e-6 c_length=6.855e-6 m=8.0054686666296142
XM9 VBOT5 DCTRL5 VREFN GND nfet_03v3 L=0.28u W=1.56u nf=1 ad='int((nf+1)/2) * W/nf * 0.18u' as='int((nf+2)/2) * W/nf * 0.18u' pd='2*int((nf+1)/2) * (W/nf + 0.18u)'
+ ps='2*int((nf+2)/2) * (W/nf + 0.18u)' nrd='0.18u / W' nrs='0.18u / W' sa=0 sb=0 sd=0 m=32
XM10 VBOT5 DCTRL5 VREFP VDD pfet_03v3 L=0.28u W=1.56u nf=1 ad='int((nf+1)/2) * W/nf * 0.18u' as='int((nf+2)/2) * W/nf * 0.18u'
+ pd='2*int((nf+1)/2) * (W/nf + 0.18u)' ps='2*int((nf+2)/2) * (W/nf + 0.18u)' nrd='0.18u / W' nrs='0.18u / W' sa=0 sb=0 sd=0 m=32
XC5 VTOP VBOT5 cap_mim_2f0_m4m5_noshield c_width=6.855e-6 c_length=6.855e-6 m=16.003760206440177
XM11 VBOT6 DCTRL6 VREFN GND nfet_03v3 L=0.28u W=1.56u nf=1 ad='int((nf+1)/2) * W/nf * 0.18u' as='int((nf+2)/2) * W/nf * 0.18u'
+ pd='2*int((nf+1)/2) * (W/nf + 0.18u)' ps='2*int((nf+2)/2) * (W/nf + 0.18u)' nrd='0.18u / W' nrs='0.18u / W' sa=0 sb=0 sd=0 m=64
XM12 VBOT6 DCTRL6 VREFP VDD pfet_03v3 L=0.28u W=1.56u nf=1 ad='int((nf+1)/2) * W/nf * 0.18u' as='int((nf+2)/2) * W/nf * 0.18u'
+ pd='2*int((nf+1)/2) * (W/nf + 0.18u)' ps='2*int((nf+2)/2) * (W/nf + 0.18u)' nrd='0.18u / W' nrs='0.18u / W' sa=0 sb=0 sd=0 m=64
XC6 VTOP VBOT6 cap_mim_2f0_m4m5_noshield c_width=6.855e-6 c_length=6.855e-6 m=31.979524276813116
XM13 VBOT7 DCTRL7 VREFN GND nfet_03v3 L=0.28u W=1.56u nf=1 ad='int((nf+1)/2) * W/nf * 0.18u' as='int((nf+2)/2) * W/nf * 0.18u'
+ pd='2*int((nf+1)/2) * (W/nf + 0.18u)' ps='2*int((nf+2)/2) * (W/nf + 0.18u)' nrd='0.18u / W' nrs='0.18u / W' sa=0 sb=0 sd=0 m=128
XM14 VBOT7 DCTRL7 VREFP VDD pfet_03v3 L=0.28u W=1.56u nf=1 ad='int((nf+1)/2) * W/nf * 0.18u' as='int((nf+2)/2) * W/nf * 0.18u'
+ pd='2*int((nf+1)/2) * (W/nf + 0.18u)' ps='2*int((nf+2)/2) * (W/nf + 0.18u)' nrd='0.18u / W' nrs='0.18u / W' sa=0 sb=0 sd=0 m=128
XC7 VTOP VBOT7 cap_mim_2f0_m4m5_noshield c_width=6.855e-6 c_length=6.855e-6 m=64.017866369109143
XC8 VTOP GND cap_mim_2f0_m4m5_noshield c_width=6.855e-6 c_length=6.855e-6 m=0.99036802174883032
x1 CLKS VDD GND VTOP VIN SWITCH_BOOT_SP
.ends CDAC_N_S012

.subckt SAR_ADC_ACTIVE VDD GND VREFP VREFN VINP VINN CLKS CMPCK
+ DCTRLP7 DCTRLP6 DCTRLP5 DCTRLP4 DCTRLP3 DCTRLP2 DCTRLP1
+ DCTRLN7 DCTRLN6 DCTRLN5 DCTRLN4 DCTRLN3 DCTRLN2 DCTRLN1
+ DCMPP DCMPN VRESP VRESN CMPNOISE
XCDACP VINP CLKS VRESP_RAW DCTRLP7 DCTRLP6 DCTRLP5 DCTRLP4 DCTRLP3 DCTRLP2 DCTRLP1 VREFP VDD GND VREFN CDAC_P_S012
XCDACN VINN CLKS VRESN_RAW DCTRLN7 DCTRLN6 DCTRLN5 DCTRLN4 DCTRLN3 DCTRLN2 DCTRLN1 VREFP VDD GND VREFN CDAC_N_S012
E_CMP_NOISE_P VRESP VRESP_RAW CMPNOISE GND 0.5
E_CMP_NOISE_N VRESN VRESN_RAW CMPNOISE GND -0.5
XCMP CMPCK DCMPP VRESP DCMPN VRESN VDD GND Comparator_StrongARM
.ends SAR_ADC_ACTIVE

.temp 27
VVDD vdd 0 3.3
VVREFP_ID vrefp_src 0 2.5
RVREFP vrefp_src vrefp {REF_R_EQ}
RVREFP_ESR vrefp vrefp_cap {REF_ESR_EQ}
CVREFP_LOCAL vrefp_cap 0 {REF_CLOCAL_EQ}
CVREFP_LINE vrefp 0 {REF_CLINE_EQ}
VVREFN_ID vrefn_src 0 0.8
RVREFN vrefn_src vrefn {REF_R_EQ}
RVREFN_ESR vrefn vrefn_cap {REF_ESR_EQ}
CVREFN_LOCAL vrefn_cap 0 {REF_CLOCAL_EQ}
CVREFN_LINE vrefn 0 {REF_CLINE_EQ}

VVINP_ID vinp_src 0 PWL(
+ 0 2.291378445 4.99999e-07 2.291378445 5e-07 2.39243295423 9.99999e-07 2.39243295423
+ 1e-06 2.15637583051 1.499999e-06 2.15637583051 1.5e-06 1.69045355446 1.999999e-06 1.69045355446
+ 2e-06 1.2062047018 2.499999e-06 1.2062047018 2.5e-06 0.923360181102 2.999999e-06 0.923360181102
+ 3e-06 0.970426895146 3.499999e-06 0.970426895146 3.5e-06 1.32595774033 3.999999e-06 1.32595774033
+ 4e-06 1.82867202648 4.499999e-06 1.82867202648 4.5e-06 2.25020302188 4.999999e-06 2.25020302188
+ 5e-06 2.39927613797 5.499999e-06 2.39927613797 5.5e-06 2.20817738501 5.999999e-06 2.20817738501
+ 6e-06 1.76365207554 6.499999e-06 1.76365207554 6.5e-06 1.26760607332 6.999999e-06 1.26760607332
+ 7e-06 0.945072118609 7.499999e-06 0.945072118609 7.5e-06 0.94257795602 7.999999e-06 0.94257795602
+ 8e-06 1.26130920921 8.499999e-06 1.26130920921 8.5e-06 1.75637886999 8.999999e-06 1.75637886999
+ 9e-06 2.20319605294 9.499999e-06 2.20319605294 9.5e-06 2.39886725052 9.999999e-06 2.39886725052
+ 1e-05 2.25459005646 1.0499999e-05 2.25459005646 1.05e-05 1.83574278287 1.0999999e-05 1.83574278287
+ 1.1e-05 1.33268473999 1.1499999e-05 1.33268473999 1.15e-05 0.97358035413 1.1999999e-05 0.97358035413
+ 1.2e-05 0.921595729766 1.2499999e-05 0.921595729766 1.25e-05 1.20029834076 1.2999999e-05 1.20029834076
+ 1.3e-05 1.68309840427 1.3499999e-05 1.68309840427 1.35e-05 2.15093637422 1.3999999e-05 2.15093637422
+ 1.4e-05 2.39133922518 1.4499999e-05 2.39133922518 1.45e-05 2.29520764623 1.4999999e-05 2.29520764623
+ 1.5e-05 1.90610414232 1.5499999e-05 1.90610414232 1.55e-05 1.40077470212 1.5999999e-05 1.40077470212
+ 1.6e-05 1.00858396578 1.6499999e-05 1.00858396578 1.65e-05 0.907544328336 1.6999999e-05 0.907544328336
+ 1.7e-05 1.14358956596 1.7499999e-05 1.14358956596 1.75e-05 1.60954275668 1.7999999e-05 1.60954275668
+ 1.8e-05 2.09386338507 1.8499999e-05 2.09386338507 1.85e-05 2.37662388564 1.8999999e-05 2.37662388564
+ 1.9e-05 2.32956989084 1.9499999e-05 2.32956989084 1.95e-05 1.97396825773 1.9999999e-05 1.97396825773
+ 2e-05 1.47130233706 2.0499999e-05 1.47130233706 2.05e-05 1.04975618836 2.0999999e-05 1.04975618836
+ 2.1e-05 0.900734279892 2.1499999e-05 0.900734279892 2.15e-05 1.09184900644 2.1999999e-05 1.09184900644
+ 2.2e-05 1.53629130543 2.2499999e-05 1.53629130543 2.25e-05 2.03239297414 2.2999999e-05 2.03239297414
+ 2.3e-05 2.35496929082 2.3499999e-05 2.35496929082 2.35e-05 2.35738060505 2.3999999e-05 2.35738060505
+ 2.4e-05 2.03862038444 2.4499999e-05 2.03862038444 2.45e-05 1.54358956716 2.4999999e-05 1.54358956716
+ 2.5e-05 1.09683685728 2.5499999e-05 1.09683685728 2.55e-05 0.901117434413 2.5999999e-05 0.901117434413
+ 2.6e-05 1.04544377286 2.6499999e-05 1.04544377286 2.65e-05 1.46423379915 2.6999999e-05 1.46423379915
+ 2.7e-05 1.96736470411 2.7499999e-05 1.96736470411 2.75e-05 2.32640630758 2.7999999e-05 2.32640630758
+ 2.8e-05 2.37841045206 2.8499999e-05 2.37841045206 2.85e-05 2.09975827417 2.8999999e-05 2.09975827417
+ 2.9e-05 1.61688502981 2.9499999e-05 1.61688502981 2.95e-05 1.14910213721 2.9999999e-05 1.14910213721
+ 3e-05 0.908581415797 3.0499999e-05 0.908581415797 3.05e-05 1.00481700514 3.0999999e-05 1.00481700514
+ 3.1e-05 1.39385909356 3.1499999e-05 1.39385909356 3.15e-05 1.89921470926 3.1999999e-05 1.89921470926
+ 3.2e-05 2.29142846133 3.2499999e-05 2.29142846133 3.25e-05 2.39242106366 3.2999999e-05 2.39242106366
+ 3.3e-05 2.15636509889 3.3499999e-05 2.15636509889 3.35e-05 1.69045162316
+ )
VVINN_ID vinn_src 0 PWL(
+ 0 1.008621555 4.99999e-07 1.008621555 5e-07 0.907567045766 9.99999e-07 0.907567045766
+ 1e-06 1.14362416949 1.499999e-06 1.14362416949 1.5e-06 1.60954644554 1.999999e-06 1.60954644554
+ 2e-06 2.0937952982 2.499999e-06 2.0937952982 2.5e-06 2.3766398189 2.999999e-06 2.3766398189
+ 3e-06 2.32957310485 3.499999e-06 2.32957310485 3.5e-06 1.97404225967 3.999999e-06 1.97404225967
+ 4e-06 1.47132797352 4.499999e-06 1.47132797352 4.5e-06 1.04979697812 4.999999e-06 1.04979697812
+ 5e-06 0.900723862032 5.499999e-06 0.900723862032 5.5e-06 1.09182261499 5.999999e-06 1.09182261499
+ 6e-06 1.53634792446 6.499999e-06 1.53634792446 6.5e-06 2.03239392668 6.999999e-06 2.03239392668
+ 7e-06 2.35492788139 7.499999e-06 2.35492788139 7.5e-06 2.35742204398 7.999999e-06 2.35742204398
+ 8e-06 2.03869079079 8.499999e-06 2.03869079079 8.5e-06 1.54362113001 8.999999e-06 1.54362113001
+ 9e-06 1.09680394706 9.499999e-06 1.09680394706 9.5e-06 0.901132749479 9.999999e-06 0.901132749479
+ 1e-05 1.04540994354 1.0499999e-05 1.04540994354 1.05e-05 1.46425721713 1.0999999e-05 1.46425721713
+ 1.1e-05 1.96731526001 1.1499999e-05 1.96731526001 1.15e-05 2.32641964587 1.1999999e-05 2.32641964587
+ 1.2e-05 2.37840427023 1.2499999e-05 2.37840427023 1.25e-05 2.09970165924 1.2999999e-05 2.09970165924
+ 1.3e-05 1.61690159573 1.3499999e-05 1.61690159573 1.35e-05 1.14906362578 1.3999999e-05 1.14906362578
+ 1.4e-05 0.908660774816 1.4499999e-05 0.908660774816 1.45e-05 1.00479235377 1.4999999e-05 1.00479235377
+ 1.5e-05 1.39389585768 1.5499999e-05 1.39389585768 1.55e-05 1.89922529788 1.5999999e-05 1.89922529788
+ 1.6e-05 2.29141603422 1.6499999e-05 2.29141603422 1.65e-05 2.39245567166 1.6999999e-05 2.39245567166
+ 1.7e-05 2.15641043404 1.7499999e-05 2.15641043404 1.75e-05 1.69045724332 1.7999999e-05 1.69045724332
+ 1.8e-05 1.20613661493 1.8499999e-05 1.20613661493 1.85e-05 0.923376114364 1.8999999e-05 0.923376114364
+ 1.9e-05 0.970430109156 1.9499999e-05 0.970430109156 1.95e-05 1.32603174227 1.9999999e-05 1.32603174227
+ 2e-05 1.82869766294 2.0499999e-05 1.82869766294 2.05e-05 2.25024381164 2.0999999e-05 2.25024381164
+ 2.1e-05 2.39926572011 2.1499999e-05 2.39926572011 2.15e-05 2.20815099356 2.1999999e-05 2.20815099356
+ 2.2e-05 1.76370869457 2.2499999e-05 1.76370869457 2.25e-05 1.26760702586 2.2999999e-05 1.26760702586
+ 2.3e-05 0.945030709177 2.3499999e-05 0.945030709177 2.35e-05 0.942619394945 2.3999999e-05 0.942619394945
+ 2.4e-05 1.26137961556 2.4499999e-05 1.26137961556 2.45e-05 1.75641043284 2.4999999e-05 1.75641043284
+ 2.5e-05 2.20316314272 2.5499999e-05 2.20316314272 2.55e-05 2.39888256559 2.5999999e-05 2.39888256559
+ 2.6e-05 2.25455622714 2.6499999e-05 2.25455622714 2.65e-05 1.83576620085 2.6999999e-05 1.83576620085
+ 2.7e-05 1.33263529589 2.7499999e-05 1.33263529589 2.75e-05 0.973593692421 2.7999999e-05 0.973593692421
+ 2.8e-05 0.921589547938 2.8499999e-05 0.921589547938 2.85e-05 1.20024172583 2.8999999e-05 1.20024172583
+ 2.9e-05 1.68311497019 2.9499999e-05 1.68311497019 2.95e-05 2.15089786279 2.9999999e-05 2.15089786279
+ 3e-05 2.3914185842 3.0499999e-05 2.3914185842 3.05e-05 2.29518299486 3.0999999e-05 2.29518299486
+ 3.1e-05 1.90614090644 3.1499999e-05 1.90614090644 3.15e-05 1.40078529074 3.1999999e-05 1.40078529074
+ 3.2e-05 1.00857153867 3.2499999e-05 1.00857153867 3.25e-05 0.90757893634 3.2999999e-05 0.90757893634
+ 3.3e-05 1.14363490111 3.3499999e-05 1.14363490111 3.35e-05 1.60954837684
+ )
RVINP vinp_src vinp {VIN_R_EQ}
CVINP vinp 0 {VIN_CP_EQ+VIN_CCM_EQ}
RVINN vinn_src vinn {VIN_R_EQ}
CVINN vinn 0 {VIN_CN_EQ+VIN_CCM_EQ}
CVIN_DIFF vinp vinn {VIN_CDM_EQ}

VCLKS_ID clks_src 0 PULSE(0 3.3 5e-08 {CLK_TR_EQ} {CLK_TF_EQ} 125n 5e-07)
RCLKS clks_src clks {CLK_R_EQ}
CCLKS clks 0 {CLK_C_EQ}

VCMP_NOISE cmp_noise 0 PWL(
+ 0 -0.001242928030117153 1.92864e-07 -0.001242928030117153 1.92964e-07 0.00065609816552011132 2.18224e-07 0.00065609816552011132
+ 2.18324e-07 0.0025566269768774299 2.43767e-07 0.0025566269768774299 2.43867e-07 0.0018280550292261071 2.69234e-07 0.0018280550292261071
+ 2.69334e-07 -0.00021399647363861746 2.94596e-07 -0.00021399647363861746 2.94696e-07 6.5710381322561098e-05 3.20034e-07 6.5710381322561098e-05
+ 3.20134e-07 0.0036117532483661923 3.45579e-07 0.0036117532483661923 3.45679e-07 0.0010712676656955639 5.099e-07 0.0010712676656955639
+ 5.1e-07 -0.0010826216941352922 6.92864e-07 -0.0010826216941352922 6.92964e-07 -0.00085431827728467457 7.18224e-07 -0.00085431827728467457
+ 7.18324e-07 -0.0005961802942245465 7.43767e-07 -0.0005961802942245465 7.43867e-07 9.5062481692356147e-05 7.69234e-07 9.5062481692356147e-05
+ 7.69334e-07 -0.00029829425019418861 7.94596e-07 -0.00029829425019418861 7.94696e-07 -0.0014490490141315993 8.20034e-07 -0.0014490490141315993
+ 8.20134e-07 0.00034052756441063447 8.45579e-07 0.00034052756441063447 8.45679e-07 -0.0023333892104348856 1.0099e-06 -0.0023333892104348856
+ 1.01e-06 -0.00046930363160202872 1.192864e-06 -0.00046930363160202872 1.192964e-06 0.0037608147957986613 1.218224e-06 0.0037608147957986613
+ 1.218324e-06 -0.001983798430444962 1.243767e-06 -0.001983798430444962 1.243867e-06 0.0011147610940825275 1.269234e-06 0.0011147610940825275
+ 1.269334e-06 -0.00035644947675447206 1.294596e-06 -0.00035644947675447206 1.294696e-06 0.0013952286574794781 1.320034e-06 0.0013952286574794781
+ 1.320134e-06 -0.00023446168793623542 1.345579e-06 -0.00023446168793623542 1.345679e-06 0.0003868690054402893 1.5099e-06 0.0003868690054402893
+ 1.51e-06 0.0015059836243246306 1.692864e-06 0.0015059836243246306 1.692964e-06 0.0017253423012674853 1.718224e-06 0.0017253423012674853
+ 1.718324e-06 -0.0014616372847063772 1.743767e-06 -0.0014616372847063772 1.743867e-06 0.0011327921866656778 1.769234e-06 0.0011327921866656778
+ 1.769334e-06 0.00052196770671736933 1.794596e-06 0.00052196770671736933 1.794696e-06 -0.00036131450297441966 1.820034e-06 -0.00036131450297441966
+ 1.820134e-06 0.0011383942857739876 1.845579e-06 0.0011383942857739876 1.845679e-06 -0.00050942592675359518 2.0099e-06 -0.00050942592675359518
+ 2.01e-06 -0.00093772966547173695 2.192864e-06 -0.00093772966547173695 2.192964e-06 0.0022998706058691785 2.218224e-06 0.0022998706058691785
+ 2.218324e-06 -0.0012098022239690589 2.243767e-06 -0.0012098022239690589 2.243867e-06 -0.00016919003510760031 2.269234e-06 -0.00016919003510760031
+ 2.269334e-06 0.0015122471493848745 2.294596e-06 0.0015122471493848745 2.294696e-06 0.00010028372284822189 2.320034e-06 0.00010028372284822189
+ 2.320134e-06 -0.00040556486575533203 2.345579e-06 -0.00040556486575533203 2.345679e-06 -0.002603138556495058 2.5099e-06 -0.002603138556495058
+ 2.51e-06 0.00092003825550262229 2.692864e-06 0.00092003825550262229 2.692964e-06 0.0005706431317881028 2.718224e-06 0.0005706431317881028
+ 2.718324e-06 0.0013335230069130067 2.743767e-06 0.0013335230069130067 2.743867e-06 -0.00035674477914901325 2.769234e-06 -0.00035674477914901325
+ 2.769334e-06 -0.0023389967093713202 2.794596e-06 -0.0023389967093713202 2.794696e-06 -0.0013497888095449272 2.820034e-06 -0.0013497888095449272
+ 2.820134e-06 -0.00032051763635784325 2.845579e-06 -0.00032051763635784325 2.845679e-06 0.00012327852087348404 3.0099e-06 0.00012327852087348404
+ 3.01e-06 0.0015769446140694284 3.192864e-06 0.0015769446140694284 3.192964e-06 -0.0018866590402514278 3.218224e-06 -0.0018866590402514278
+ 3.218324e-06 0.002233161558022034 3.243767e-06 0.002233161558022034 3.243867e-06 -0.00067429806670010859 3.269234e-06 -0.00067429806670010859
+ 3.269334e-06 -0.0022776775439969747 3.294596e-06 -0.0022776775439969747 3.294696e-06 0.0022597173760866536 3.320034e-06 0.0022597173760866536
+ 3.320134e-06 0.0021831187110852982 3.345579e-06 0.0021831187110852982 3.345679e-06 -0.0023200982610469792 3.5099e-06 -0.0023200982610469792
+ 3.51e-06 0.00072729756702187033 3.692864e-06 0.00072729756702187033 3.692964e-06 -0.001579824800949511 3.718224e-06 -0.001579824800949511
+ 3.718324e-06 0.0026798541739172827 3.743767e-06 0.0026798541739172827 3.743867e-06 -0.0010105232349311413 3.769234e-06 -0.0010105232349311413
+ 3.769334e-06 -0.0020430758802331135 3.794596e-06 -0.0020430758802331135 3.794696e-06 -0.0014339829410747549 3.820034e-06 -0.0014339829410747549
+ 3.820134e-06 0.0017570264044465143 3.845579e-06 0.0017570264044465143 3.845679e-06 -0.0017085842252994689 4.0099e-06 -0.0017085842252994689
+ 4.01e-06 0.002601146003363696 4.192864e-06 0.002601146003363696 4.192964e-06 0.00059861223201514277 4.218224e-06 0.00059861223201514277
+ 4.218324e-06 0.0020783860103904383 4.243767e-06 0.0020783860103904383 4.243867e-06 -0.0002499050412105928 4.269234e-06 -0.0002499050412105928
+ 4.269334e-06 0.0014428438299071984 4.294596e-06 0.0014428438299071984 4.294696e-06 0.0024065089812691904 4.320034e-06 0.0024065089812691904
+ 4.320134e-06 0.0014561881316991242 4.345579e-06 0.0014561881316991242 4.345679e-06 0.0014450179760253051 4.5099e-06 0.0014450179760253051
+ 4.51e-06 0.001257030769566579 4.692864e-06 0.001257030769566579 4.692964e-06 -0.0010294444666975387 4.718224e-06 -0.0010294444666975387
+ 4.718324e-06 0.00032669726914129847 4.743767e-06 0.00032669726914129847 4.743867e-06 0.00041009689334817228 4.769234e-06 0.00041009689334817228
+ 4.769334e-06 0.00087943182306918276 4.794596e-06 0.00087943182306918276 4.794696e-06 0.00069953186269866422 4.820034e-06 0.00069953186269866422
+ 4.820134e-06 0.00034702708947876866 4.845579e-06 0.00034702708947876866 4.845679e-06 -4.7315751113436087e-05 5.0099e-06 -4.7315751113436087e-05
+ 5.01e-06 -0.0026290696541003827 5.192864e-06 -0.0026290696541003827 5.192964e-06 -0.0017802290067536581 5.218224e-06 -0.0017802290067536581
+ 5.218324e-06 0.00044823983823002929 5.243767e-06 0.00044823983823002929 5.243867e-06 2.7868911715264176e-05 5.269234e-06 2.7868911715264176e-05
+ 5.269334e-06 -2.9087818305509025e-05 5.294596e-06 -2.9087818305509025e-05 5.294696e-06 3.5142161115445932e-05 5.320034e-06 3.5142161115445932e-05
+ 5.320134e-06 -0.00041047593156203047 5.345579e-06 -0.00041047593156203047 5.345679e-06 -5.4716941958941514e-05 5.5099e-06 -5.4716941958941514e-05
+ 5.51e-06 -0.00021475053733342709 5.692864e-06 -0.00021475053733342709 5.692964e-06 -0.0027970158748529422 5.718224e-06 -0.0027970158748529422
+ 5.718324e-06 -0.00070559342717575312 5.743767e-06 -0.00070559342717575312 5.743867e-06 -2.4721945103773589e-05 5.769234e-06 -2.4721945103773589e-05
+ 5.769334e-06 -0.001727092452187666 5.794596e-06 -0.001727092452187666 5.794696e-06 -0.0018555373582529019 5.820034e-06 -0.0018555373582529019
+ 5.820134e-06 -0.00020707577387527113 5.845579e-06 -0.00020707577387527113 5.845679e-06 -9.6814952723504484e-05 6.0099e-06 -9.6814952723504484e-05
+ 6.01e-06 0.0027078320086090907 6.192864e-06 0.0027078320086090907 6.192964e-06 -0.00095265032997253452 6.218224e-06 -0.00095265032997253452
+ 6.218324e-06 0.00041820063193266833 6.243767e-06 0.00041820063193266833 6.243867e-06 0.00031863500868278892 6.269234e-06 0.00031863500868278892
+ 6.269334e-06 0.00065318158562083499 6.294596e-06 0.00065318158562083499 6.294696e-06 0.00099931828352932362 6.320034e-06 0.00099931828352932362
+ 6.320134e-06 0.0032921247209411761 6.345579e-06 0.0032921247209411761 6.345679e-06 0.00015605966457064171 6.5099e-06 0.00015605966457064171
+ 6.51e-06 0.0005218118700365175 6.692864e-06 0.0005218118700365175 6.692964e-06 -0.0021944805458458702 6.718224e-06 -0.0021944805458458702
+ 6.718324e-06 0.0013568062408175058 6.743767e-06 0.0013568062408175058 6.743867e-06 0.00092603500537389184 6.769234e-06 0.00092603500537389184
+ 6.769334e-06 -0.0012775897072325147 6.794596e-06 -0.0012775897072325147 6.794696e-06 -0.00093859257286219358 6.820034e-06 -0.00093859257286219358
+ 6.820134e-06 -0.0017677899046924816 6.845579e-06 -0.0017677899046924816 6.845679e-06 -0.00029106044429321923 7.0099e-06 -0.00029106044429321923
+ 7.01e-06 -0.0016184911387206622 7.192864e-06 -0.0016184911387206622 7.192964e-06 -0.00054222440603989073 7.218224e-06 -0.00054222440603989073
+ 7.218324e-06 -0.0017553793050438199 7.243767e-06 -0.0017553793050438199 7.243867e-06 -0.00069590176153378597 7.269234e-06 -0.00069590176153378597
+ 7.269334e-06 6.9327807758234373e-05 7.294596e-06 6.9327807758234373e-05 7.294696e-06 -0.0026598388107375911 7.320034e-06 -0.0026598388107375911
+ 7.320134e-06 -0.00054377070030289592 7.345579e-06 -0.00054377070030289592 7.345679e-06 -0.0005571769854570887 7.5099e-06 -0.0005571769854570887
+ 7.51e-06 -0.0015727973609749705 7.692864e-06 -0.0015727973609749705 7.692964e-06 -0.0010342023307134481 7.718224e-06 -0.0010342023307134481
+ 7.718324e-06 -0.00075856582425020693 7.743767e-06 -0.00075856582425020693 7.743867e-06 -0.00020001447126098045 7.769234e-06 -0.00020001447126098045
+ 7.769334e-06 -0.00052586775873242819 7.794596e-06 -0.00052586775873242819 7.794696e-06 -0.00040403948248453418 7.820034e-06 -0.00040403948248453418
+ 7.820134e-06 0.00018342149698216703 7.845579e-06 0.00018342149698216703 7.845679e-06 -0.00029605516367903813 8.0099e-06 -0.00029605516367903813
+ 8.01e-06 -0.0004075941789941608 8.192864e-06 -0.0004075941789941608 8.192964e-06 0.0015149211775006728 8.218224e-06 0.0015149211775006728
+ 8.218324e-06 -0.00040771354502481177 8.243767e-06 -0.00040771354502481177 8.243867e-06 -0.0012408762542089717 8.269234e-06 -0.0012408762542089717
+ 8.269334e-06 0.00031153122261291631 8.294596e-06 0.00031153122261291631 8.294696e-06 -0.0043308795058419492 8.320034e-06 -0.0043308795058419492
+ 8.320134e-06 0.0047313517272616198 8.345579e-06 0.0047313517272616198 8.345679e-06 -0.00066123353110166894 8.5099e-06 -0.00066123353110166894
+ 8.51e-06 0.00075720467177514683 8.692864e-06 0.00075720467177514683 8.692964e-06 0.00034479120622575327 8.718224e-06 0.00034479120622575327
+ 8.718324e-06 0.0023359165339943847 8.743767e-06 0.0023359165339943847 8.743867e-06 0.0022110206445205803 8.769234e-06 0.0022110206445205803
+ 8.769334e-06 -0.0011624365215675706 8.794596e-06 -0.0011624365215675706 8.794696e-06 0.0012001618315159966 8.820034e-06 0.0012001618315159966
+ 8.820134e-06 0.0032417497552151607 8.845579e-06 0.0032417497552151607 8.845679e-06 -0.00037562971512998105 9.0099e-06 -0.00037562971512998105
+ 9.01e-06 0.001636761985243751 9.192864e-06 0.001636761985243751 9.192964e-06 -0.0029059102859459898 9.218224e-06 -0.0029059102859459898
+ 9.218324e-06 -0.0027066862378860098 9.243767e-06 -0.0027066862378860098 9.243867e-06 0.0012537394703477009 9.269234e-06 0.0012537394703477009
+ 9.269334e-06 -0.0020565991323770552 9.294596e-06 -0.0020565991323770552 9.294696e-06 0.00052480016648772797 9.320034e-06 0.00052480016648772797
+ 9.320134e-06 0.00057301356136982848 9.345579e-06 0.00057301356136982848 9.345679e-06 -0.00074668213267868166 9.5099e-06 -0.00074668213267868166
+ 9.51e-06 -0.00079566212865607292 9.692864e-06 -0.00079566212865607292 9.692964e-06 0.001441060158236593 9.718224e-06 0.001441060158236593
+ 9.718324e-06 -0.00027806955617321841 9.743767e-06 -0.00027806955617321841 9.743867e-06 -0.00049006231251273432 9.769234e-06 -0.00049006231251273432
+ 9.769334e-06 -0.00025512770788795877 9.794596e-06 -0.00025512770788795877 9.794696e-06 -0.0031325856396001947 9.820034e-06 -0.0031325856396001947
+ 9.820134e-06 0.0015882765371592028 9.845579e-06 0.0015882765371592028 9.845679e-06 6.4168450893499078e-05 1.00099e-05 6.4168450893499078e-05
+ 1.001e-05 0.0030400114639186908 1.0192864e-05 0.0030400114639186908 1.0192964e-05 -0.0035104981288432676 1.0218224e-05 -0.0035104981288432676
+ 1.0218324e-05 0.0014537427477302998 1.0243767e-05 0.0014537427477302998 1.0243867e-05 0.00070333453659287713 1.0269234e-05 0.00070333453659287713
+ 1.0269334e-05 0.00034810605551220442 1.0294596e-05 0.00034810605551220442 1.0294696e-05 0.00032106563763124521 1.0320034e-05 0.00032106563763124521
+ 1.0320134e-05 -0.00099631475584113414 1.0345579e-05 -0.00099631475584113414 1.0345679e-05 -0.0012490248965699358 1.05099e-05 -0.0012490248965699358
+ 1.051e-05 -0.00086131847642472597 1.0692864e-05 -0.00086131847642472597 1.0692964e-05 -0.0010230407335534591 1.0718224e-05 -0.0010230407335534591
+ 1.0718324e-05 -0.00014242842075216203 1.0743767e-05 -0.00014242842075216203 1.0743867e-05 -0.0011941234631770161 1.0769234e-05 -0.0011941234631770161
+ 1.0769334e-05 0.0035595760205774226 1.0794596e-05 0.0035595760205774226 1.0794696e-05 -0.0014069933359953271 1.0820034e-05 -0.0014069933359953271
+ 1.0820134e-05 -0.0010884589865620018 1.0845579e-05 -0.0010884589865620018 1.0845679e-05 -0.0020894586425481772 1.10099e-05 -0.0020894586425481772
+ 1.101e-05 9.9954677851467152e-06 1.1192864e-05 9.9954677851467152e-06 1.1192964e-05 0.00014690322516036644 1.1218224e-05 0.00014690322516036644
+ 1.1218324e-05 -0.00049866349068074516 1.1243767e-05 -0.00049866349068074516 1.1243867e-05 -0.001338345526203235 1.1269234e-05 -0.001338345526203235
+ 1.1269334e-05 0.00093660241736892949 1.1294596e-05 0.00093660241736892949 1.1294696e-05 -0.0010221123622517416 1.1320034e-05 -0.0010221123622517416
+ 1.1320134e-05 0.002552679759266395 1.1345579e-05 0.002552679759266395 1.1345679e-05 -0.0011213705244961514 1.15099e-05 -0.0011213705244961514
+ 1.151e-05 -0.00092949202521867131 1.1692864e-05 -0.00092949202521867131 1.1692964e-05 -0.00041732706686863248 1.1718224e-05 -0.00041732706686863248
+ 1.1718324e-05 -0.0009128519178434988 1.1743767e-05 -0.0009128519178434988 1.1743867e-05 -0.00079506498372205038 1.1769234e-05 -0.00079506498372205038
+ 1.1769334e-05 -0.0020156913604112746 1.1794596e-05 -0.0020156913604112746 1.1794696e-05 0.00030004626977377487 1.1820034e-05 0.00030004626977377487
+ 1.1820134e-05 -0.00035473025163384976 1.1845579e-05 -0.00035473025163384976 1.1845679e-05 -0.00057725532156135517 1.20099e-05 -0.00057725532156135517
+ 1.201e-05 0.0010025494401059037 1.2192864e-05 0.0010025494401059037 1.2192964e-05 -0.00039538658114645898 1.2218224e-05 -0.00039538658114645898
+ 1.2218324e-05 -0.0011445498734391224 1.2243767e-05 -0.0011445498734391224 1.2243867e-05 0.00035682042515134923 1.2269234e-05 0.00035682042515134923
+ 1.2269334e-05 8.4526258156417836e-06 1.2294596e-05 8.4526258156417836e-06 1.2294696e-05 4.0292103093404364e-05 1.2320034e-05 4.0292103093404364e-05
+ 1.2320134e-05 -0.00076230491089509112 1.2345579e-05 -0.00076230491089509112 1.2345679e-05 -0.00053334056162332531 1.25099e-05 -0.00053334056162332531
+ 1.251e-05 6.2158428184362909e-05 1.2692864e-05 6.2158428184362909e-05 1.2692964e-05 0.001001676358294859 1.2718224e-05 0.001001676358294859
+ 1.2718324e-05 0.00065666456294917529 1.2743767e-05 0.00065666456294917529 1.2743867e-05 0.0010739437027586459 1.2769234e-05 0.0010739437027586459
+ 1.2769334e-05 -0.0017225986634104645 1.2794596e-05 -0.0017225986634104645 1.2794696e-05 -0.00062792913358916257 1.2820034e-05 -0.00062792913358916257
+ 1.2820134e-05 0.00030871903438403999 1.2845579e-05 0.00030871903438403999 1.2845679e-05 0.00087344624301021129 1.30099e-05 0.00087344624301021129
+ 1.301e-05 -0.001559278343831463 1.3192864e-05 -0.001559278343831463 1.3192964e-05 3.6933313159756997e-05 1.3218224e-05 3.6933313159756997e-05
+ 1.3218324e-05 -0.0013575911812522476 1.3243767e-05 -0.0013575911812522476 1.3243867e-05 0.00081582704663863987 1.3269234e-05 0.00081582704663863987
+ 1.3269334e-05 0.00081286976109027677 1.3294596e-05 0.00081286976109027677 1.3294696e-05 -0.0023493898979875315 1.3320034e-05 -0.0023493898979875315
+ 1.3320134e-05 -0.0016965836374597057 1.3345579e-05 -0.0016965836374597057 1.3345679e-05 -0.0033292912682610625 1.35099e-05 -0.0033292912682610625
+ 1.351e-05 0.0010389107276736525 1.3692864e-05 0.0010389107276736525 1.3692964e-05 0.0016241574242858165 1.3718224e-05 0.0016241574242858165
+ 1.3718324e-05 0.0018947906032100803 1.3743767e-05 0.0018947906032100803 1.3743867e-05 0.0017522040849062524 1.3769234e-05 0.0017522040849062524
+ 1.3769334e-05 -0.0013695590033636058 1.3794596e-05 -0.0013695590033636058 1.3794696e-05 0.00042901275244643414 1.3820034e-05 0.00042901275244643414
+ 1.3820134e-05 -0.00066297892032647274 1.3845579e-05 -0.00066297892032647274 1.3845679e-05 -0.0022827956216739838 1.40099e-05 -0.0022827956216739838
+ 1.401e-05 -0.0010135196039163027 1.4192864e-05 -0.0010135196039163027 1.4192964e-05 0.0010308819009860401 1.4218224e-05 0.0010308819009860401
+ 1.4218324e-05 0.00042223171699705929 1.4243767e-05 0.00042223171699705929 1.4243867e-05 -0.00014300673711324199 1.4269234e-05 -0.00014300673711324199
+ 1.4269334e-05 -0.0011495256897085385 1.4294596e-05 -0.0011495256897085385 1.4294696e-05 -0.00021981867781362808 1.4320034e-05 -0.00021981867781362808
+ 1.4320134e-05 0.0011843201064772485 1.4345579e-05 0.0011843201064772485 1.4345679e-05 -0.0022889376133534592 1.45099e-05 -0.0022889376133534592
+ 1.451e-05 -0.00021284807654874436 1.4692864e-05 -0.00021284807654874436 1.4692964e-05 -0.0022332724987358487 1.4718224e-05 -0.0022332724987358487
+ 1.4718324e-05 0.0018127197376233948 1.4743767e-05 0.0018127197376233948 1.4743867e-05 -0.0010060690882626679 1.4769234e-05 -0.0010060690882626679
+ 1.4769334e-05 -0.0009828175759318766 1.4794596e-05 -0.0009828175759318766 1.4794696e-05 -0.0011775752336423517 1.4820034e-05 -0.0011775752336423517
+ 1.4820134e-05 0.0003050537663236519 1.4845579e-05 0.0003050537663236519 1.4845679e-05 -0.00019988015884145612 1.50099e-05 -0.00019988015884145612
+ 1.501e-05 -0.00061073141251814984 1.5192864e-05 -0.00061073141251814984 1.5192964e-05 0.00038729615870203738 1.5218224e-05 0.00038729615870203738
+ 1.5218324e-05 -0.0018152906603680339 1.5243767e-05 -0.0018152906603680339 1.5243867e-05 -0.0014552398364672857 1.5269234e-05 -0.0014552398364672857
+ 1.5269334e-05 -0.0012237712226975843 1.5294596e-05 -0.0012237712226975843 1.5294696e-05 8.7654791544749828e-05 1.5320034e-05 8.7654791544749828e-05
+ 1.5320134e-05 0.00033576736341337768 1.5345579e-05 0.00033576736341337768 1.5345679e-05 0.0028058975225335177 1.55099e-05 0.0028058975225335177
+ 1.551e-05 -0.00011097030489473896 1.5692864e-05 -0.00011097030489473896 1.5692964e-05 0.002166641515142227 1.5718224e-05 0.002166641515142227
+ 1.5718324e-05 0.0012506815315286033 1.5743767e-05 0.0012506815315286033 1.5743867e-05 -0.0010798962639656329 1.5769234e-05 -0.0010798962639656329
+ 1.5769334e-05 0.0029375569935713897 1.5794596e-05 0.0029375569935713897 1.5794696e-05 0.0011350053758644629 1.5820034e-05 0.0011350053758644629
+ 1.5820134e-05 -0.0027300478326682544 1.5845579e-05 -0.0027300478326682544 1.5845679e-05 0.002870785155532385 1.60099e-05 0.002870785155532385
+ 1.601e-05 0.00027633961502033941 1.6192864e-05 0.00027633961502033941 1.6192964e-05 -0.0023341716766914784 1.6218224e-05 -0.0023341716766914784
+ 1.6218324e-05 -0.00012040239624588135 1.6243767e-05 -0.00012040239624588135 1.6243867e-05 0.0030530773002611787 1.6269234e-05 0.0030530773002611787
+ 1.6269334e-05 5.3279272634196302e-05 1.6294596e-05 5.3279272634196302e-05 1.6294696e-05 -0.0012982392382597399 1.6320034e-05 -0.0012982392382597399
+ 1.6320134e-05 0.00038521308279821915 1.6345579e-05 0.00038521308279821915 1.6345679e-05 0.00014554519099411811 1.65099e-05 0.00014554519099411811
+ 1.651e-05 0.00066328092212345629 1.6692864e-05 0.00066328092212345629 1.6692964e-05 -0.0017114352170739401 1.6718224e-05 -0.0017114352170739401
+ 1.6718324e-05 -0.00035594309163145492 1.6743767e-05 -0.00035594309163145492 1.6743867e-05 0.0012925520193785476 1.6769234e-05 0.0012925520193785476
+ 1.6769334e-05 0.0010741120784239998 1.6794596e-05 0.0010741120784239998 1.6794696e-05 -0.0018793630468929422 1.6820034e-05 -0.0018793630468929422
+ 1.6820134e-05 0.0034240335864506102 1.6845579e-05 0.0034240335864506102 1.6845679e-05 -0.0012061873320740695 1.70099e-05 -0.0012061873320740695
+ 1.701e-05 -0.0004753171601422398 1.7192864e-05 -0.0004753171601422398 1.7192964e-05 -0.0016457216202247814 1.7218224e-05 -0.0016457216202247814
+ 1.7218324e-05 0.00027028268686699253 1.7243767e-05 0.00027028268686699253 1.7243867e-05 -5.9272152178498831e-05 1.7269234e-05 -5.9272152178498831e-05
+ 1.7269334e-05 0.00052196766753563064 1.7294596e-05 0.00052196766753563064 1.7294696e-05 0.0025690371201286676 1.7320034e-05 0.0025690371201286676
+ 1.7320134e-05 -0.00071553144281598792 1.7345579e-05 -0.00071553144281598792 1.7345679e-05 0.001112839108851648 1.75099e-05 0.001112839108851648
+ 1.751e-05 0.00065452948709143082 1.7692864e-05 0.00065452948709143082 1.7692964e-05 0.0003005787409177478 1.7718224e-05 0.0003005787409177478
+ 1.7718324e-05 0.002104330456011278 1.7743767e-05 0.002104330456011278 1.7743867e-05 0.00108612490308018 1.7769234e-05 0.00108612490308018
+ 1.7769334e-05 -0.00066903739991682018 1.7794596e-05 -0.00066903739991682018 1.7794696e-05 -0.0011693287118096933 1.7820034e-05 -0.0011693287118096933
+ 1.7820134e-05 0.0017435347147253604 1.7845579e-05 0.0017435347147253604 1.7845679e-05 -0.0012460849143460084 1.80099e-05 -0.0012460849143460084
+ 1.801e-05 -0.0016888201090811674 1.8192864e-05 -0.0016888201090811674 1.8192964e-05 -0.0017037368003595696 1.8218224e-05 -0.0017037368003595696
+ 1.8218324e-05 0.0013288823124263014 1.8243767e-05 0.0013288823124263014 1.8243867e-05 0.0017075642700812557 1.8269234e-05 0.0017075642700812557
+ 1.8269334e-05 0.00027301420269119166 1.8294596e-05 0.00027301420269119166 1.8294696e-05 0.00030316148811062585 1.8320034e-05 0.00030316148811062585
+ 1.8320134e-05 -0.0023559112776107703 1.8345579e-05 -0.0023559112776107703 1.8345679e-05 0.0014955318292101897 1.85099e-05 0.0014955318292101897
+ 1.851e-05 0.00017724761823387624 1.8692864e-05 0.00017724761823387624 1.8692964e-05 -0.00077096873969079518 1.8718224e-05 -0.00077096873969079518
+ 1.8718324e-05 -0.0018283165255238648 1.8743767e-05 -0.0018283165255238648 1.8743867e-05 -0.00017256298772393557 1.8769234e-05 -0.00017256298772393557
+ 1.8769334e-05 -0.0016328781694455988 1.8794596e-05 -0.0016328781694455988 1.8794696e-05 -0.0020241677819260824 1.8820034e-05 -0.0020241677819260824
+ 1.8820134e-05 -0.00074023523608293142 1.8845579e-05 -0.00074023523608293142 1.8845679e-05 -0.00098028517711646994 1.90099e-05 -0.00098028517711646994
+ 1.901e-05 -0.00087788927657443574 1.9192864e-05 -0.00087788927657443574 1.9192964e-05 -0.002304389356656506 1.9218224e-05 -0.002304389356656506
+ 1.9218324e-05 -0.00075663985936465965 1.9243767e-05 -0.00075663985936465965 1.9243867e-05 -0.0023410693779122773 1.9269234e-05 -0.0023410693779122773
+ 1.9269334e-05 -0.00054237904182520438 1.9294596e-05 -0.00054237904182520438 1.9294696e-05 0.00098907004433878253 1.9320034e-05 0.00098907004433878253
+ 1.9320134e-05 0.0028034702613523328 1.9345579e-05 0.0028034702613523328 1.9345679e-05 -0.00027116627437222648 1.95099e-05 -0.00027116627437222648
+ 1.951e-05 -0.0023270148278142049 1.9692864e-05 -0.0023270148278142049 1.9692964e-05 -0.00021715116284526064 1.9718224e-05 -0.00021715116284526064
+ 1.9718324e-05 -0.0032871160190065716 1.9743767e-05 -0.0032871160190065716 1.9743867e-05 0.0024579551572032248 1.9769234e-05 0.0024579551572032248
+ 1.9769334e-05 -0.0028797341703514648 1.9794596e-05 -0.0028797341703514648 1.9794696e-05 0.0003476525087051745 1.9820034e-05 0.0003476525087051745
+ 1.9820134e-05 0.00022642969141935658 1.9845579e-05 0.00022642969141935658 1.9845679e-05 -0.0029083138623497524 2.00099e-05 -0.0029083138623497524
+ 2.001e-05 -0.00054865829546337831 2.0192864e-05 -0.00054865829546337831 2.0192964e-05 -0.00035942721861587269 2.0218224e-05 -0.00035942721861587269
+ 2.0218324e-05 -0.0012334198089172831 2.0243767e-05 -0.0012334198089172831 2.0243867e-05 0.0010912048728587854 2.0269234e-05 0.0010912048728587854
+ 2.0269334e-05 0.00050642698986293514 2.0294596e-05 0.00050642698986293514 2.0294696e-05 0.0003536368819339208 2.0320034e-05 0.0003536368819339208
+ 2.0320134e-05 0.00048907006613864976 2.0345579e-05 0.00048907006613864976 2.0345679e-05 0.000730381048413656 2.05099e-05 0.000730381048413656
+ 2.051e-05 -0.003809490963363507 2.0692864e-05 -0.003809490963363507 2.0692964e-05 0.00066530983145187956 2.0718224e-05 0.00066530983145187956
+ 2.0718324e-05 4.3655415959120427e-05 2.0743767e-05 4.3655415959120427e-05 2.0743867e-05 0.00054992961822369099 2.0769234e-05 0.00054992961822369099
+ 2.0769334e-05 0.0014383313945417367 2.0794596e-05 0.0014383313945417367 2.0794696e-05 0.00078409971799036596 2.0820034e-05 0.00078409971799036596
+ 2.0820134e-05 1.9592927412467333e-05 2.0845579e-05 1.9592927412467333e-05 2.0845679e-05 -0.0018870170990689542 2.10099e-05 -0.0018870170990689542
+ 2.101e-05 -0.0012259329721163554 2.1192864e-05 -0.0012259329721163554 2.1192964e-05 0.0011506858658063444 2.1218224e-05 0.0011506858658063444
+ 2.1218324e-05 0.00068297574816000915 2.1243767e-05 0.00068297574816000915 2.1243867e-05 0.00087896478295160609 2.1269234e-05 0.00087896478295160609
+ 2.1269334e-05 0.0017669383833086121 2.1294596e-05 0.0017669383833086121 2.1294696e-05 0.00038523626493993822 2.1320034e-05 0.00038523626493993822
+ 2.1320134e-05 -3.0245364588007245e-05 2.1345579e-05 -3.0245364588007245e-05 2.1345679e-05 5.8669960769005671e-05 2.15099e-05 5.8669960769005671e-05
+ 2.151e-05 -0.0015539974363173357 2.1692864e-05 -0.0015539974363173357 2.1692964e-05 3.1682741202648776e-05 2.1718224e-05 3.1682741202648776e-05
+ 2.1718324e-05 0.00023477476856381276 2.1743767e-05 0.00023477476856381276 2.1743867e-05 0.00092429193971018254 2.1769234e-05 0.00092429193971018254
+ 2.1769334e-05 -0.0010084056241798356 2.1794596e-05 -0.0010084056241798356 2.1794696e-05 0.00093738749067262387 2.1820034e-05 0.00093738749067262387
+ 2.1820134e-05 0.0016361839709718479 2.1845579e-05 0.0016361839709718479 2.1845679e-05 -0.0011774360677137452 2.20099e-05 -0.0011774360677137452
+ 2.201e-05 -0.0020643489938887601 2.2192864e-05 -0.0020643489938887601 2.2192964e-05 -0.0011183898206632602 2.2218224e-05 -0.0011183898206632602
+ 2.2218324e-05 -0.00094797452091993824 2.2243767e-05 -0.00094797452091993824 2.2243867e-05 -0.00084293360500403605 2.2269234e-05 -0.00084293360500403605
+ 2.2269334e-05 0.00051743084797628027 2.2294596e-05 0.00051743084797628027 2.2294696e-05 0.0028358610746619215 2.2320034e-05 0.0028358610746619215
+ 2.2320134e-05 0.0023589407277610683 2.2345579e-05 0.0023589407277610683 2.2345679e-05 0.0023517584360278083 2.25099e-05 0.0023517584360278083
+ 2.251e-05 0.00092791374101195703 2.2692864e-05 0.00092791374101195703 2.2692964e-05 0.0034883533008063933 2.2718224e-05 0.0034883533008063933
+ 2.2718324e-05 0.0019794854938380382 2.2743767e-05 0.0019794854938380382 2.2743867e-05 -0.00055897760481000882 2.2769234e-05 -0.00055897760481000882
+ 2.2769334e-05 -0.00092564151980833629 2.2794596e-05 -0.00092564151980833629 2.2794696e-05 -7.1782333177957146e-05 2.2820034e-05 -7.1782333177957146e-05
+ 2.2820134e-05 0.00033451180070433217 2.2845579e-05 0.00033451180070433217 2.2845679e-05 -0.0017529410307181087 2.30099e-05 -0.0017529410307181087
+ 2.301e-05 -0.0022110729664426925 2.3192864e-05 -0.0022110729664426925 2.3192964e-05 0.00096126710910439677 2.3218224e-05 0.00096126710910439677
+ 2.3218324e-05 -0.0014332982832449726 2.3243767e-05 -0.0014332982832449726 2.3243867e-05 0.0005713107567669784 2.3269234e-05 0.0005713107567669784
+ 2.3269334e-05 -0.00012110760917602769 2.3294596e-05 -0.00012110760917602769 2.3294696e-05 -0.0011106590098658459 2.3320034e-05 -0.0011106590098658459
+ 2.3320134e-05 -0.0009707175559689503 2.3345579e-05 -0.0009707175559689503 2.3345679e-05 0.00070439523229360299 2.35099e-05 0.00070439523229360299
+ 2.351e-05 0.00013889502628474144 2.3692864e-05 0.00013889502628474144 2.3692964e-05 0.00077324062941581864 2.3718224e-05 0.00077324062941581864
+ 2.3718324e-05 0.0013787513947079461 2.3743767e-05 0.0013787513947079461 2.3743867e-05 -0.00052105570850419648 2.3769234e-05 -0.00052105570850419648
+ 2.3769334e-05 -1.9394257886623906e-07 2.3794596e-05 -1.9394257886623906e-07 2.3794696e-05 -0.00034565508232348049 2.3820034e-05 -0.00034565508232348049
+ 2.3820134e-05 -0.0010890408840814828 2.3845579e-05 -0.0010890408840814828 2.3845679e-05 0.00044670590142136793 2.40099e-05 0.00044670590142136793
+ 2.401e-05 -0.0026476564932752093 2.4192864e-05 -0.0026476564932752093 2.4192964e-05 0.00060041077398666047 2.4218224e-05 0.00060041077398666047
+ 2.4218324e-05 -0.00047526546228384743 2.4243767e-05 -0.00047526546228384743 2.4243867e-05 0.002437043096208129 2.4269234e-05 0.002437043096208129
+ 2.4269334e-05 -0.0012184189925655623 2.4294596e-05 -0.0012184189925655623 2.4294696e-05 0.0020569608937125688 2.4320034e-05 0.0020569608937125688
+ 2.4320134e-05 -0.000847178861562622 2.4345579e-05 -0.000847178861562622 2.4345679e-05 6.5721013097334513e-05 2.45099e-05 6.5721013097334513e-05
+ 2.451e-05 0.002587526717105831 2.4692864e-05 0.002587526717105831 2.4692964e-05 0.0019652705610056012 2.4718224e-05 0.0019652705610056012
+ 2.4718324e-05 -0.00039173308610785149 2.4743767e-05 -0.00039173308610785149 2.4743867e-05 0.0001426729351838799 2.4769234e-05 0.0001426729351838799
+ 2.4769334e-05 -0.0011775683552833096 2.4794596e-05 -0.0011775683552833096 2.4794696e-05 0.0014351389105187727 2.4820034e-05 0.0014351389105187727
+ 2.4820134e-05 -0.00026096790165886684 2.4845579e-05 -0.00026096790165886684 2.4845679e-05 -0.00012207541427999255 2.50099e-05 -0.00012207541427999255
+ 2.501e-05 -0.00094271308138766925 2.5192864e-05 -0.00094271308138766925 2.5192964e-05 -0.0001682989322189329 2.5218224e-05 -0.0001682989322189329
+ 2.5218324e-05 -0.00037536448666863301 2.5243767e-05 -0.00037536448666863301 2.5243867e-05 0.0021790150099065195 2.5269234e-05 0.0021790150099065195
+ 2.5269334e-05 0.00088590658430609591 2.5294596e-05 0.00088590658430609591 2.5294696e-05 0.001500803525571151 2.5320034e-05 0.001500803525571151
+ 2.5320134e-05 -0.00026475146071720562 2.5345579e-05 -0.00026475146071720562 2.5345679e-05 -0.00011546942927585636 2.55099e-05 -0.00011546942927585636
+ 2.551e-05 -0.00030456814652544143 2.5692864e-05 -0.00030456814652544143 2.5692964e-05 -0.0018531622966093816 2.5718224e-05 -0.0018531622966093816
+ 2.5718324e-05 0.00098950553217605876 2.5743767e-05 0.00098950553217605876 2.5743867e-05 0.001116731048861445 2.5769234e-05 0.001116731048861445
+ 2.5769334e-05 0.0039283844202710194 2.5794596e-05 0.0039283844202710194 2.5794696e-05 -0.0013961363754782686 2.5820034e-05 -0.0013961363754782686
+ 2.5820134e-05 0.0020887693599550214 2.5845579e-05 0.0020887693599550214 2.5845679e-05 -0.00088504516117512782 2.60099e-05 -0.00088504516117512782
+ 2.601e-05 -0.0018208476298011654 2.6192864e-05 -0.0018208476298011654 2.6192964e-05 0.0013627566741460742 2.6218224e-05 0.0013627566741460742
+ 2.6218324e-05 -0.0012208269444719169 2.6243767e-05 -0.0012208269444719169 2.6243867e-05 4.2233298314993036e-05 2.6269234e-05 4.2233298314993036e-05
+ 2.6269334e-05 0.0010848624828336704 2.6294596e-05 0.0010848624828336704 2.6294696e-05 0.0018035598930881041 2.6320034e-05 0.0018035598930881041
+ 2.6320134e-05 0.00039022661286121759 2.6345579e-05 0.00039022661286121759 2.6345679e-05 -0.0024412413416015992 2.65099e-05 -0.0024412413416015992
+ 2.651e-05 0.001597294291322282 2.6692864e-05 0.001597294291322282 2.6692964e-05 0.00092846509716535558 2.6718224e-05 0.00092846509716535558
+ 2.6718324e-05 5.5936233681057402e-05 2.6743767e-05 5.5936233681057402e-05 2.6743867e-05 0.00041469506111561119 2.6769234e-05 0.00041469506111561119
+ 2.6769334e-05 -0.00075771438771939158 2.6794596e-05 -0.00075771438771939158 2.6794696e-05 -0.0012888071593666296 2.6820034e-05 -0.0012888071593666296
+ 2.6820134e-05 -0.00037830929667500196 2.6845579e-05 -0.00037830929667500196 2.6845679e-05 -7.9236509903746029e-05 2.70099e-05 -7.9236509903746029e-05
+ 2.701e-05 -0.00059962477968096225 2.7192864e-05 -0.00059962477968096225 2.7192964e-05 0.0015727388460178887 2.7218224e-05 0.0015727388460178887
+ 2.7218324e-05 0.00066035803602037114 2.7243767e-05 0.00066035803602037114 2.7243867e-05 0.0011916176161926209 2.7269234e-05 0.0011916176161926209
+ 2.7269334e-05 -0.0017119294967437356 2.7294596e-05 -0.0017119294967437356 2.7294696e-05 -0.00016431741441777788 2.7320034e-05 -0.00016431741441777788
+ 2.7320134e-05 0.0019007701976312447 2.7345579e-05 0.0019007701976312447 2.7345679e-05 0.00040384423361267417 2.75099e-05 0.00040384423361267417
+ 2.751e-05 0.00038397911847340568 2.7692864e-05 0.00038397911847340568 2.7692964e-05 0.002108790896790419 2.7718224e-05 0.002108790896790419
+ 2.7718324e-05 -0.00029577588592198195 2.7743767e-05 -0.00029577588592198195 2.7743867e-05 0.00093352537576693888 2.7769234e-05 0.00093352537576693888
+ 2.7769334e-05 -0.00044738020548447805 2.7794596e-05 -0.00044738020548447805 2.7794696e-05 0.0018068367721692704 2.7820034e-05 0.0018068367721692704
+ 2.7820134e-05 -0.0013540700737977533 2.7845579e-05 -0.0013540700737977533 2.7845679e-05 0.00068999650632633558 2.80099e-05 0.00068999650632633558
+ 2.801e-05 0.0010926096693628915 2.8192864e-05 0.0010926096693628915 2.8192964e-05 -0.00089640630433535963 2.8218224e-05 -0.00089640630433535963
+ 2.8218324e-05 0.00047654009478318571 2.8243767e-05 0.00047654009478318571 2.8243867e-05 0.0015609502157038365 2.8269234e-05 0.0015609502157038365
+ 2.8269334e-05 4.7490695120165463e-05 2.8294596e-05 4.7490695120165463e-05 2.8294696e-05 -8.613247649679903e-05 2.8320034e-05 -8.613247649679903e-05
+ 2.8320134e-05 0.0029930832584991276 2.8345579e-05 0.0029930832584991276 2.8345679e-05 -0.0011586633043484465 2.85099e-05 -0.0011586633043484465
+ 2.851e-05 0.0031150335386403976 2.8692864e-05 0.0031150335386403976 2.8692964e-05 -0.0047257278260791225 2.8718224e-05 -0.0047257278260791225
+ 2.8718324e-05 0.0005367908498408291 2.8743767e-05 0.0005367908498408291 2.8743867e-05 -0.0011216295843722809 2.8769234e-05 -0.0011216295843722809
+ 2.8769334e-05 -0.00058484808902587544 2.8794596e-05 -0.00058484808902587544 2.8794696e-05 -0.00030138514134180235 2.8820034e-05 -0.00030138514134180235
+ 2.8820134e-05 -0.00043601871133794334 2.8845579e-05 -0.00043601871133794334 2.8845679e-05 -9.3200092721397687e-05 2.90099e-05 -9.3200092721397687e-05
+ 2.901e-05 -0.00029840909780205131 2.9192864e-05 -0.00029840909780205131 2.9192964e-05 -0.0012341611950712598 2.9218224e-05 -0.0012341611950712598
+ 2.9218324e-05 0.0017382844490801826 2.9243767e-05 0.0017382844490801826 2.9243867e-05 0.0023660375760423832 2.9269234e-05 0.0023660375760423832
+ 2.9269334e-05 0.0026054753264201824 2.9294596e-05 0.0026054753264201824 2.9294696e-05 -0.00036197436697953979 2.9320034e-05 -0.00036197436697953979
+ 2.9320134e-05 0.00060455802712065126 2.9345579e-05 0.00060455802712065126 2.9345679e-05 -0.0024450782531407213 2.95099e-05 -0.0024450782531407213
+ 2.951e-05 -0.00034194039590799475 2.9692864e-05 -0.00034194039590799475 2.9692964e-05 0.0010666861675383058 2.9718224e-05 0.0010666861675383058
+ 2.9718324e-05 -0.0003794485876115349 2.9743767e-05 -0.0003794485876115349 2.9743867e-05 0.0028206574410785329 2.9769234e-05 0.0028206574410785329
+ 2.9769334e-05 0.00039863664929834844 2.9794596e-05 0.00039863664929834844 2.9794696e-05 -0.00032771534632227334 2.9820034e-05 -0.00032771534632227334
+ 2.9820134e-05 -0.0012617491190584952 2.9845579e-05 -0.0012617491190584952 2.9845679e-05 -0.00066233392464873852 3.00099e-05 -0.00066233392464873852
+ 3.001e-05 0.0010121813037483232 3.0192864e-05 0.0010121813037483232 3.0192964e-05 0.0019863204842027076 3.0218224e-05 0.0019863204842027076
+ 3.0218324e-05 0.0014607037043993516 3.0243767e-05 0.0014607037043993516 3.0243867e-05 -0.0023653113014462769 3.0269234e-05 -0.0023653113014462769
+ 3.0269334e-05 -0.00013682828950552751 3.0294596e-05 -0.00013682828950552751 3.0294696e-05 0.00034389343941178328 3.0320034e-05 0.00034389343941178328
+ 3.0320134e-05 -0.0024673352781767704 3.0345579e-05 -0.0024673352781767704 3.0345679e-05 -0.00042717988172027169 3.05099e-05 -0.00042717988172027169
+ 3.051e-05 0.00020359996404107676 3.0692864e-05 0.00020359996404107676 3.0692964e-05 -0.00037793176777070386 3.0718224e-05 -0.00037793176777070386
+ 3.0718324e-05 -0.0024972241074899359 3.0743767e-05 -0.0024972241074899359 3.0743867e-05 -0.00080245141219171612 3.0769234e-05 -0.00080245141219171612
+ 3.0769334e-05 -0.0021106730556578147 3.0794596e-05 -0.0021106730556578147 3.0794696e-05 0.00042392486012884944 3.0820034e-05 0.00042392486012884944
+ 3.0820134e-05 0.00050675808839857942 3.0845579e-05 0.00050675808839857942 3.0845679e-05 0.00033432840323362309 3.10099e-05 0.00033432840323362309
+ 3.101e-05 -0.0030661467728724666 3.1192864e-05 -0.0030661467728724666 3.1192964e-05 -0.00084720026950693326 3.1218224e-05 -0.00084720026950693326
+ 3.1218324e-05 7.0772222739258657e-05 3.1243767e-05 7.0772222739258657e-05 3.1243867e-05 -0.00038509144773639543 3.1269234e-05 -0.00038509144773639543
+ 3.1269334e-05 0.0013179438592569033 3.1294596e-05 0.0013179438592569033 3.1294696e-05 -0.0011354214907373834 3.1320034e-05 -0.0011354214907373834
+ 3.1320134e-05 0.0018559134130516912 3.1345579e-05 0.0018559134130516912 3.1345679e-05 0.0021703524397352412 3.15099e-05 0.0021703524397352412
+ 3.151e-05 9.8206337046971389e-05 3.1692864e-05 9.8206337046971389e-05 3.1692964e-05 -0.0011899317359495244 3.1718224e-05 -0.0011899317359495244
+ 3.1718324e-05 0.00034104374793327485 3.1743767e-05 0.00034104374793327485 3.1743867e-05 -0.0014825037537713566 3.1769234e-05 -0.0014825037537713566
+ 3.1769334e-05 0.001515839036264265 3.1794596e-05 0.001515839036264265 3.1794696e-05 0.0015076535343097168 3.1820034e-05 0.0015076535343097168
+ 3.1820134e-05 8.6252309793684101e-05 3.1845579e-05 8.6252309793684101e-05 3.1845679e-05 0.0015554082990805042 3.20099e-05 0.0015554082990805042
+ 3.201e-05 0.00038747075313553061 3.2192864e-05 0.00038747075313553061 3.2192964e-05 9.4038921693335637e-05 3.2218224e-05 9.4038921693335637e-05
+ 3.2218324e-05 0.0015024118512957979 3.2243767e-05 0.0015024118512957979 3.2243867e-05 0.001958398691868811 3.2269234e-05 0.001958398691868811
+ 3.2269334e-05 -0.0012486814602881424 3.2294596e-05 -0.0012486814602881424 3.2294696e-05 -0.0016212150078556255 3.2320034e-05 -0.0016212150078556255
+ 3.2320134e-05 -0.0021591616137103318 3.2345579e-05 -0.0021591616137103318 3.2345679e-05 0.00066311812012298749 3.25099e-05 0.00066311812012298749
+ 3.251e-05 -0.0004753365932516566 3.2692864e-05 -0.0004753365932516566 3.2692964e-05 0.0010467542893533501 3.2718224e-05 0.0010467542893533501
+ 3.2718324e-05 0.00079577881181860336 3.2743767e-05 0.00079577881181860336 3.2743867e-05 -0.00095180815860609468 3.2769234e-05 -0.00095180815860609468
+ 3.2769334e-05 -0.00096064552003231397 3.2794596e-05 -0.00096064552003231397 3.2794696e-05 -0.00062204385764493334 3.2820034e-05 -0.00062204385764493334
+ 3.2820134e-05 -0.00078023262512232885 3.2845579e-05 -0.00078023262512232885 3.2845679e-05 0.0007689554220212054 3.30099e-05 0.0007689554220212054
+ 3.301e-05 -0.00011411815211937169 3.3192864e-05 -0.00011411815211937169 3.3192964e-05 -0.00069380600460892277 3.3218224e-05 -0.00069380600460892277
+ 3.3218324e-05 -1.4251562811469971e-06 3.3243767e-05 -1.4251562811469971e-06 3.3243867e-05 0.0013018466871232513 3.3269234e-05 0.0013018466871232513
+ 3.3269334e-05 0.0011746273644723294 3.3294596e-05 0.0011746273644723294 3.3294696e-05 -0.00018429496185761284 3.3320034e-05 -0.00018429496185761284
+ 3.3320134e-05 -3.9771211965542784e-05 3.3345579e-05 -3.9771211965542784e-05 3.3345679e-05 0.0027609394865413359 3.35099e-05 0.0027609394865413359
+ 3.351e-05 0.00066117742688525695 3.3692864e-05 0.00066117742688525695 3.3692964e-05 -0.0023451303426741273 3.3718224e-05 -0.0023451303426741273
+ 3.3718324e-05 0.00025188421947379484 3.3743767e-05 0.00025188421947379484 3.3743867e-05 -0.00048334315585613774 3.3769234e-05 -0.00048334315585613774
+ 3.3769334e-05 0.0028366787670102366 3.3794596e-05 0.0028366787670102366 3.3794696e-05 0.0004865518011235425 3.3820034e-05 0.0004865518011235425
+ 3.3820134e-05 -0.00048226920453513499 3.3845579e-05 -0.00048226920453513499 3.3845679e-05 0.0029323829576657951 3.4e-05 0.0029323829576657951
+ )

XCORE vdd 0 vrefp vrefn vinp vinn clks cmpck
+ dctrlp7 dctrlp6 dctrlp5 dctrlp4 dctrlp3 dctrlp2 dctrlp1
+ dctrln7 dctrln6 dctrln5 dctrln4 dctrln3 dctrln2 dctrln1
+ dcmpp dcmpn vresp vresn cmp_noise SAR_ADC_ACTIVE
E_SAMPLE_DIFF sampled_diff 0 vresp vresn 1
E_INPUT_DIFF input_diff 0 vinp vinn 1

CLOGIC_P dcmpp 0 {CLOGIC_IN_P}
CLOGIC_N dcmpn 0 {CLOGIC_IN_N}
A_CLKS [clks] [clks_d] adc_logic_in
A_DCMPP [dcmpp] [dcmpp_d] adc_logic_in
A_DCMPN [dcmpn] [dcmpn_d] adc_logic_in
ABEH [clks_d dcmpp_d dcmpn_d]
+ [cmpck_d
+ dctrlp7_d dctrlp6_d dctrlp5_d dctrlp4_d dctrlp3_d dctrlp2_d dctrlp1_d
+ dctrln7_d dctrln6_d dctrln5_d dctrln4_d dctrln3_d dctrln2_d dctrln1_d
+ dout7_d dout6_d dout5_d dout4_d dout3_d dout2_d dout1_d dout0_d
+ eoc_d
+ invalid7_d invalid6_d invalid5_d invalid4_d invalid3_d invalid2_d invalid1_d invalid0_d
+ timeout7_d timeout6_d timeout5_d timeout4_d timeout3_d timeout2_d timeout1_d timeout0_d
+ complete_d] sar_logic_beh

A_CMPCK [cmpck_d] [cmpck_drv] dac_cmpck
A_DCTRLP [dctrlp7_d dctrlp6_d dctrlp5_d dctrlp4_d dctrlp3_d dctrlp2_d dctrlp1_d]
+ [dctrlp7_drv dctrlp6_drv dctrlp5_drv dctrlp4_drv dctrlp3_drv dctrlp2_drv dctrlp1_drv] dac_dctrl
A_DCTRLN [dctrln7_d dctrln6_d dctrln5_d dctrln4_d dctrln3_d dctrln2_d dctrln1_d]
+ [dctrln7_drv dctrln6_drv dctrln5_drv dctrln4_drv dctrln3_drv dctrln2_drv dctrln1_drv] dac_dctrl
A_DOUT [dout7_d dout6_d dout5_d dout4_d dout3_d dout2_d dout1_d dout0_d]
+ [dout7_drv dout6_drv dout5_drv dout4_drv dout3_drv dout2_drv dout1_drv dout0_drv] dac_dout
A_STATUS [eoc_d invalid0_d timeout0_d complete_d] [eoc invalid0 timeout0 complete] dac_status

R_CMPCK cmpck_drv cmpck {CMPCK_R_EQ}
R_DCTRLP7 dctrlp7_drv dctrlp7 {DCTRL_R_EQ}
R_DCTRLP6 dctrlp6_drv dctrlp6 {DCTRL_R_EQ}
R_DCTRLP5 dctrlp5_drv dctrlp5 {DCTRL_R_EQ}
R_DCTRLP4 dctrlp4_drv dctrlp4 {DCTRL_R_EQ}
R_DCTRLP3 dctrlp3_drv dctrlp3 {DCTRL_R_EQ}
R_DCTRLP2 dctrlp2_drv dctrlp2 {DCTRL_R_EQ}
R_DCTRLP1 dctrlp1_drv dctrlp1 {DCTRL_R_EQ}
R_DCTRLN7 dctrln7_drv dctrln7 {DCTRL_R_EQ}
R_DCTRLN6 dctrln6_drv dctrln6 {DCTRL_R_EQ}
R_DCTRLN5 dctrln5_drv dctrln5 {DCTRL_R_EQ}
R_DCTRLN4 dctrln4_drv dctrln4 {DCTRL_R_EQ}
R_DCTRLN3 dctrln3_drv dctrln3 {DCTRL_R_EQ}
R_DCTRLN2 dctrln2_drv dctrln2 {DCTRL_R_EQ}
R_DCTRLN1 dctrln1_drv dctrln1 {DCTRL_R_EQ}

R_DOUT7 dout7_drv dout7_rx {DOUT_R_EQ}
R_DOUT6 dout6_drv dout6_rx {DOUT_R_EQ}
R_DOUT5 dout5_drv dout5_rx {DOUT_R_EQ}
R_DOUT4 dout4_drv dout4_rx {DOUT_R_EQ}
R_DOUT3 dout3_drv dout3_rx {DOUT_R_EQ}
R_DOUT2 dout2_drv dout2_rx {DOUT_R_EQ}
R_DOUT1 dout1_drv dout1_rx {DOUT_R_EQ}
R_DOUT0 dout0_drv dout0_rx {DOUT_R_EQ}
C_DOUT7 dout7_rx 0 {DOUT_C_EQ}
C_DOUT6 dout6_rx 0 {DOUT_C_EQ}
C_DOUT5 dout5_rx 0 {DOUT_C_EQ}
C_DOUT4 dout4_rx 0 {DOUT_C_EQ}
C_DOUT3 dout3_rx 0 {DOUT_C_EQ}
C_DOUT2 dout2_rx 0 {DOUT_C_EQ}
C_DOUT1 dout1_rx 0 {DOUT_C_EQ}
C_DOUT0 dout0_rx 0 {DOUT_C_EQ}

.model adc_logic_in adc_bridge in_low=0.99 in_high=2.31 rise_delay=1p fall_delay=1p
.model dac_cmpck dac_bridge input_load=10f t_rise={CMPCK_TR_EQ} t_fall={CMPCK_TF_EQ} out_low=0 out_high=3.3
.model dac_dctrl dac_bridge input_load=10f t_rise={DCTRL_TR_EQ} t_fall={DCTRL_TF_EQ} out_low=0 out_high=3.3
.model dac_dout dac_bridge input_load=10f t_rise={DOUT_TR_EQ} t_fall={DOUT_TF_EQ} out_low=0 out_high=3.3
.model dac_status dac_bridge input_load=1f t_rise=0.05n t_fall=0.05n out_low=0 out_high=3.3
.model sar_logic_beh d_cosim simulation="/foss/designs/A44_CMP_XM5_XM6_W8P2524_XM7_XM11_W16P8587_MC200_PVT_FULLSTATIC_20260728_R1/02_PVT3_MC20_LOW_W4/models/SAR_LOGIC_BEH_TT_3P3_27C.so" delay=1p

.save v(cmpck) v(vresp) v(vresn) v(vinp) v(vinn) v(sampled_diff) v(input_diff)
+ v(dout7_rx) v(dout6_rx) v(dout5_rx) v(dout4_rx) v(dout3_rx) v(dout2_rx) v(dout1_rx) v(dout0_rx)
+ v(complete) v(invalid0) v(timeout0)
.save v(dcmpp) v(dcmpn)
+ v(dout7_drv) v(dout6_drv) v(dout5_drv) v(dout4_drv) v(dout3_drv) v(dout2_drv) v(dout1_drv) v(dout0_drv)
+ v(dctrlp7) v(dctrlp6) v(dctrlp5) v(dctrlp4) v(dctrlp3) v(dctrlp2) v(dctrlp1)
+ v(dctrln7) v(dctrln6) v(dctrln5) v(dctrln4) v(dctrln3) v(dctrln2) v(dctrln1)
.control
set noaskquit
set plotwinsize=0
tran 5e-10 3.3995e-05 0 5e-11
meas tran f000_d7 find v(dout7_rx) at=4.8e-07
meas tran f000_d6 find v(dout6_rx) at=4.8e-07
meas tran f000_d5 find v(dout5_rx) at=4.8e-07
meas tran f000_d4 find v(dout4_rx) at=4.8e-07
meas tran f000_d3 find v(dout3_rx) at=4.8e-07
meas tran f000_d2 find v(dout2_rx) at=4.8e-07
meas tran f000_d1 find v(dout1_rx) at=4.8e-07
meas tran f000_d0 find v(dout0_rx) at=4.8e-07
meas tran f000_complete find v(complete) at=4.8e-07
meas tran f000_invalid find v(invalid0) at=4.8e-07
meas tran f000_timeout find v(timeout0) at=4.8e-07
meas tran f000_sampled find v(sampled_diff) at=1.7e-07
meas tran f000_input find v(input_diff) at=1.7e-07
meas tran f000_tcomplete when v(complete)=1.65 rise=1
meas tran f001_d7 find v(dout7_rx) at=9.8e-07
meas tran f001_d6 find v(dout6_rx) at=9.8e-07
meas tran f001_d5 find v(dout5_rx) at=9.8e-07
meas tran f001_d4 find v(dout4_rx) at=9.8e-07
meas tran f001_d3 find v(dout3_rx) at=9.8e-07
meas tran f001_d2 find v(dout2_rx) at=9.8e-07
meas tran f001_d1 find v(dout1_rx) at=9.8e-07
meas tran f001_d0 find v(dout0_rx) at=9.8e-07
meas tran f001_complete find v(complete) at=9.8e-07
meas tran f001_invalid find v(invalid0) at=9.8e-07
meas tran f001_timeout find v(timeout0) at=9.8e-07
meas tran f001_sampled find v(sampled_diff) at=6.7e-07
meas tran f001_input find v(input_diff) at=6.7e-07
meas tran f001_tcomplete when v(complete)=1.65 rise=2
meas tran f002_d7 find v(dout7_rx) at=1.48e-06
meas tran f002_d6 find v(dout6_rx) at=1.48e-06
meas tran f002_d5 find v(dout5_rx) at=1.48e-06
meas tran f002_d4 find v(dout4_rx) at=1.48e-06
meas tran f002_d3 find v(dout3_rx) at=1.48e-06
meas tran f002_d2 find v(dout2_rx) at=1.48e-06
meas tran f002_d1 find v(dout1_rx) at=1.48e-06
meas tran f002_d0 find v(dout0_rx) at=1.48e-06
meas tran f002_complete find v(complete) at=1.48e-06
meas tran f002_invalid find v(invalid0) at=1.48e-06
meas tran f002_timeout find v(timeout0) at=1.48e-06
meas tran f002_sampled find v(sampled_diff) at=1.17e-06
meas tran f002_input find v(input_diff) at=1.17e-06
meas tran f002_tcomplete when v(complete)=1.65 rise=3
meas tran f003_d7 find v(dout7_rx) at=1.98e-06
meas tran f003_d6 find v(dout6_rx) at=1.98e-06
meas tran f003_d5 find v(dout5_rx) at=1.98e-06
meas tran f003_d4 find v(dout4_rx) at=1.98e-06
meas tran f003_d3 find v(dout3_rx) at=1.98e-06
meas tran f003_d2 find v(dout2_rx) at=1.98e-06
meas tran f003_d1 find v(dout1_rx) at=1.98e-06
meas tran f003_d0 find v(dout0_rx) at=1.98e-06
meas tran f003_complete find v(complete) at=1.98e-06
meas tran f003_invalid find v(invalid0) at=1.98e-06
meas tran f003_timeout find v(timeout0) at=1.98e-06
meas tran f003_sampled find v(sampled_diff) at=1.67e-06
meas tran f003_input find v(input_diff) at=1.67e-06
meas tran f003_tcomplete when v(complete)=1.65 rise=4
meas tran f004_d7 find v(dout7_rx) at=2.48e-06
meas tran f004_d6 find v(dout6_rx) at=2.48e-06
meas tran f004_d5 find v(dout5_rx) at=2.48e-06
meas tran f004_d4 find v(dout4_rx) at=2.48e-06
meas tran f004_d3 find v(dout3_rx) at=2.48e-06
meas tran f004_d2 find v(dout2_rx) at=2.48e-06
meas tran f004_d1 find v(dout1_rx) at=2.48e-06
meas tran f004_d0 find v(dout0_rx) at=2.48e-06
meas tran f004_complete find v(complete) at=2.48e-06
meas tran f004_invalid find v(invalid0) at=2.48e-06
meas tran f004_timeout find v(timeout0) at=2.48e-06
meas tran f004_sampled find v(sampled_diff) at=2.17e-06
meas tran f004_input find v(input_diff) at=2.17e-06
meas tran f004_tcomplete when v(complete)=1.65 rise=5
meas tran f005_d7 find v(dout7_rx) at=2.98e-06
meas tran f005_d6 find v(dout6_rx) at=2.98e-06
meas tran f005_d5 find v(dout5_rx) at=2.98e-06
meas tran f005_d4 find v(dout4_rx) at=2.98e-06
meas tran f005_d3 find v(dout3_rx) at=2.98e-06
meas tran f005_d2 find v(dout2_rx) at=2.98e-06
meas tran f005_d1 find v(dout1_rx) at=2.98e-06
meas tran f005_d0 find v(dout0_rx) at=2.98e-06
meas tran f005_complete find v(complete) at=2.98e-06
meas tran f005_invalid find v(invalid0) at=2.98e-06
meas tran f005_timeout find v(timeout0) at=2.98e-06
meas tran f005_sampled find v(sampled_diff) at=2.67e-06
meas tran f005_input find v(input_diff) at=2.67e-06
meas tran f005_tcomplete when v(complete)=1.65 rise=6
meas tran f006_d7 find v(dout7_rx) at=3.48e-06
meas tran f006_d6 find v(dout6_rx) at=3.48e-06
meas tran f006_d5 find v(dout5_rx) at=3.48e-06
meas tran f006_d4 find v(dout4_rx) at=3.48e-06
meas tran f006_d3 find v(dout3_rx) at=3.48e-06
meas tran f006_d2 find v(dout2_rx) at=3.48e-06
meas tran f006_d1 find v(dout1_rx) at=3.48e-06
meas tran f006_d0 find v(dout0_rx) at=3.48e-06
meas tran f006_complete find v(complete) at=3.48e-06
meas tran f006_invalid find v(invalid0) at=3.48e-06
meas tran f006_timeout find v(timeout0) at=3.48e-06
meas tran f006_sampled find v(sampled_diff) at=3.17e-06
meas tran f006_input find v(input_diff) at=3.17e-06
meas tran f006_tcomplete when v(complete)=1.65 rise=7
meas tran f007_d7 find v(dout7_rx) at=3.98e-06
meas tran f007_d6 find v(dout6_rx) at=3.98e-06
meas tran f007_d5 find v(dout5_rx) at=3.98e-06
meas tran f007_d4 find v(dout4_rx) at=3.98e-06
meas tran f007_d3 find v(dout3_rx) at=3.98e-06
meas tran f007_d2 find v(dout2_rx) at=3.98e-06
meas tran f007_d1 find v(dout1_rx) at=3.98e-06
meas tran f007_d0 find v(dout0_rx) at=3.98e-06
meas tran f007_complete find v(complete) at=3.98e-06
meas tran f007_invalid find v(invalid0) at=3.98e-06
meas tran f007_timeout find v(timeout0) at=3.98e-06
meas tran f007_sampled find v(sampled_diff) at=3.67e-06
meas tran f007_input find v(input_diff) at=3.67e-06
meas tran f007_tcomplete when v(complete)=1.65 rise=8
meas tran f008_d7 find v(dout7_rx) at=4.48e-06
meas tran f008_d6 find v(dout6_rx) at=4.48e-06
meas tran f008_d5 find v(dout5_rx) at=4.48e-06
meas tran f008_d4 find v(dout4_rx) at=4.48e-06
meas tran f008_d3 find v(dout3_rx) at=4.48e-06
meas tran f008_d2 find v(dout2_rx) at=4.48e-06
meas tran f008_d1 find v(dout1_rx) at=4.48e-06
meas tran f008_d0 find v(dout0_rx) at=4.48e-06
meas tran f008_complete find v(complete) at=4.48e-06
meas tran f008_invalid find v(invalid0) at=4.48e-06
meas tran f008_timeout find v(timeout0) at=4.48e-06
meas tran f008_sampled find v(sampled_diff) at=4.17e-06
meas tran f008_input find v(input_diff) at=4.17e-06
meas tran f008_tcomplete when v(complete)=1.65 rise=9
meas tran f009_d7 find v(dout7_rx) at=4.98e-06
meas tran f009_d6 find v(dout6_rx) at=4.98e-06
meas tran f009_d5 find v(dout5_rx) at=4.98e-06
meas tran f009_d4 find v(dout4_rx) at=4.98e-06
meas tran f009_d3 find v(dout3_rx) at=4.98e-06
meas tran f009_d2 find v(dout2_rx) at=4.98e-06
meas tran f009_d1 find v(dout1_rx) at=4.98e-06
meas tran f009_d0 find v(dout0_rx) at=4.98e-06
meas tran f009_complete find v(complete) at=4.98e-06
meas tran f009_invalid find v(invalid0) at=4.98e-06
meas tran f009_timeout find v(timeout0) at=4.98e-06
meas tran f009_sampled find v(sampled_diff) at=4.67e-06
meas tran f009_input find v(input_diff) at=4.67e-06
meas tran f009_tcomplete when v(complete)=1.65 rise=10
meas tran f010_d7 find v(dout7_rx) at=5.48e-06
meas tran f010_d6 find v(dout6_rx) at=5.48e-06
meas tran f010_d5 find v(dout5_rx) at=5.48e-06
meas tran f010_d4 find v(dout4_rx) at=5.48e-06
meas tran f010_d3 find v(dout3_rx) at=5.48e-06
meas tran f010_d2 find v(dout2_rx) at=5.48e-06
meas tran f010_d1 find v(dout1_rx) at=5.48e-06
meas tran f010_d0 find v(dout0_rx) at=5.48e-06
meas tran f010_complete find v(complete) at=5.48e-06
meas tran f010_invalid find v(invalid0) at=5.48e-06
meas tran f010_timeout find v(timeout0) at=5.48e-06
meas tran f010_sampled find v(sampled_diff) at=5.17e-06
meas tran f010_input find v(input_diff) at=5.17e-06
meas tran f010_tcomplete when v(complete)=1.65 rise=11
meas tran f011_d7 find v(dout7_rx) at=5.98e-06
meas tran f011_d6 find v(dout6_rx) at=5.98e-06
meas tran f011_d5 find v(dout5_rx) at=5.98e-06
meas tran f011_d4 find v(dout4_rx) at=5.98e-06
meas tran f011_d3 find v(dout3_rx) at=5.98e-06
meas tran f011_d2 find v(dout2_rx) at=5.98e-06
meas tran f011_d1 find v(dout1_rx) at=5.98e-06
meas tran f011_d0 find v(dout0_rx) at=5.98e-06
meas tran f011_complete find v(complete) at=5.98e-06
meas tran f011_invalid find v(invalid0) at=5.98e-06
meas tran f011_timeout find v(timeout0) at=5.98e-06
meas tran f011_sampled find v(sampled_diff) at=5.67e-06
meas tran f011_input find v(input_diff) at=5.67e-06
meas tran f011_tcomplete when v(complete)=1.65 rise=12
meas tran f012_d7 find v(dout7_rx) at=6.48e-06
meas tran f012_d6 find v(dout6_rx) at=6.48e-06
meas tran f012_d5 find v(dout5_rx) at=6.48e-06
meas tran f012_d4 find v(dout4_rx) at=6.48e-06
meas tran f012_d3 find v(dout3_rx) at=6.48e-06
meas tran f012_d2 find v(dout2_rx) at=6.48e-06
meas tran f012_d1 find v(dout1_rx) at=6.48e-06
meas tran f012_d0 find v(dout0_rx) at=6.48e-06
meas tran f012_complete find v(complete) at=6.48e-06
meas tran f012_invalid find v(invalid0) at=6.48e-06
meas tran f012_timeout find v(timeout0) at=6.48e-06
meas tran f012_sampled find v(sampled_diff) at=6.17e-06
meas tran f012_input find v(input_diff) at=6.17e-06
meas tran f012_tcomplete when v(complete)=1.65 rise=13
meas tran f013_d7 find v(dout7_rx) at=6.98e-06
meas tran f013_d6 find v(dout6_rx) at=6.98e-06
meas tran f013_d5 find v(dout5_rx) at=6.98e-06
meas tran f013_d4 find v(dout4_rx) at=6.98e-06
meas tran f013_d3 find v(dout3_rx) at=6.98e-06
meas tran f013_d2 find v(dout2_rx) at=6.98e-06
meas tran f013_d1 find v(dout1_rx) at=6.98e-06
meas tran f013_d0 find v(dout0_rx) at=6.98e-06
meas tran f013_complete find v(complete) at=6.98e-06
meas tran f013_invalid find v(invalid0) at=6.98e-06
meas tran f013_timeout find v(timeout0) at=6.98e-06
meas tran f013_sampled find v(sampled_diff) at=6.67e-06
meas tran f013_input find v(input_diff) at=6.67e-06
meas tran f013_tcomplete when v(complete)=1.65 rise=14
meas tran f014_d7 find v(dout7_rx) at=7.48e-06
meas tran f014_d6 find v(dout6_rx) at=7.48e-06
meas tran f014_d5 find v(dout5_rx) at=7.48e-06
meas tran f014_d4 find v(dout4_rx) at=7.48e-06
meas tran f014_d3 find v(dout3_rx) at=7.48e-06
meas tran f014_d2 find v(dout2_rx) at=7.48e-06
meas tran f014_d1 find v(dout1_rx) at=7.48e-06
meas tran f014_d0 find v(dout0_rx) at=7.48e-06
meas tran f014_complete find v(complete) at=7.48e-06
meas tran f014_invalid find v(invalid0) at=7.48e-06
meas tran f014_timeout find v(timeout0) at=7.48e-06
meas tran f014_sampled find v(sampled_diff) at=7.17e-06
meas tran f014_input find v(input_diff) at=7.17e-06
meas tran f014_tcomplete when v(complete)=1.65 rise=15
meas tran f015_d7 find v(dout7_rx) at=7.98e-06
meas tran f015_d6 find v(dout6_rx) at=7.98e-06
meas tran f015_d5 find v(dout5_rx) at=7.98e-06
meas tran f015_d4 find v(dout4_rx) at=7.98e-06
meas tran f015_d3 find v(dout3_rx) at=7.98e-06
meas tran f015_d2 find v(dout2_rx) at=7.98e-06
meas tran f015_d1 find v(dout1_rx) at=7.98e-06
meas tran f015_d0 find v(dout0_rx) at=7.98e-06
meas tran f015_complete find v(complete) at=7.98e-06
meas tran f015_invalid find v(invalid0) at=7.98e-06
meas tran f015_timeout find v(timeout0) at=7.98e-06
meas tran f015_sampled find v(sampled_diff) at=7.67e-06
meas tran f015_input find v(input_diff) at=7.67e-06
meas tran f015_tcomplete when v(complete)=1.65 rise=16
meas tran f016_d7 find v(dout7_rx) at=8.48e-06
meas tran f016_d6 find v(dout6_rx) at=8.48e-06
meas tran f016_d5 find v(dout5_rx) at=8.48e-06
meas tran f016_d4 find v(dout4_rx) at=8.48e-06
meas tran f016_d3 find v(dout3_rx) at=8.48e-06
meas tran f016_d2 find v(dout2_rx) at=8.48e-06
meas tran f016_d1 find v(dout1_rx) at=8.48e-06
meas tran f016_d0 find v(dout0_rx) at=8.48e-06
meas tran f016_complete find v(complete) at=8.48e-06
meas tran f016_invalid find v(invalid0) at=8.48e-06
meas tran f016_timeout find v(timeout0) at=8.48e-06
meas tran f016_sampled find v(sampled_diff) at=8.17e-06
meas tran f016_input find v(input_diff) at=8.17e-06
meas tran f016_tcomplete when v(complete)=1.65 rise=17
meas tran f017_d7 find v(dout7_rx) at=8.98e-06
meas tran f017_d6 find v(dout6_rx) at=8.98e-06
meas tran f017_d5 find v(dout5_rx) at=8.98e-06
meas tran f017_d4 find v(dout4_rx) at=8.98e-06
meas tran f017_d3 find v(dout3_rx) at=8.98e-06
meas tran f017_d2 find v(dout2_rx) at=8.98e-06
meas tran f017_d1 find v(dout1_rx) at=8.98e-06
meas tran f017_d0 find v(dout0_rx) at=8.98e-06
meas tran f017_complete find v(complete) at=8.98e-06
meas tran f017_invalid find v(invalid0) at=8.98e-06
meas tran f017_timeout find v(timeout0) at=8.98e-06
meas tran f017_sampled find v(sampled_diff) at=8.67e-06
meas tran f017_input find v(input_diff) at=8.67e-06
meas tran f017_tcomplete when v(complete)=1.65 rise=18
meas tran f018_d7 find v(dout7_rx) at=9.48e-06
meas tran f018_d6 find v(dout6_rx) at=9.48e-06
meas tran f018_d5 find v(dout5_rx) at=9.48e-06
meas tran f018_d4 find v(dout4_rx) at=9.48e-06
meas tran f018_d3 find v(dout3_rx) at=9.48e-06
meas tran f018_d2 find v(dout2_rx) at=9.48e-06
meas tran f018_d1 find v(dout1_rx) at=9.48e-06
meas tran f018_d0 find v(dout0_rx) at=9.48e-06
meas tran f018_complete find v(complete) at=9.48e-06
meas tran f018_invalid find v(invalid0) at=9.48e-06
meas tran f018_timeout find v(timeout0) at=9.48e-06
meas tran f018_sampled find v(sampled_diff) at=9.17e-06
meas tran f018_input find v(input_diff) at=9.17e-06
meas tran f018_tcomplete when v(complete)=1.65 rise=19
meas tran f019_d7 find v(dout7_rx) at=9.98e-06
meas tran f019_d6 find v(dout6_rx) at=9.98e-06
meas tran f019_d5 find v(dout5_rx) at=9.98e-06
meas tran f019_d4 find v(dout4_rx) at=9.98e-06
meas tran f019_d3 find v(dout3_rx) at=9.98e-06
meas tran f019_d2 find v(dout2_rx) at=9.98e-06
meas tran f019_d1 find v(dout1_rx) at=9.98e-06
meas tran f019_d0 find v(dout0_rx) at=9.98e-06
meas tran f019_complete find v(complete) at=9.98e-06
meas tran f019_invalid find v(invalid0) at=9.98e-06
meas tran f019_timeout find v(timeout0) at=9.98e-06
meas tran f019_sampled find v(sampled_diff) at=9.67e-06
meas tran f019_input find v(input_diff) at=9.67e-06
meas tran f019_tcomplete when v(complete)=1.65 rise=20
meas tran f020_d7 find v(dout7_rx) at=1.048e-05
meas tran f020_d6 find v(dout6_rx) at=1.048e-05
meas tran f020_d5 find v(dout5_rx) at=1.048e-05
meas tran f020_d4 find v(dout4_rx) at=1.048e-05
meas tran f020_d3 find v(dout3_rx) at=1.048e-05
meas tran f020_d2 find v(dout2_rx) at=1.048e-05
meas tran f020_d1 find v(dout1_rx) at=1.048e-05
meas tran f020_d0 find v(dout0_rx) at=1.048e-05
meas tran f020_complete find v(complete) at=1.048e-05
meas tran f020_invalid find v(invalid0) at=1.048e-05
meas tran f020_timeout find v(timeout0) at=1.048e-05
meas tran f020_sampled find v(sampled_diff) at=1.017e-05
meas tran f020_input find v(input_diff) at=1.017e-05
meas tran f020_tcomplete when v(complete)=1.65 rise=21
meas tran f021_d7 find v(dout7_rx) at=1.098e-05
meas tran f021_d6 find v(dout6_rx) at=1.098e-05
meas tran f021_d5 find v(dout5_rx) at=1.098e-05
meas tran f021_d4 find v(dout4_rx) at=1.098e-05
meas tran f021_d3 find v(dout3_rx) at=1.098e-05
meas tran f021_d2 find v(dout2_rx) at=1.098e-05
meas tran f021_d1 find v(dout1_rx) at=1.098e-05
meas tran f021_d0 find v(dout0_rx) at=1.098e-05
meas tran f021_complete find v(complete) at=1.098e-05
meas tran f021_invalid find v(invalid0) at=1.098e-05
meas tran f021_timeout find v(timeout0) at=1.098e-05
meas tran f021_sampled find v(sampled_diff) at=1.067e-05
meas tran f021_input find v(input_diff) at=1.067e-05
meas tran f021_tcomplete when v(complete)=1.65 rise=22
meas tran f022_d7 find v(dout7_rx) at=1.148e-05
meas tran f022_d6 find v(dout6_rx) at=1.148e-05
meas tran f022_d5 find v(dout5_rx) at=1.148e-05
meas tran f022_d4 find v(dout4_rx) at=1.148e-05
meas tran f022_d3 find v(dout3_rx) at=1.148e-05
meas tran f022_d2 find v(dout2_rx) at=1.148e-05
meas tran f022_d1 find v(dout1_rx) at=1.148e-05
meas tran f022_d0 find v(dout0_rx) at=1.148e-05
meas tran f022_complete find v(complete) at=1.148e-05
meas tran f022_invalid find v(invalid0) at=1.148e-05
meas tran f022_timeout find v(timeout0) at=1.148e-05
meas tran f022_sampled find v(sampled_diff) at=1.117e-05
meas tran f022_input find v(input_diff) at=1.117e-05
meas tran f022_tcomplete when v(complete)=1.65 rise=23
meas tran f023_d7 find v(dout7_rx) at=1.198e-05
meas tran f023_d6 find v(dout6_rx) at=1.198e-05
meas tran f023_d5 find v(dout5_rx) at=1.198e-05
meas tran f023_d4 find v(dout4_rx) at=1.198e-05
meas tran f023_d3 find v(dout3_rx) at=1.198e-05
meas tran f023_d2 find v(dout2_rx) at=1.198e-05
meas tran f023_d1 find v(dout1_rx) at=1.198e-05
meas tran f023_d0 find v(dout0_rx) at=1.198e-05
meas tran f023_complete find v(complete) at=1.198e-05
meas tran f023_invalid find v(invalid0) at=1.198e-05
meas tran f023_timeout find v(timeout0) at=1.198e-05
meas tran f023_sampled find v(sampled_diff) at=1.167e-05
meas tran f023_input find v(input_diff) at=1.167e-05
meas tran f023_tcomplete when v(complete)=1.65 rise=24
meas tran f024_d7 find v(dout7_rx) at=1.248e-05
meas tran f024_d6 find v(dout6_rx) at=1.248e-05
meas tran f024_d5 find v(dout5_rx) at=1.248e-05
meas tran f024_d4 find v(dout4_rx) at=1.248e-05
meas tran f024_d3 find v(dout3_rx) at=1.248e-05
meas tran f024_d2 find v(dout2_rx) at=1.248e-05
meas tran f024_d1 find v(dout1_rx) at=1.248e-05
meas tran f024_d0 find v(dout0_rx) at=1.248e-05
meas tran f024_complete find v(complete) at=1.248e-05
meas tran f024_invalid find v(invalid0) at=1.248e-05
meas tran f024_timeout find v(timeout0) at=1.248e-05
meas tran f024_sampled find v(sampled_diff) at=1.217e-05
meas tran f024_input find v(input_diff) at=1.217e-05
meas tran f024_tcomplete when v(complete)=1.65 rise=25
meas tran f025_d7 find v(dout7_rx) at=1.298e-05
meas tran f025_d6 find v(dout6_rx) at=1.298e-05
meas tran f025_d5 find v(dout5_rx) at=1.298e-05
meas tran f025_d4 find v(dout4_rx) at=1.298e-05
meas tran f025_d3 find v(dout3_rx) at=1.298e-05
meas tran f025_d2 find v(dout2_rx) at=1.298e-05
meas tran f025_d1 find v(dout1_rx) at=1.298e-05
meas tran f025_d0 find v(dout0_rx) at=1.298e-05
meas tran f025_complete find v(complete) at=1.298e-05
meas tran f025_invalid find v(invalid0) at=1.298e-05
meas tran f025_timeout find v(timeout0) at=1.298e-05
meas tran f025_sampled find v(sampled_diff) at=1.267e-05
meas tran f025_input find v(input_diff) at=1.267e-05
meas tran f025_tcomplete when v(complete)=1.65 rise=26
meas tran f026_d7 find v(dout7_rx) at=1.348e-05
meas tran f026_d6 find v(dout6_rx) at=1.348e-05
meas tran f026_d5 find v(dout5_rx) at=1.348e-05
meas tran f026_d4 find v(dout4_rx) at=1.348e-05
meas tran f026_d3 find v(dout3_rx) at=1.348e-05
meas tran f026_d2 find v(dout2_rx) at=1.348e-05
meas tran f026_d1 find v(dout1_rx) at=1.348e-05
meas tran f026_d0 find v(dout0_rx) at=1.348e-05
meas tran f026_complete find v(complete) at=1.348e-05
meas tran f026_invalid find v(invalid0) at=1.348e-05
meas tran f026_timeout find v(timeout0) at=1.348e-05
meas tran f026_sampled find v(sampled_diff) at=1.317e-05
meas tran f026_input find v(input_diff) at=1.317e-05
meas tran f026_tcomplete when v(complete)=1.65 rise=27
meas tran f027_d7 find v(dout7_rx) at=1.398e-05
meas tran f027_d6 find v(dout6_rx) at=1.398e-05
meas tran f027_d5 find v(dout5_rx) at=1.398e-05
meas tran f027_d4 find v(dout4_rx) at=1.398e-05
meas tran f027_d3 find v(dout3_rx) at=1.398e-05
meas tran f027_d2 find v(dout2_rx) at=1.398e-05
meas tran f027_d1 find v(dout1_rx) at=1.398e-05
meas tran f027_d0 find v(dout0_rx) at=1.398e-05
meas tran f027_complete find v(complete) at=1.398e-05
meas tran f027_invalid find v(invalid0) at=1.398e-05
meas tran f027_timeout find v(timeout0) at=1.398e-05
meas tran f027_sampled find v(sampled_diff) at=1.367e-05
meas tran f027_input find v(input_diff) at=1.367e-05
meas tran f027_tcomplete when v(complete)=1.65 rise=28
meas tran f028_d7 find v(dout7_rx) at=1.448e-05
meas tran f028_d6 find v(dout6_rx) at=1.448e-05
meas tran f028_d5 find v(dout5_rx) at=1.448e-05
meas tran f028_d4 find v(dout4_rx) at=1.448e-05
meas tran f028_d3 find v(dout3_rx) at=1.448e-05
meas tran f028_d2 find v(dout2_rx) at=1.448e-05
meas tran f028_d1 find v(dout1_rx) at=1.448e-05
meas tran f028_d0 find v(dout0_rx) at=1.448e-05
meas tran f028_complete find v(complete) at=1.448e-05
meas tran f028_invalid find v(invalid0) at=1.448e-05
meas tran f028_timeout find v(timeout0) at=1.448e-05
meas tran f028_sampled find v(sampled_diff) at=1.417e-05
meas tran f028_input find v(input_diff) at=1.417e-05
meas tran f028_tcomplete when v(complete)=1.65 rise=29
meas tran f029_d7 find v(dout7_rx) at=1.498e-05
meas tran f029_d6 find v(dout6_rx) at=1.498e-05
meas tran f029_d5 find v(dout5_rx) at=1.498e-05
meas tran f029_d4 find v(dout4_rx) at=1.498e-05
meas tran f029_d3 find v(dout3_rx) at=1.498e-05
meas tran f029_d2 find v(dout2_rx) at=1.498e-05
meas tran f029_d1 find v(dout1_rx) at=1.498e-05
meas tran f029_d0 find v(dout0_rx) at=1.498e-05
meas tran f029_complete find v(complete) at=1.498e-05
meas tran f029_invalid find v(invalid0) at=1.498e-05
meas tran f029_timeout find v(timeout0) at=1.498e-05
meas tran f029_sampled find v(sampled_diff) at=1.467e-05
meas tran f029_input find v(input_diff) at=1.467e-05
meas tran f029_tcomplete when v(complete)=1.65 rise=30
meas tran f030_d7 find v(dout7_rx) at=1.548e-05
meas tran f030_d6 find v(dout6_rx) at=1.548e-05
meas tran f030_d5 find v(dout5_rx) at=1.548e-05
meas tran f030_d4 find v(dout4_rx) at=1.548e-05
meas tran f030_d3 find v(dout3_rx) at=1.548e-05
meas tran f030_d2 find v(dout2_rx) at=1.548e-05
meas tran f030_d1 find v(dout1_rx) at=1.548e-05
meas tran f030_d0 find v(dout0_rx) at=1.548e-05
meas tran f030_complete find v(complete) at=1.548e-05
meas tran f030_invalid find v(invalid0) at=1.548e-05
meas tran f030_timeout find v(timeout0) at=1.548e-05
meas tran f030_sampled find v(sampled_diff) at=1.517e-05
meas tran f030_input find v(input_diff) at=1.517e-05
meas tran f030_tcomplete when v(complete)=1.65 rise=31
meas tran f031_d7 find v(dout7_rx) at=1.598e-05
meas tran f031_d6 find v(dout6_rx) at=1.598e-05
meas tran f031_d5 find v(dout5_rx) at=1.598e-05
meas tran f031_d4 find v(dout4_rx) at=1.598e-05
meas tran f031_d3 find v(dout3_rx) at=1.598e-05
meas tran f031_d2 find v(dout2_rx) at=1.598e-05
meas tran f031_d1 find v(dout1_rx) at=1.598e-05
meas tran f031_d0 find v(dout0_rx) at=1.598e-05
meas tran f031_complete find v(complete) at=1.598e-05
meas tran f031_invalid find v(invalid0) at=1.598e-05
meas tran f031_timeout find v(timeout0) at=1.598e-05
meas tran f031_sampled find v(sampled_diff) at=1.567e-05
meas tran f031_input find v(input_diff) at=1.567e-05
meas tran f031_tcomplete when v(complete)=1.65 rise=32
meas tran f032_d7 find v(dout7_rx) at=1.648e-05
meas tran f032_d6 find v(dout6_rx) at=1.648e-05
meas tran f032_d5 find v(dout5_rx) at=1.648e-05
meas tran f032_d4 find v(dout4_rx) at=1.648e-05
meas tran f032_d3 find v(dout3_rx) at=1.648e-05
meas tran f032_d2 find v(dout2_rx) at=1.648e-05
meas tran f032_d1 find v(dout1_rx) at=1.648e-05
meas tran f032_d0 find v(dout0_rx) at=1.648e-05
meas tran f032_complete find v(complete) at=1.648e-05
meas tran f032_invalid find v(invalid0) at=1.648e-05
meas tran f032_timeout find v(timeout0) at=1.648e-05
meas tran f032_sampled find v(sampled_diff) at=1.617e-05
meas tran f032_input find v(input_diff) at=1.617e-05
meas tran f032_tcomplete when v(complete)=1.65 rise=33
meas tran f033_d7 find v(dout7_rx) at=1.698e-05
meas tran f033_d6 find v(dout6_rx) at=1.698e-05
meas tran f033_d5 find v(dout5_rx) at=1.698e-05
meas tran f033_d4 find v(dout4_rx) at=1.698e-05
meas tran f033_d3 find v(dout3_rx) at=1.698e-05
meas tran f033_d2 find v(dout2_rx) at=1.698e-05
meas tran f033_d1 find v(dout1_rx) at=1.698e-05
meas tran f033_d0 find v(dout0_rx) at=1.698e-05
meas tran f033_complete find v(complete) at=1.698e-05
meas tran f033_invalid find v(invalid0) at=1.698e-05
meas tran f033_timeout find v(timeout0) at=1.698e-05
meas tran f033_sampled find v(sampled_diff) at=1.667e-05
meas tran f033_input find v(input_diff) at=1.667e-05
meas tran f033_tcomplete when v(complete)=1.65 rise=34
meas tran f034_d7 find v(dout7_rx) at=1.748e-05
meas tran f034_d6 find v(dout6_rx) at=1.748e-05
meas tran f034_d5 find v(dout5_rx) at=1.748e-05
meas tran f034_d4 find v(dout4_rx) at=1.748e-05
meas tran f034_d3 find v(dout3_rx) at=1.748e-05
meas tran f034_d2 find v(dout2_rx) at=1.748e-05
meas tran f034_d1 find v(dout1_rx) at=1.748e-05
meas tran f034_d0 find v(dout0_rx) at=1.748e-05
meas tran f034_complete find v(complete) at=1.748e-05
meas tran f034_invalid find v(invalid0) at=1.748e-05
meas tran f034_timeout find v(timeout0) at=1.748e-05
meas tran f034_sampled find v(sampled_diff) at=1.717e-05
meas tran f034_input find v(input_diff) at=1.717e-05
meas tran f034_tcomplete when v(complete)=1.65 rise=35
meas tran f035_d7 find v(dout7_rx) at=1.798e-05
meas tran f035_d6 find v(dout6_rx) at=1.798e-05
meas tran f035_d5 find v(dout5_rx) at=1.798e-05
meas tran f035_d4 find v(dout4_rx) at=1.798e-05
meas tran f035_d3 find v(dout3_rx) at=1.798e-05
meas tran f035_d2 find v(dout2_rx) at=1.798e-05
meas tran f035_d1 find v(dout1_rx) at=1.798e-05
meas tran f035_d0 find v(dout0_rx) at=1.798e-05
meas tran f035_complete find v(complete) at=1.798e-05
meas tran f035_invalid find v(invalid0) at=1.798e-05
meas tran f035_timeout find v(timeout0) at=1.798e-05
meas tran f035_sampled find v(sampled_diff) at=1.767e-05
meas tran f035_input find v(input_diff) at=1.767e-05
meas tran f035_tcomplete when v(complete)=1.65 rise=36
meas tran f036_d7 find v(dout7_rx) at=1.848e-05
meas tran f036_d6 find v(dout6_rx) at=1.848e-05
meas tran f036_d5 find v(dout5_rx) at=1.848e-05
meas tran f036_d4 find v(dout4_rx) at=1.848e-05
meas tran f036_d3 find v(dout3_rx) at=1.848e-05
meas tran f036_d2 find v(dout2_rx) at=1.848e-05
meas tran f036_d1 find v(dout1_rx) at=1.848e-05
meas tran f036_d0 find v(dout0_rx) at=1.848e-05
meas tran f036_complete find v(complete) at=1.848e-05
meas tran f036_invalid find v(invalid0) at=1.848e-05
meas tran f036_timeout find v(timeout0) at=1.848e-05
meas tran f036_sampled find v(sampled_diff) at=1.817e-05
meas tran f036_input find v(input_diff) at=1.817e-05
meas tran f036_tcomplete when v(complete)=1.65 rise=37
meas tran f037_d7 find v(dout7_rx) at=1.898e-05
meas tran f037_d6 find v(dout6_rx) at=1.898e-05
meas tran f037_d5 find v(dout5_rx) at=1.898e-05
meas tran f037_d4 find v(dout4_rx) at=1.898e-05
meas tran f037_d3 find v(dout3_rx) at=1.898e-05
meas tran f037_d2 find v(dout2_rx) at=1.898e-05
meas tran f037_d1 find v(dout1_rx) at=1.898e-05
meas tran f037_d0 find v(dout0_rx) at=1.898e-05
meas tran f037_complete find v(complete) at=1.898e-05
meas tran f037_invalid find v(invalid0) at=1.898e-05
meas tran f037_timeout find v(timeout0) at=1.898e-05
meas tran f037_sampled find v(sampled_diff) at=1.867e-05
meas tran f037_input find v(input_diff) at=1.867e-05
meas tran f037_tcomplete when v(complete)=1.65 rise=38
meas tran f038_d7 find v(dout7_rx) at=1.948e-05
meas tran f038_d6 find v(dout6_rx) at=1.948e-05
meas tran f038_d5 find v(dout5_rx) at=1.948e-05
meas tran f038_d4 find v(dout4_rx) at=1.948e-05
meas tran f038_d3 find v(dout3_rx) at=1.948e-05
meas tran f038_d2 find v(dout2_rx) at=1.948e-05
meas tran f038_d1 find v(dout1_rx) at=1.948e-05
meas tran f038_d0 find v(dout0_rx) at=1.948e-05
meas tran f038_complete find v(complete) at=1.948e-05
meas tran f038_invalid find v(invalid0) at=1.948e-05
meas tran f038_timeout find v(timeout0) at=1.948e-05
meas tran f038_sampled find v(sampled_diff) at=1.917e-05
meas tran f038_input find v(input_diff) at=1.917e-05
meas tran f038_tcomplete when v(complete)=1.65 rise=39
meas tran f039_d7 find v(dout7_rx) at=1.998e-05
meas tran f039_d6 find v(dout6_rx) at=1.998e-05
meas tran f039_d5 find v(dout5_rx) at=1.998e-05
meas tran f039_d4 find v(dout4_rx) at=1.998e-05
meas tran f039_d3 find v(dout3_rx) at=1.998e-05
meas tran f039_d2 find v(dout2_rx) at=1.998e-05
meas tran f039_d1 find v(dout1_rx) at=1.998e-05
meas tran f039_d0 find v(dout0_rx) at=1.998e-05
meas tran f039_complete find v(complete) at=1.998e-05
meas tran f039_invalid find v(invalid0) at=1.998e-05
meas tran f039_timeout find v(timeout0) at=1.998e-05
meas tran f039_sampled find v(sampled_diff) at=1.967e-05
meas tran f039_input find v(input_diff) at=1.967e-05
meas tran f039_tcomplete when v(complete)=1.65 rise=40
meas tran f040_d7 find v(dout7_rx) at=2.048e-05
meas tran f040_d6 find v(dout6_rx) at=2.048e-05
meas tran f040_d5 find v(dout5_rx) at=2.048e-05
meas tran f040_d4 find v(dout4_rx) at=2.048e-05
meas tran f040_d3 find v(dout3_rx) at=2.048e-05
meas tran f040_d2 find v(dout2_rx) at=2.048e-05
meas tran f040_d1 find v(dout1_rx) at=2.048e-05
meas tran f040_d0 find v(dout0_rx) at=2.048e-05
meas tran f040_complete find v(complete) at=2.048e-05
meas tran f040_invalid find v(invalid0) at=2.048e-05
meas tran f040_timeout find v(timeout0) at=2.048e-05
meas tran f040_sampled find v(sampled_diff) at=2.017e-05
meas tran f040_input find v(input_diff) at=2.017e-05
meas tran f040_tcomplete when v(complete)=1.65 rise=41
meas tran f041_d7 find v(dout7_rx) at=2.098e-05
meas tran f041_d6 find v(dout6_rx) at=2.098e-05
meas tran f041_d5 find v(dout5_rx) at=2.098e-05
meas tran f041_d4 find v(dout4_rx) at=2.098e-05
meas tran f041_d3 find v(dout3_rx) at=2.098e-05
meas tran f041_d2 find v(dout2_rx) at=2.098e-05
meas tran f041_d1 find v(dout1_rx) at=2.098e-05
meas tran f041_d0 find v(dout0_rx) at=2.098e-05
meas tran f041_complete find v(complete) at=2.098e-05
meas tran f041_invalid find v(invalid0) at=2.098e-05
meas tran f041_timeout find v(timeout0) at=2.098e-05
meas tran f041_sampled find v(sampled_diff) at=2.067e-05
meas tran f041_input find v(input_diff) at=2.067e-05
meas tran f041_tcomplete when v(complete)=1.65 rise=42
meas tran f042_d7 find v(dout7_rx) at=2.148e-05
meas tran f042_d6 find v(dout6_rx) at=2.148e-05
meas tran f042_d5 find v(dout5_rx) at=2.148e-05
meas tran f042_d4 find v(dout4_rx) at=2.148e-05
meas tran f042_d3 find v(dout3_rx) at=2.148e-05
meas tran f042_d2 find v(dout2_rx) at=2.148e-05
meas tran f042_d1 find v(dout1_rx) at=2.148e-05
meas tran f042_d0 find v(dout0_rx) at=2.148e-05
meas tran f042_complete find v(complete) at=2.148e-05
meas tran f042_invalid find v(invalid0) at=2.148e-05
meas tran f042_timeout find v(timeout0) at=2.148e-05
meas tran f042_sampled find v(sampled_diff) at=2.117e-05
meas tran f042_input find v(input_diff) at=2.117e-05
meas tran f042_tcomplete when v(complete)=1.65 rise=43
meas tran f043_d7 find v(dout7_rx) at=2.198e-05
meas tran f043_d6 find v(dout6_rx) at=2.198e-05
meas tran f043_d5 find v(dout5_rx) at=2.198e-05
meas tran f043_d4 find v(dout4_rx) at=2.198e-05
meas tran f043_d3 find v(dout3_rx) at=2.198e-05
meas tran f043_d2 find v(dout2_rx) at=2.198e-05
meas tran f043_d1 find v(dout1_rx) at=2.198e-05
meas tran f043_d0 find v(dout0_rx) at=2.198e-05
meas tran f043_complete find v(complete) at=2.198e-05
meas tran f043_invalid find v(invalid0) at=2.198e-05
meas tran f043_timeout find v(timeout0) at=2.198e-05
meas tran f043_sampled find v(sampled_diff) at=2.167e-05
meas tran f043_input find v(input_diff) at=2.167e-05
meas tran f043_tcomplete when v(complete)=1.65 rise=44
meas tran f044_d7 find v(dout7_rx) at=2.248e-05
meas tran f044_d6 find v(dout6_rx) at=2.248e-05
meas tran f044_d5 find v(dout5_rx) at=2.248e-05
meas tran f044_d4 find v(dout4_rx) at=2.248e-05
meas tran f044_d3 find v(dout3_rx) at=2.248e-05
meas tran f044_d2 find v(dout2_rx) at=2.248e-05
meas tran f044_d1 find v(dout1_rx) at=2.248e-05
meas tran f044_d0 find v(dout0_rx) at=2.248e-05
meas tran f044_complete find v(complete) at=2.248e-05
meas tran f044_invalid find v(invalid0) at=2.248e-05
meas tran f044_timeout find v(timeout0) at=2.248e-05
meas tran f044_sampled find v(sampled_diff) at=2.217e-05
meas tran f044_input find v(input_diff) at=2.217e-05
meas tran f044_tcomplete when v(complete)=1.65 rise=45
meas tran f045_d7 find v(dout7_rx) at=2.298e-05
meas tran f045_d6 find v(dout6_rx) at=2.298e-05
meas tran f045_d5 find v(dout5_rx) at=2.298e-05
meas tran f045_d4 find v(dout4_rx) at=2.298e-05
meas tran f045_d3 find v(dout3_rx) at=2.298e-05
meas tran f045_d2 find v(dout2_rx) at=2.298e-05
meas tran f045_d1 find v(dout1_rx) at=2.298e-05
meas tran f045_d0 find v(dout0_rx) at=2.298e-05
meas tran f045_complete find v(complete) at=2.298e-05
meas tran f045_invalid find v(invalid0) at=2.298e-05
meas tran f045_timeout find v(timeout0) at=2.298e-05
meas tran f045_sampled find v(sampled_diff) at=2.267e-05
meas tran f045_input find v(input_diff) at=2.267e-05
meas tran f045_tcomplete when v(complete)=1.65 rise=46
meas tran f046_d7 find v(dout7_rx) at=2.348e-05
meas tran f046_d6 find v(dout6_rx) at=2.348e-05
meas tran f046_d5 find v(dout5_rx) at=2.348e-05
meas tran f046_d4 find v(dout4_rx) at=2.348e-05
meas tran f046_d3 find v(dout3_rx) at=2.348e-05
meas tran f046_d2 find v(dout2_rx) at=2.348e-05
meas tran f046_d1 find v(dout1_rx) at=2.348e-05
meas tran f046_d0 find v(dout0_rx) at=2.348e-05
meas tran f046_complete find v(complete) at=2.348e-05
meas tran f046_invalid find v(invalid0) at=2.348e-05
meas tran f046_timeout find v(timeout0) at=2.348e-05
meas tran f046_sampled find v(sampled_diff) at=2.317e-05
meas tran f046_input find v(input_diff) at=2.317e-05
meas tran f046_tcomplete when v(complete)=1.65 rise=47
meas tran f047_d7 find v(dout7_rx) at=2.398e-05
meas tran f047_d6 find v(dout6_rx) at=2.398e-05
meas tran f047_d5 find v(dout5_rx) at=2.398e-05
meas tran f047_d4 find v(dout4_rx) at=2.398e-05
meas tran f047_d3 find v(dout3_rx) at=2.398e-05
meas tran f047_d2 find v(dout2_rx) at=2.398e-05
meas tran f047_d1 find v(dout1_rx) at=2.398e-05
meas tran f047_d0 find v(dout0_rx) at=2.398e-05
meas tran f047_complete find v(complete) at=2.398e-05
meas tran f047_invalid find v(invalid0) at=2.398e-05
meas tran f047_timeout find v(timeout0) at=2.398e-05
meas tran f047_sampled find v(sampled_diff) at=2.367e-05
meas tran f047_input find v(input_diff) at=2.367e-05
meas tran f047_tcomplete when v(complete)=1.65 rise=48
meas tran f048_d7 find v(dout7_rx) at=2.448e-05
meas tran f048_d6 find v(dout6_rx) at=2.448e-05
meas tran f048_d5 find v(dout5_rx) at=2.448e-05
meas tran f048_d4 find v(dout4_rx) at=2.448e-05
meas tran f048_d3 find v(dout3_rx) at=2.448e-05
meas tran f048_d2 find v(dout2_rx) at=2.448e-05
meas tran f048_d1 find v(dout1_rx) at=2.448e-05
meas tran f048_d0 find v(dout0_rx) at=2.448e-05
meas tran f048_complete find v(complete) at=2.448e-05
meas tran f048_invalid find v(invalid0) at=2.448e-05
meas tran f048_timeout find v(timeout0) at=2.448e-05
meas tran f048_sampled find v(sampled_diff) at=2.417e-05
meas tran f048_input find v(input_diff) at=2.417e-05
meas tran f048_tcomplete when v(complete)=1.65 rise=49
meas tran f049_d7 find v(dout7_rx) at=2.498e-05
meas tran f049_d6 find v(dout6_rx) at=2.498e-05
meas tran f049_d5 find v(dout5_rx) at=2.498e-05
meas tran f049_d4 find v(dout4_rx) at=2.498e-05
meas tran f049_d3 find v(dout3_rx) at=2.498e-05
meas tran f049_d2 find v(dout2_rx) at=2.498e-05
meas tran f049_d1 find v(dout1_rx) at=2.498e-05
meas tran f049_d0 find v(dout0_rx) at=2.498e-05
meas tran f049_complete find v(complete) at=2.498e-05
meas tran f049_invalid find v(invalid0) at=2.498e-05
meas tran f049_timeout find v(timeout0) at=2.498e-05
meas tran f049_sampled find v(sampled_diff) at=2.467e-05
meas tran f049_input find v(input_diff) at=2.467e-05
meas tran f049_tcomplete when v(complete)=1.65 rise=50
meas tran f050_d7 find v(dout7_rx) at=2.548e-05
meas tran f050_d6 find v(dout6_rx) at=2.548e-05
meas tran f050_d5 find v(dout5_rx) at=2.548e-05
meas tran f050_d4 find v(dout4_rx) at=2.548e-05
meas tran f050_d3 find v(dout3_rx) at=2.548e-05
meas tran f050_d2 find v(dout2_rx) at=2.548e-05
meas tran f050_d1 find v(dout1_rx) at=2.548e-05
meas tran f050_d0 find v(dout0_rx) at=2.548e-05
meas tran f050_complete find v(complete) at=2.548e-05
meas tran f050_invalid find v(invalid0) at=2.548e-05
meas tran f050_timeout find v(timeout0) at=2.548e-05
meas tran f050_sampled find v(sampled_diff) at=2.517e-05
meas tran f050_input find v(input_diff) at=2.517e-05
meas tran f050_tcomplete when v(complete)=1.65 rise=51
meas tran f051_d7 find v(dout7_rx) at=2.598e-05
meas tran f051_d6 find v(dout6_rx) at=2.598e-05
meas tran f051_d5 find v(dout5_rx) at=2.598e-05
meas tran f051_d4 find v(dout4_rx) at=2.598e-05
meas tran f051_d3 find v(dout3_rx) at=2.598e-05
meas tran f051_d2 find v(dout2_rx) at=2.598e-05
meas tran f051_d1 find v(dout1_rx) at=2.598e-05
meas tran f051_d0 find v(dout0_rx) at=2.598e-05
meas tran f051_complete find v(complete) at=2.598e-05
meas tran f051_invalid find v(invalid0) at=2.598e-05
meas tran f051_timeout find v(timeout0) at=2.598e-05
meas tran f051_sampled find v(sampled_diff) at=2.567e-05
meas tran f051_input find v(input_diff) at=2.567e-05
meas tran f051_tcomplete when v(complete)=1.65 rise=52
meas tran f052_d7 find v(dout7_rx) at=2.648e-05
meas tran f052_d6 find v(dout6_rx) at=2.648e-05
meas tran f052_d5 find v(dout5_rx) at=2.648e-05
meas tran f052_d4 find v(dout4_rx) at=2.648e-05
meas tran f052_d3 find v(dout3_rx) at=2.648e-05
meas tran f052_d2 find v(dout2_rx) at=2.648e-05
meas tran f052_d1 find v(dout1_rx) at=2.648e-05
meas tran f052_d0 find v(dout0_rx) at=2.648e-05
meas tran f052_complete find v(complete) at=2.648e-05
meas tran f052_invalid find v(invalid0) at=2.648e-05
meas tran f052_timeout find v(timeout0) at=2.648e-05
meas tran f052_sampled find v(sampled_diff) at=2.617e-05
meas tran f052_input find v(input_diff) at=2.617e-05
meas tran f052_tcomplete when v(complete)=1.65 rise=53
meas tran f053_d7 find v(dout7_rx) at=2.698e-05
meas tran f053_d6 find v(dout6_rx) at=2.698e-05
meas tran f053_d5 find v(dout5_rx) at=2.698e-05
meas tran f053_d4 find v(dout4_rx) at=2.698e-05
meas tran f053_d3 find v(dout3_rx) at=2.698e-05
meas tran f053_d2 find v(dout2_rx) at=2.698e-05
meas tran f053_d1 find v(dout1_rx) at=2.698e-05
meas tran f053_d0 find v(dout0_rx) at=2.698e-05
meas tran f053_complete find v(complete) at=2.698e-05
meas tran f053_invalid find v(invalid0) at=2.698e-05
meas tran f053_timeout find v(timeout0) at=2.698e-05
meas tran f053_sampled find v(sampled_diff) at=2.667e-05
meas tran f053_input find v(input_diff) at=2.667e-05
meas tran f053_tcomplete when v(complete)=1.65 rise=54
meas tran f054_d7 find v(dout7_rx) at=2.748e-05
meas tran f054_d6 find v(dout6_rx) at=2.748e-05
meas tran f054_d5 find v(dout5_rx) at=2.748e-05
meas tran f054_d4 find v(dout4_rx) at=2.748e-05
meas tran f054_d3 find v(dout3_rx) at=2.748e-05
meas tran f054_d2 find v(dout2_rx) at=2.748e-05
meas tran f054_d1 find v(dout1_rx) at=2.748e-05
meas tran f054_d0 find v(dout0_rx) at=2.748e-05
meas tran f054_complete find v(complete) at=2.748e-05
meas tran f054_invalid find v(invalid0) at=2.748e-05
meas tran f054_timeout find v(timeout0) at=2.748e-05
meas tran f054_sampled find v(sampled_diff) at=2.717e-05
meas tran f054_input find v(input_diff) at=2.717e-05
meas tran f054_tcomplete when v(complete)=1.65 rise=55
meas tran f055_d7 find v(dout7_rx) at=2.798e-05
meas tran f055_d6 find v(dout6_rx) at=2.798e-05
meas tran f055_d5 find v(dout5_rx) at=2.798e-05
meas tran f055_d4 find v(dout4_rx) at=2.798e-05
meas tran f055_d3 find v(dout3_rx) at=2.798e-05
meas tran f055_d2 find v(dout2_rx) at=2.798e-05
meas tran f055_d1 find v(dout1_rx) at=2.798e-05
meas tran f055_d0 find v(dout0_rx) at=2.798e-05
meas tran f055_complete find v(complete) at=2.798e-05
meas tran f055_invalid find v(invalid0) at=2.798e-05
meas tran f055_timeout find v(timeout0) at=2.798e-05
meas tran f055_sampled find v(sampled_diff) at=2.767e-05
meas tran f055_input find v(input_diff) at=2.767e-05
meas tran f055_tcomplete when v(complete)=1.65 rise=56
meas tran f056_d7 find v(dout7_rx) at=2.848e-05
meas tran f056_d6 find v(dout6_rx) at=2.848e-05
meas tran f056_d5 find v(dout5_rx) at=2.848e-05
meas tran f056_d4 find v(dout4_rx) at=2.848e-05
meas tran f056_d3 find v(dout3_rx) at=2.848e-05
meas tran f056_d2 find v(dout2_rx) at=2.848e-05
meas tran f056_d1 find v(dout1_rx) at=2.848e-05
meas tran f056_d0 find v(dout0_rx) at=2.848e-05
meas tran f056_complete find v(complete) at=2.848e-05
meas tran f056_invalid find v(invalid0) at=2.848e-05
meas tran f056_timeout find v(timeout0) at=2.848e-05
meas tran f056_sampled find v(sampled_diff) at=2.817e-05
meas tran f056_input find v(input_diff) at=2.817e-05
meas tran f056_tcomplete when v(complete)=1.65 rise=57
meas tran f057_d7 find v(dout7_rx) at=2.898e-05
meas tran f057_d6 find v(dout6_rx) at=2.898e-05
meas tran f057_d5 find v(dout5_rx) at=2.898e-05
meas tran f057_d4 find v(dout4_rx) at=2.898e-05
meas tran f057_d3 find v(dout3_rx) at=2.898e-05
meas tran f057_d2 find v(dout2_rx) at=2.898e-05
meas tran f057_d1 find v(dout1_rx) at=2.898e-05
meas tran f057_d0 find v(dout0_rx) at=2.898e-05
meas tran f057_complete find v(complete) at=2.898e-05
meas tran f057_invalid find v(invalid0) at=2.898e-05
meas tran f057_timeout find v(timeout0) at=2.898e-05
meas tran f057_sampled find v(sampled_diff) at=2.867e-05
meas tran f057_input find v(input_diff) at=2.867e-05
meas tran f057_tcomplete when v(complete)=1.65 rise=58
meas tran f058_d7 find v(dout7_rx) at=2.948e-05
meas tran f058_d6 find v(dout6_rx) at=2.948e-05
meas tran f058_d5 find v(dout5_rx) at=2.948e-05
meas tran f058_d4 find v(dout4_rx) at=2.948e-05
meas tran f058_d3 find v(dout3_rx) at=2.948e-05
meas tran f058_d2 find v(dout2_rx) at=2.948e-05
meas tran f058_d1 find v(dout1_rx) at=2.948e-05
meas tran f058_d0 find v(dout0_rx) at=2.948e-05
meas tran f058_complete find v(complete) at=2.948e-05
meas tran f058_invalid find v(invalid0) at=2.948e-05
meas tran f058_timeout find v(timeout0) at=2.948e-05
meas tran f058_sampled find v(sampled_diff) at=2.917e-05
meas tran f058_input find v(input_diff) at=2.917e-05
meas tran f058_tcomplete when v(complete)=1.65 rise=59
meas tran f059_d7 find v(dout7_rx) at=2.998e-05
meas tran f059_d6 find v(dout6_rx) at=2.998e-05
meas tran f059_d5 find v(dout5_rx) at=2.998e-05
meas tran f059_d4 find v(dout4_rx) at=2.998e-05
meas tran f059_d3 find v(dout3_rx) at=2.998e-05
meas tran f059_d2 find v(dout2_rx) at=2.998e-05
meas tran f059_d1 find v(dout1_rx) at=2.998e-05
meas tran f059_d0 find v(dout0_rx) at=2.998e-05
meas tran f059_complete find v(complete) at=2.998e-05
meas tran f059_invalid find v(invalid0) at=2.998e-05
meas tran f059_timeout find v(timeout0) at=2.998e-05
meas tran f059_sampled find v(sampled_diff) at=2.967e-05
meas tran f059_input find v(input_diff) at=2.967e-05
meas tran f059_tcomplete when v(complete)=1.65 rise=60
meas tran f060_d7 find v(dout7_rx) at=3.048e-05
meas tran f060_d6 find v(dout6_rx) at=3.048e-05
meas tran f060_d5 find v(dout5_rx) at=3.048e-05
meas tran f060_d4 find v(dout4_rx) at=3.048e-05
meas tran f060_d3 find v(dout3_rx) at=3.048e-05
meas tran f060_d2 find v(dout2_rx) at=3.048e-05
meas tran f060_d1 find v(dout1_rx) at=3.048e-05
meas tran f060_d0 find v(dout0_rx) at=3.048e-05
meas tran f060_complete find v(complete) at=3.048e-05
meas tran f060_invalid find v(invalid0) at=3.048e-05
meas tran f060_timeout find v(timeout0) at=3.048e-05
meas tran f060_sampled find v(sampled_diff) at=3.017e-05
meas tran f060_input find v(input_diff) at=3.017e-05
meas tran f060_tcomplete when v(complete)=1.65 rise=61
meas tran f061_d7 find v(dout7_rx) at=3.098e-05
meas tran f061_d6 find v(dout6_rx) at=3.098e-05
meas tran f061_d5 find v(dout5_rx) at=3.098e-05
meas tran f061_d4 find v(dout4_rx) at=3.098e-05
meas tran f061_d3 find v(dout3_rx) at=3.098e-05
meas tran f061_d2 find v(dout2_rx) at=3.098e-05
meas tran f061_d1 find v(dout1_rx) at=3.098e-05
meas tran f061_d0 find v(dout0_rx) at=3.098e-05
meas tran f061_complete find v(complete) at=3.098e-05
meas tran f061_invalid find v(invalid0) at=3.098e-05
meas tran f061_timeout find v(timeout0) at=3.098e-05
meas tran f061_sampled find v(sampled_diff) at=3.067e-05
meas tran f061_input find v(input_diff) at=3.067e-05
meas tran f061_tcomplete when v(complete)=1.65 rise=62
meas tran f062_d7 find v(dout7_rx) at=3.148e-05
meas tran f062_d6 find v(dout6_rx) at=3.148e-05
meas tran f062_d5 find v(dout5_rx) at=3.148e-05
meas tran f062_d4 find v(dout4_rx) at=3.148e-05
meas tran f062_d3 find v(dout3_rx) at=3.148e-05
meas tran f062_d2 find v(dout2_rx) at=3.148e-05
meas tran f062_d1 find v(dout1_rx) at=3.148e-05
meas tran f062_d0 find v(dout0_rx) at=3.148e-05
meas tran f062_complete find v(complete) at=3.148e-05
meas tran f062_invalid find v(invalid0) at=3.148e-05
meas tran f062_timeout find v(timeout0) at=3.148e-05
meas tran f062_sampled find v(sampled_diff) at=3.117e-05
meas tran f062_input find v(input_diff) at=3.117e-05
meas tran f062_tcomplete when v(complete)=1.65 rise=63
meas tran f063_d7 find v(dout7_rx) at=3.198e-05
meas tran f063_d6 find v(dout6_rx) at=3.198e-05
meas tran f063_d5 find v(dout5_rx) at=3.198e-05
meas tran f063_d4 find v(dout4_rx) at=3.198e-05
meas tran f063_d3 find v(dout3_rx) at=3.198e-05
meas tran f063_d2 find v(dout2_rx) at=3.198e-05
meas tran f063_d1 find v(dout1_rx) at=3.198e-05
meas tran f063_d0 find v(dout0_rx) at=3.198e-05
meas tran f063_complete find v(complete) at=3.198e-05
meas tran f063_invalid find v(invalid0) at=3.198e-05
meas tran f063_timeout find v(timeout0) at=3.198e-05
meas tran f063_sampled find v(sampled_diff) at=3.167e-05
meas tran f063_input find v(input_diff) at=3.167e-05
meas tran f063_tcomplete when v(complete)=1.65 rise=64
meas tran f064_d7 find v(dout7_rx) at=3.248e-05
meas tran f064_d6 find v(dout6_rx) at=3.248e-05
meas tran f064_d5 find v(dout5_rx) at=3.248e-05
meas tran f064_d4 find v(dout4_rx) at=3.248e-05
meas tran f064_d3 find v(dout3_rx) at=3.248e-05
meas tran f064_d2 find v(dout2_rx) at=3.248e-05
meas tran f064_d1 find v(dout1_rx) at=3.248e-05
meas tran f064_d0 find v(dout0_rx) at=3.248e-05
meas tran f064_complete find v(complete) at=3.248e-05
meas tran f064_invalid find v(invalid0) at=3.248e-05
meas tran f064_timeout find v(timeout0) at=3.248e-05
meas tran f064_sampled find v(sampled_diff) at=3.217e-05
meas tran f064_input find v(input_diff) at=3.217e-05
meas tran f064_tcomplete when v(complete)=1.65 rise=65
meas tran f065_d7 find v(dout7_rx) at=3.298e-05
meas tran f065_d6 find v(dout6_rx) at=3.298e-05
meas tran f065_d5 find v(dout5_rx) at=3.298e-05
meas tran f065_d4 find v(dout4_rx) at=3.298e-05
meas tran f065_d3 find v(dout3_rx) at=3.298e-05
meas tran f065_d2 find v(dout2_rx) at=3.298e-05
meas tran f065_d1 find v(dout1_rx) at=3.298e-05
meas tran f065_d0 find v(dout0_rx) at=3.298e-05
meas tran f065_complete find v(complete) at=3.298e-05
meas tran f065_invalid find v(invalid0) at=3.298e-05
meas tran f065_timeout find v(timeout0) at=3.298e-05
meas tran f065_sampled find v(sampled_diff) at=3.267e-05
meas tran f065_input find v(input_diff) at=3.267e-05
meas tran f065_tcomplete when v(complete)=1.65 rise=66
meas tran f066_d7 find v(dout7_rx) at=3.348e-05
meas tran f066_d6 find v(dout6_rx) at=3.348e-05
meas tran f066_d5 find v(dout5_rx) at=3.348e-05
meas tran f066_d4 find v(dout4_rx) at=3.348e-05
meas tran f066_d3 find v(dout3_rx) at=3.348e-05
meas tran f066_d2 find v(dout2_rx) at=3.348e-05
meas tran f066_d1 find v(dout1_rx) at=3.348e-05
meas tran f066_d0 find v(dout0_rx) at=3.348e-05
meas tran f066_complete find v(complete) at=3.348e-05
meas tran f066_invalid find v(invalid0) at=3.348e-05
meas tran f066_timeout find v(timeout0) at=3.348e-05
meas tran f066_sampled find v(sampled_diff) at=3.317e-05
meas tran f066_input find v(input_diff) at=3.317e-05
meas tran f066_tcomplete when v(complete)=1.65 rise=67
meas tran f067_d7 find v(dout7_rx) at=3.398e-05
meas tran f067_d6 find v(dout6_rx) at=3.398e-05
meas tran f067_d5 find v(dout5_rx) at=3.398e-05
meas tran f067_d4 find v(dout4_rx) at=3.398e-05
meas tran f067_d3 find v(dout3_rx) at=3.398e-05
meas tran f067_d2 find v(dout2_rx) at=3.398e-05
meas tran f067_d1 find v(dout1_rx) at=3.398e-05
meas tran f067_d0 find v(dout0_rx) at=3.398e-05
meas tran f067_complete find v(complete) at=3.398e-05
meas tran f067_invalid find v(invalid0) at=3.398e-05
meas tran f067_timeout find v(timeout0) at=3.398e-05
meas tran f067_sampled find v(sampled_diff) at=3.367e-05
meas tran f067_input find v(input_diff) at=3.367e-05
meas tran f067_tcomplete when v(complete)=1.65 rise=68
meas tran p_f000_cmp7_p0 find v(dcmpp) at=1.86964e-07
meas tran p_f000_cmp7_n0 find v(dcmpn) at=1.86964e-07
meas tran p_f000_cmp7_p5 find v(dcmpp) at=1.91964e-07
meas tran p_f000_cmp7_n5 find v(dcmpn) at=1.91964e-07
meas tran p_f000_cmp6_p0 find v(dcmpp) at=2.12324e-07
meas tran p_f000_cmp6_n0 find v(dcmpn) at=2.12324e-07
meas tran p_f000_cmp6_p5 find v(dcmpp) at=2.17324e-07
meas tran p_f000_cmp6_n5 find v(dcmpn) at=2.17324e-07
meas tran p_f000_cmp5_p0 find v(dcmpp) at=2.37867e-07
meas tran p_f000_cmp5_n0 find v(dcmpn) at=2.37867e-07
meas tran p_f000_cmp5_p5 find v(dcmpp) at=2.42867e-07
meas tran p_f000_cmp5_n5 find v(dcmpn) at=2.42867e-07
meas tran p_f000_cmp4_p0 find v(dcmpp) at=2.63334e-07
meas tran p_f000_cmp4_n0 find v(dcmpn) at=2.63334e-07
meas tran p_f000_cmp4_p5 find v(dcmpp) at=2.68334e-07
meas tran p_f000_cmp4_n5 find v(dcmpn) at=2.68334e-07
meas tran p_f000_cmp3_p0 find v(dcmpp) at=2.88696e-07
meas tran p_f000_cmp3_n0 find v(dcmpn) at=2.88696e-07
meas tran p_f000_cmp3_p5 find v(dcmpp) at=2.93696e-07
meas tran p_f000_cmp3_n5 find v(dcmpn) at=2.93696e-07
meas tran p_f000_cmp2_p0 find v(dcmpp) at=3.14134e-07
meas tran p_f000_cmp2_n0 find v(dcmpn) at=3.14134e-07
meas tran p_f000_cmp2_p5 find v(dcmpp) at=3.19134e-07
meas tran p_f000_cmp2_n5 find v(dcmpn) at=3.19134e-07
meas tran p_f000_cmp1_p0 find v(dcmpp) at=3.39679e-07
meas tran p_f000_cmp1_n0 find v(dcmpn) at=3.39679e-07
meas tran p_f000_cmp1_p5 find v(dcmpp) at=3.44679e-07
meas tran p_f000_cmp1_n5 find v(dcmpn) at=3.44679e-07
meas tran p_f000_cmp0_p0 find v(dcmpp) at=3.65055e-07
meas tran p_f000_cmp0_n0 find v(dcmpn) at=3.65055e-07
meas tran p_f000_cmp0_p5 find v(dcmpp) at=3.70055e-07
meas tran p_f000_cmp0_n5 find v(dcmpn) at=3.70055e-07
meas tran p_f000_dctrl7_p find v(dctrlp7) at=2.105e-07
meas tran p_f000_dctrl7_n find v(dctrln7) at=2.105e-07
meas tran p_f000_dctrl6_p find v(dctrlp6) at=2.35953e-07
meas tran p_f000_dctrl6_n find v(dctrln6) at=2.35953e-07
meas tran p_f000_dctrl5_p find v(dctrlp5) at=2.6142e-07
meas tran p_f000_dctrl5_n find v(dctrln5) at=2.6142e-07
meas tran p_f000_dctrl4_p find v(dctrlp4) at=2.86871e-07
meas tran p_f000_dctrl4_n find v(dctrln4) at=2.86871e-07
meas tran p_f000_dctrl3_p find v(dctrlp3) at=3.12309e-07
meas tran p_f000_dctrl3_n find v(dctrln3) at=3.12309e-07
meas tran p_f000_dctrl2_p find v(dctrlp2) at=3.37765e-07
meas tran p_f000_dctrl2_n find v(dctrln2) at=3.37765e-07
meas tran p_f000_dctrl1_p find v(dctrlp1) at=3.63231e-07
meas tran p_f000_dctrl1_n find v(dctrln1) at=3.63231e-07
meas tran p_f000_do7_drv_470 find v(dout7_drv) at=4.7e-07
meas tran p_f000_do7_rx_470 find v(dout7_rx) at=4.7e-07
meas tran p_f000_do6_drv_470 find v(dout6_drv) at=4.7e-07
meas tran p_f000_do6_rx_470 find v(dout6_rx) at=4.7e-07
meas tran p_f000_do5_drv_470 find v(dout5_drv) at=4.7e-07
meas tran p_f000_do5_rx_470 find v(dout5_rx) at=4.7e-07
meas tran p_f000_do4_drv_470 find v(dout4_drv) at=4.7e-07
meas tran p_f000_do4_rx_470 find v(dout4_rx) at=4.7e-07
meas tran p_f000_do3_drv_470 find v(dout3_drv) at=4.7e-07
meas tran p_f000_do3_rx_470 find v(dout3_rx) at=4.7e-07
meas tran p_f000_do2_drv_470 find v(dout2_drv) at=4.7e-07
meas tran p_f000_do2_rx_470 find v(dout2_rx) at=4.7e-07
meas tran p_f000_do1_drv_470 find v(dout1_drv) at=4.7e-07
meas tran p_f000_do1_rx_470 find v(dout1_rx) at=4.7e-07
meas tran p_f000_do0_drv_470 find v(dout0_drv) at=4.7e-07
meas tran p_f000_do0_rx_470 find v(dout0_rx) at=4.7e-07
meas tran p_f000_do7_drv_480 find v(dout7_drv) at=4.8e-07
meas tran p_f000_do7_rx_480 find v(dout7_rx) at=4.8e-07
meas tran p_f000_do6_drv_480 find v(dout6_drv) at=4.8e-07
meas tran p_f000_do6_rx_480 find v(dout6_rx) at=4.8e-07
meas tran p_f000_do5_drv_480 find v(dout5_drv) at=4.8e-07
meas tran p_f000_do5_rx_480 find v(dout5_rx) at=4.8e-07
meas tran p_f000_do4_drv_480 find v(dout4_drv) at=4.8e-07
meas tran p_f000_do4_rx_480 find v(dout4_rx) at=4.8e-07
meas tran p_f000_do3_drv_480 find v(dout3_drv) at=4.8e-07
meas tran p_f000_do3_rx_480 find v(dout3_rx) at=4.8e-07
meas tran p_f000_do2_drv_480 find v(dout2_drv) at=4.8e-07
meas tran p_f000_do2_rx_480 find v(dout2_rx) at=4.8e-07
meas tran p_f000_do1_drv_480 find v(dout1_drv) at=4.8e-07
meas tran p_f000_do1_rx_480 find v(dout1_rx) at=4.8e-07
meas tran p_f000_do0_drv_480 find v(dout0_drv) at=4.8e-07
meas tran p_f000_do0_rx_480 find v(dout0_rx) at=4.8e-07
meas tran p_f001_cmp7_p0 find v(dcmpp) at=6.86964e-07
meas tran p_f001_cmp7_n0 find v(dcmpn) at=6.86964e-07
meas tran p_f001_cmp7_p5 find v(dcmpp) at=6.91964e-07
meas tran p_f001_cmp7_n5 find v(dcmpn) at=6.91964e-07
meas tran p_f001_cmp6_p0 find v(dcmpp) at=7.12324e-07
meas tran p_f001_cmp6_n0 find v(dcmpn) at=7.12324e-07
meas tran p_f001_cmp6_p5 find v(dcmpp) at=7.17324e-07
meas tran p_f001_cmp6_n5 find v(dcmpn) at=7.17324e-07
meas tran p_f001_cmp5_p0 find v(dcmpp) at=7.37867e-07
meas tran p_f001_cmp5_n0 find v(dcmpn) at=7.37867e-07
meas tran p_f001_cmp5_p5 find v(dcmpp) at=7.42867e-07
meas tran p_f001_cmp5_n5 find v(dcmpn) at=7.42867e-07
meas tran p_f001_cmp4_p0 find v(dcmpp) at=7.63334e-07
meas tran p_f001_cmp4_n0 find v(dcmpn) at=7.63334e-07
meas tran p_f001_cmp4_p5 find v(dcmpp) at=7.68334e-07
meas tran p_f001_cmp4_n5 find v(dcmpn) at=7.68334e-07
meas tran p_f001_cmp3_p0 find v(dcmpp) at=7.88696e-07
meas tran p_f001_cmp3_n0 find v(dcmpn) at=7.88696e-07
meas tran p_f001_cmp3_p5 find v(dcmpp) at=7.93696e-07
meas tran p_f001_cmp3_n5 find v(dcmpn) at=7.93696e-07
meas tran p_f001_cmp2_p0 find v(dcmpp) at=8.14134e-07
meas tran p_f001_cmp2_n0 find v(dcmpn) at=8.14134e-07
meas tran p_f001_cmp2_p5 find v(dcmpp) at=8.19134e-07
meas tran p_f001_cmp2_n5 find v(dcmpn) at=8.19134e-07
meas tran p_f001_cmp1_p0 find v(dcmpp) at=8.39679e-07
meas tran p_f001_cmp1_n0 find v(dcmpn) at=8.39679e-07
meas tran p_f001_cmp1_p5 find v(dcmpp) at=8.44679e-07
meas tran p_f001_cmp1_n5 find v(dcmpn) at=8.44679e-07
meas tran p_f001_cmp0_p0 find v(dcmpp) at=8.65055e-07
meas tran p_f001_cmp0_n0 find v(dcmpn) at=8.65055e-07
meas tran p_f001_cmp0_p5 find v(dcmpp) at=8.70055e-07
meas tran p_f001_cmp0_n5 find v(dcmpn) at=8.70055e-07
meas tran p_f001_dctrl7_p find v(dctrlp7) at=7.105e-07
meas tran p_f001_dctrl7_n find v(dctrln7) at=7.105e-07
meas tran p_f001_dctrl6_p find v(dctrlp6) at=7.35953e-07
meas tran p_f001_dctrl6_n find v(dctrln6) at=7.35953e-07
meas tran p_f001_dctrl5_p find v(dctrlp5) at=7.6142e-07
meas tran p_f001_dctrl5_n find v(dctrln5) at=7.6142e-07
meas tran p_f001_dctrl4_p find v(dctrlp4) at=7.86871e-07
meas tran p_f001_dctrl4_n find v(dctrln4) at=7.86871e-07
meas tran p_f001_dctrl3_p find v(dctrlp3) at=8.12309e-07
meas tran p_f001_dctrl3_n find v(dctrln3) at=8.12309e-07
meas tran p_f001_dctrl2_p find v(dctrlp2) at=8.37765e-07
meas tran p_f001_dctrl2_n find v(dctrln2) at=8.37765e-07
meas tran p_f001_dctrl1_p find v(dctrlp1) at=8.63231e-07
meas tran p_f001_dctrl1_n find v(dctrln1) at=8.63231e-07
meas tran p_f001_do7_drv_470 find v(dout7_drv) at=9.7e-07
meas tran p_f001_do7_rx_470 find v(dout7_rx) at=9.7e-07
meas tran p_f001_do6_drv_470 find v(dout6_drv) at=9.7e-07
meas tran p_f001_do6_rx_470 find v(dout6_rx) at=9.7e-07
meas tran p_f001_do5_drv_470 find v(dout5_drv) at=9.7e-07
meas tran p_f001_do5_rx_470 find v(dout5_rx) at=9.7e-07
meas tran p_f001_do4_drv_470 find v(dout4_drv) at=9.7e-07
meas tran p_f001_do4_rx_470 find v(dout4_rx) at=9.7e-07
meas tran p_f001_do3_drv_470 find v(dout3_drv) at=9.7e-07
meas tran p_f001_do3_rx_470 find v(dout3_rx) at=9.7e-07
meas tran p_f001_do2_drv_470 find v(dout2_drv) at=9.7e-07
meas tran p_f001_do2_rx_470 find v(dout2_rx) at=9.7e-07
meas tran p_f001_do1_drv_470 find v(dout1_drv) at=9.7e-07
meas tran p_f001_do1_rx_470 find v(dout1_rx) at=9.7e-07
meas tran p_f001_do0_drv_470 find v(dout0_drv) at=9.7e-07
meas tran p_f001_do0_rx_470 find v(dout0_rx) at=9.7e-07
meas tran p_f001_do7_drv_480 find v(dout7_drv) at=9.8e-07
meas tran p_f001_do7_rx_480 find v(dout7_rx) at=9.8e-07
meas tran p_f001_do6_drv_480 find v(dout6_drv) at=9.8e-07
meas tran p_f001_do6_rx_480 find v(dout6_rx) at=9.8e-07
meas tran p_f001_do5_drv_480 find v(dout5_drv) at=9.8e-07
meas tran p_f001_do5_rx_480 find v(dout5_rx) at=9.8e-07
meas tran p_f001_do4_drv_480 find v(dout4_drv) at=9.8e-07
meas tran p_f001_do4_rx_480 find v(dout4_rx) at=9.8e-07
meas tran p_f001_do3_drv_480 find v(dout3_drv) at=9.8e-07
meas tran p_f001_do3_rx_480 find v(dout3_rx) at=9.8e-07
meas tran p_f001_do2_drv_480 find v(dout2_drv) at=9.8e-07
meas tran p_f001_do2_rx_480 find v(dout2_rx) at=9.8e-07
meas tran p_f001_do1_drv_480 find v(dout1_drv) at=9.8e-07
meas tran p_f001_do1_rx_480 find v(dout1_rx) at=9.8e-07
meas tran p_f001_do0_drv_480 find v(dout0_drv) at=9.8e-07
meas tran p_f001_do0_rx_480 find v(dout0_rx) at=9.8e-07
meas tran p_f002_cmp7_p0 find v(dcmpp) at=1.186964e-06
meas tran p_f002_cmp7_n0 find v(dcmpn) at=1.186964e-06
meas tran p_f002_cmp7_p5 find v(dcmpp) at=1.191964e-06
meas tran p_f002_cmp7_n5 find v(dcmpn) at=1.191964e-06
meas tran p_f002_cmp6_p0 find v(dcmpp) at=1.212324e-06
meas tran p_f002_cmp6_n0 find v(dcmpn) at=1.212324e-06
meas tran p_f002_cmp6_p5 find v(dcmpp) at=1.217324e-06
meas tran p_f002_cmp6_n5 find v(dcmpn) at=1.217324e-06
meas tran p_f002_cmp5_p0 find v(dcmpp) at=1.237867e-06
meas tran p_f002_cmp5_n0 find v(dcmpn) at=1.237867e-06
meas tran p_f002_cmp5_p5 find v(dcmpp) at=1.242867e-06
meas tran p_f002_cmp5_n5 find v(dcmpn) at=1.242867e-06
meas tran p_f002_cmp4_p0 find v(dcmpp) at=1.263334e-06
meas tran p_f002_cmp4_n0 find v(dcmpn) at=1.263334e-06
meas tran p_f002_cmp4_p5 find v(dcmpp) at=1.268334e-06
meas tran p_f002_cmp4_n5 find v(dcmpn) at=1.268334e-06
meas tran p_f002_cmp3_p0 find v(dcmpp) at=1.288696e-06
meas tran p_f002_cmp3_n0 find v(dcmpn) at=1.288696e-06
meas tran p_f002_cmp3_p5 find v(dcmpp) at=1.293696e-06
meas tran p_f002_cmp3_n5 find v(dcmpn) at=1.293696e-06
meas tran p_f002_cmp2_p0 find v(dcmpp) at=1.314134e-06
meas tran p_f002_cmp2_n0 find v(dcmpn) at=1.314134e-06
meas tran p_f002_cmp2_p5 find v(dcmpp) at=1.319134e-06
meas tran p_f002_cmp2_n5 find v(dcmpn) at=1.319134e-06
meas tran p_f002_cmp1_p0 find v(dcmpp) at=1.339679e-06
meas tran p_f002_cmp1_n0 find v(dcmpn) at=1.339679e-06
meas tran p_f002_cmp1_p5 find v(dcmpp) at=1.344679e-06
meas tran p_f002_cmp1_n5 find v(dcmpn) at=1.344679e-06
meas tran p_f002_cmp0_p0 find v(dcmpp) at=1.365055e-06
meas tran p_f002_cmp0_n0 find v(dcmpn) at=1.365055e-06
meas tran p_f002_cmp0_p5 find v(dcmpp) at=1.370055e-06
meas tran p_f002_cmp0_n5 find v(dcmpn) at=1.370055e-06
meas tran p_f002_dctrl7_p find v(dctrlp7) at=1.2105e-06
meas tran p_f002_dctrl7_n find v(dctrln7) at=1.2105e-06
meas tran p_f002_dctrl6_p find v(dctrlp6) at=1.235953e-06
meas tran p_f002_dctrl6_n find v(dctrln6) at=1.235953e-06
meas tran p_f002_dctrl5_p find v(dctrlp5) at=1.26142e-06
meas tran p_f002_dctrl5_n find v(dctrln5) at=1.26142e-06
meas tran p_f002_dctrl4_p find v(dctrlp4) at=1.286871e-06
meas tran p_f002_dctrl4_n find v(dctrln4) at=1.286871e-06
meas tran p_f002_dctrl3_p find v(dctrlp3) at=1.312309e-06
meas tran p_f002_dctrl3_n find v(dctrln3) at=1.312309e-06
meas tran p_f002_dctrl2_p find v(dctrlp2) at=1.337765e-06
meas tran p_f002_dctrl2_n find v(dctrln2) at=1.337765e-06
meas tran p_f002_dctrl1_p find v(dctrlp1) at=1.363231e-06
meas tran p_f002_dctrl1_n find v(dctrln1) at=1.363231e-06
meas tran p_f002_do7_drv_470 find v(dout7_drv) at=1.47e-06
meas tran p_f002_do7_rx_470 find v(dout7_rx) at=1.47e-06
meas tran p_f002_do6_drv_470 find v(dout6_drv) at=1.47e-06
meas tran p_f002_do6_rx_470 find v(dout6_rx) at=1.47e-06
meas tran p_f002_do5_drv_470 find v(dout5_drv) at=1.47e-06
meas tran p_f002_do5_rx_470 find v(dout5_rx) at=1.47e-06
meas tran p_f002_do4_drv_470 find v(dout4_drv) at=1.47e-06
meas tran p_f002_do4_rx_470 find v(dout4_rx) at=1.47e-06
meas tran p_f002_do3_drv_470 find v(dout3_drv) at=1.47e-06
meas tran p_f002_do3_rx_470 find v(dout3_rx) at=1.47e-06
meas tran p_f002_do2_drv_470 find v(dout2_drv) at=1.47e-06
meas tran p_f002_do2_rx_470 find v(dout2_rx) at=1.47e-06
meas tran p_f002_do1_drv_470 find v(dout1_drv) at=1.47e-06
meas tran p_f002_do1_rx_470 find v(dout1_rx) at=1.47e-06
meas tran p_f002_do0_drv_470 find v(dout0_drv) at=1.47e-06
meas tran p_f002_do0_rx_470 find v(dout0_rx) at=1.47e-06
meas tran p_f002_do7_drv_480 find v(dout7_drv) at=1.48e-06
meas tran p_f002_do7_rx_480 find v(dout7_rx) at=1.48e-06
meas tran p_f002_do6_drv_480 find v(dout6_drv) at=1.48e-06
meas tran p_f002_do6_rx_480 find v(dout6_rx) at=1.48e-06
meas tran p_f002_do5_drv_480 find v(dout5_drv) at=1.48e-06
meas tran p_f002_do5_rx_480 find v(dout5_rx) at=1.48e-06
meas tran p_f002_do4_drv_480 find v(dout4_drv) at=1.48e-06
meas tran p_f002_do4_rx_480 find v(dout4_rx) at=1.48e-06
meas tran p_f002_do3_drv_480 find v(dout3_drv) at=1.48e-06
meas tran p_f002_do3_rx_480 find v(dout3_rx) at=1.48e-06
meas tran p_f002_do2_drv_480 find v(dout2_drv) at=1.48e-06
meas tran p_f002_do2_rx_480 find v(dout2_rx) at=1.48e-06
meas tran p_f002_do1_drv_480 find v(dout1_drv) at=1.48e-06
meas tran p_f002_do1_rx_480 find v(dout1_rx) at=1.48e-06
meas tran p_f002_do0_drv_480 find v(dout0_drv) at=1.48e-06
meas tran p_f002_do0_rx_480 find v(dout0_rx) at=1.48e-06
meas tran p_f003_cmp7_p0 find v(dcmpp) at=1.686964e-06
meas tran p_f003_cmp7_n0 find v(dcmpn) at=1.686964e-06
meas tran p_f003_cmp7_p5 find v(dcmpp) at=1.691964e-06
meas tran p_f003_cmp7_n5 find v(dcmpn) at=1.691964e-06
meas tran p_f003_cmp6_p0 find v(dcmpp) at=1.712324e-06
meas tran p_f003_cmp6_n0 find v(dcmpn) at=1.712324e-06
meas tran p_f003_cmp6_p5 find v(dcmpp) at=1.717324e-06
meas tran p_f003_cmp6_n5 find v(dcmpn) at=1.717324e-06
meas tran p_f003_cmp5_p0 find v(dcmpp) at=1.737867e-06
meas tran p_f003_cmp5_n0 find v(dcmpn) at=1.737867e-06
meas tran p_f003_cmp5_p5 find v(dcmpp) at=1.742867e-06
meas tran p_f003_cmp5_n5 find v(dcmpn) at=1.742867e-06
meas tran p_f003_cmp4_p0 find v(dcmpp) at=1.763334e-06
meas tran p_f003_cmp4_n0 find v(dcmpn) at=1.763334e-06
meas tran p_f003_cmp4_p5 find v(dcmpp) at=1.768334e-06
meas tran p_f003_cmp4_n5 find v(dcmpn) at=1.768334e-06
meas tran p_f003_cmp3_p0 find v(dcmpp) at=1.788696e-06
meas tran p_f003_cmp3_n0 find v(dcmpn) at=1.788696e-06
meas tran p_f003_cmp3_p5 find v(dcmpp) at=1.793696e-06
meas tran p_f003_cmp3_n5 find v(dcmpn) at=1.793696e-06
meas tran p_f003_cmp2_p0 find v(dcmpp) at=1.814134e-06
meas tran p_f003_cmp2_n0 find v(dcmpn) at=1.814134e-06
meas tran p_f003_cmp2_p5 find v(dcmpp) at=1.819134e-06
meas tran p_f003_cmp2_n5 find v(dcmpn) at=1.819134e-06
meas tran p_f003_cmp1_p0 find v(dcmpp) at=1.839679e-06
meas tran p_f003_cmp1_n0 find v(dcmpn) at=1.839679e-06
meas tran p_f003_cmp1_p5 find v(dcmpp) at=1.844679e-06
meas tran p_f003_cmp1_n5 find v(dcmpn) at=1.844679e-06
meas tran p_f003_cmp0_p0 find v(dcmpp) at=1.865055e-06
meas tran p_f003_cmp0_n0 find v(dcmpn) at=1.865055e-06
meas tran p_f003_cmp0_p5 find v(dcmpp) at=1.870055e-06
meas tran p_f003_cmp0_n5 find v(dcmpn) at=1.870055e-06
meas tran p_f003_dctrl7_p find v(dctrlp7) at=1.7105e-06
meas tran p_f003_dctrl7_n find v(dctrln7) at=1.7105e-06
meas tran p_f003_dctrl6_p find v(dctrlp6) at=1.735953e-06
meas tran p_f003_dctrl6_n find v(dctrln6) at=1.735953e-06
meas tran p_f003_dctrl5_p find v(dctrlp5) at=1.76142e-06
meas tran p_f003_dctrl5_n find v(dctrln5) at=1.76142e-06
meas tran p_f003_dctrl4_p find v(dctrlp4) at=1.786871e-06
meas tran p_f003_dctrl4_n find v(dctrln4) at=1.786871e-06
meas tran p_f003_dctrl3_p find v(dctrlp3) at=1.812309e-06
meas tran p_f003_dctrl3_n find v(dctrln3) at=1.812309e-06
meas tran p_f003_dctrl2_p find v(dctrlp2) at=1.837765e-06
meas tran p_f003_dctrl2_n find v(dctrln2) at=1.837765e-06
meas tran p_f003_dctrl1_p find v(dctrlp1) at=1.863231e-06
meas tran p_f003_dctrl1_n find v(dctrln1) at=1.863231e-06
meas tran p_f003_do7_drv_470 find v(dout7_drv) at=1.97e-06
meas tran p_f003_do7_rx_470 find v(dout7_rx) at=1.97e-06
meas tran p_f003_do6_drv_470 find v(dout6_drv) at=1.97e-06
meas tran p_f003_do6_rx_470 find v(dout6_rx) at=1.97e-06
meas tran p_f003_do5_drv_470 find v(dout5_drv) at=1.97e-06
meas tran p_f003_do5_rx_470 find v(dout5_rx) at=1.97e-06
meas tran p_f003_do4_drv_470 find v(dout4_drv) at=1.97e-06
meas tran p_f003_do4_rx_470 find v(dout4_rx) at=1.97e-06
meas tran p_f003_do3_drv_470 find v(dout3_drv) at=1.97e-06
meas tran p_f003_do3_rx_470 find v(dout3_rx) at=1.97e-06
meas tran p_f003_do2_drv_470 find v(dout2_drv) at=1.97e-06
meas tran p_f003_do2_rx_470 find v(dout2_rx) at=1.97e-06
meas tran p_f003_do1_drv_470 find v(dout1_drv) at=1.97e-06
meas tran p_f003_do1_rx_470 find v(dout1_rx) at=1.97e-06
meas tran p_f003_do0_drv_470 find v(dout0_drv) at=1.97e-06
meas tran p_f003_do0_rx_470 find v(dout0_rx) at=1.97e-06
meas tran p_f003_do7_drv_480 find v(dout7_drv) at=1.98e-06
meas tran p_f003_do7_rx_480 find v(dout7_rx) at=1.98e-06
meas tran p_f003_do6_drv_480 find v(dout6_drv) at=1.98e-06
meas tran p_f003_do6_rx_480 find v(dout6_rx) at=1.98e-06
meas tran p_f003_do5_drv_480 find v(dout5_drv) at=1.98e-06
meas tran p_f003_do5_rx_480 find v(dout5_rx) at=1.98e-06
meas tran p_f003_do4_drv_480 find v(dout4_drv) at=1.98e-06
meas tran p_f003_do4_rx_480 find v(dout4_rx) at=1.98e-06
meas tran p_f003_do3_drv_480 find v(dout3_drv) at=1.98e-06
meas tran p_f003_do3_rx_480 find v(dout3_rx) at=1.98e-06
meas tran p_f003_do2_drv_480 find v(dout2_drv) at=1.98e-06
meas tran p_f003_do2_rx_480 find v(dout2_rx) at=1.98e-06
meas tran p_f003_do1_drv_480 find v(dout1_drv) at=1.98e-06
meas tran p_f003_do1_rx_480 find v(dout1_rx) at=1.98e-06
meas tran p_f003_do0_drv_480 find v(dout0_drv) at=1.98e-06
meas tran p_f003_do0_rx_480 find v(dout0_rx) at=1.98e-06
meas tran p_f064_cmp7_p0 find v(dcmpp) at=3.2186964e-05
meas tran p_f064_cmp7_n0 find v(dcmpn) at=3.2186964e-05
meas tran p_f064_cmp7_p5 find v(dcmpp) at=3.2191964e-05
meas tran p_f064_cmp7_n5 find v(dcmpn) at=3.2191964e-05
meas tran p_f064_cmp6_p0 find v(dcmpp) at=3.2212324e-05
meas tran p_f064_cmp6_n0 find v(dcmpn) at=3.2212324e-05
meas tran p_f064_cmp6_p5 find v(dcmpp) at=3.2217324e-05
meas tran p_f064_cmp6_n5 find v(dcmpn) at=3.2217324e-05
meas tran p_f064_cmp5_p0 find v(dcmpp) at=3.2237867e-05
meas tran p_f064_cmp5_n0 find v(dcmpn) at=3.2237867e-05
meas tran p_f064_cmp5_p5 find v(dcmpp) at=3.2242867e-05
meas tran p_f064_cmp5_n5 find v(dcmpn) at=3.2242867e-05
meas tran p_f064_cmp4_p0 find v(dcmpp) at=3.2263334e-05
meas tran p_f064_cmp4_n0 find v(dcmpn) at=3.2263334e-05
meas tran p_f064_cmp4_p5 find v(dcmpp) at=3.2268334e-05
meas tran p_f064_cmp4_n5 find v(dcmpn) at=3.2268334e-05
meas tran p_f064_cmp3_p0 find v(dcmpp) at=3.2288696e-05
meas tran p_f064_cmp3_n0 find v(dcmpn) at=3.2288696e-05
meas tran p_f064_cmp3_p5 find v(dcmpp) at=3.2293696e-05
meas tran p_f064_cmp3_n5 find v(dcmpn) at=3.2293696e-05
meas tran p_f064_cmp2_p0 find v(dcmpp) at=3.2314134e-05
meas tran p_f064_cmp2_n0 find v(dcmpn) at=3.2314134e-05
meas tran p_f064_cmp2_p5 find v(dcmpp) at=3.2319134e-05
meas tran p_f064_cmp2_n5 find v(dcmpn) at=3.2319134e-05
meas tran p_f064_cmp1_p0 find v(dcmpp) at=3.2339679e-05
meas tran p_f064_cmp1_n0 find v(dcmpn) at=3.2339679e-05
meas tran p_f064_cmp1_p5 find v(dcmpp) at=3.2344679e-05
meas tran p_f064_cmp1_n5 find v(dcmpn) at=3.2344679e-05
meas tran p_f064_cmp0_p0 find v(dcmpp) at=3.2365055e-05
meas tran p_f064_cmp0_n0 find v(dcmpn) at=3.2365055e-05
meas tran p_f064_cmp0_p5 find v(dcmpp) at=3.2370055e-05
meas tran p_f064_cmp0_n5 find v(dcmpn) at=3.2370055e-05
meas tran p_f064_dctrl7_p find v(dctrlp7) at=3.22105e-05
meas tran p_f064_dctrl7_n find v(dctrln7) at=3.22105e-05
meas tran p_f064_dctrl6_p find v(dctrlp6) at=3.2235953e-05
meas tran p_f064_dctrl6_n find v(dctrln6) at=3.2235953e-05
meas tran p_f064_dctrl5_p find v(dctrlp5) at=3.226142e-05
meas tran p_f064_dctrl5_n find v(dctrln5) at=3.226142e-05
meas tran p_f064_dctrl4_p find v(dctrlp4) at=3.2286871e-05
meas tran p_f064_dctrl4_n find v(dctrln4) at=3.2286871e-05
meas tran p_f064_dctrl3_p find v(dctrlp3) at=3.2312309e-05
meas tran p_f064_dctrl3_n find v(dctrln3) at=3.2312309e-05
meas tran p_f064_dctrl2_p find v(dctrlp2) at=3.2337765e-05
meas tran p_f064_dctrl2_n find v(dctrln2) at=3.2337765e-05
meas tran p_f064_dctrl1_p find v(dctrlp1) at=3.2363231e-05
meas tran p_f064_dctrl1_n find v(dctrln1) at=3.2363231e-05
meas tran p_f064_do7_drv_470 find v(dout7_drv) at=3.247e-05
meas tran p_f064_do7_rx_470 find v(dout7_rx) at=3.247e-05
meas tran p_f064_do6_drv_470 find v(dout6_drv) at=3.247e-05
meas tran p_f064_do6_rx_470 find v(dout6_rx) at=3.247e-05
meas tran p_f064_do5_drv_470 find v(dout5_drv) at=3.247e-05
meas tran p_f064_do5_rx_470 find v(dout5_rx) at=3.247e-05
meas tran p_f064_do4_drv_470 find v(dout4_drv) at=3.247e-05
meas tran p_f064_do4_rx_470 find v(dout4_rx) at=3.247e-05
meas tran p_f064_do3_drv_470 find v(dout3_drv) at=3.247e-05
meas tran p_f064_do3_rx_470 find v(dout3_rx) at=3.247e-05
meas tran p_f064_do2_drv_470 find v(dout2_drv) at=3.247e-05
meas tran p_f064_do2_rx_470 find v(dout2_rx) at=3.247e-05
meas tran p_f064_do1_drv_470 find v(dout1_drv) at=3.247e-05
meas tran p_f064_do1_rx_470 find v(dout1_rx) at=3.247e-05
meas tran p_f064_do0_drv_470 find v(dout0_drv) at=3.247e-05
meas tran p_f064_do0_rx_470 find v(dout0_rx) at=3.247e-05
meas tran p_f064_do7_drv_480 find v(dout7_drv) at=3.248e-05
meas tran p_f064_do7_rx_480 find v(dout7_rx) at=3.248e-05
meas tran p_f064_do6_drv_480 find v(dout6_drv) at=3.248e-05
meas tran p_f064_do6_rx_480 find v(dout6_rx) at=3.248e-05
meas tran p_f064_do5_drv_480 find v(dout5_drv) at=3.248e-05
meas tran p_f064_do5_rx_480 find v(dout5_rx) at=3.248e-05
meas tran p_f064_do4_drv_480 find v(dout4_drv) at=3.248e-05
meas tran p_f064_do4_rx_480 find v(dout4_rx) at=3.248e-05
meas tran p_f064_do3_drv_480 find v(dout3_drv) at=3.248e-05
meas tran p_f064_do3_rx_480 find v(dout3_rx) at=3.248e-05
meas tran p_f064_do2_drv_480 find v(dout2_drv) at=3.248e-05
meas tran p_f064_do2_rx_480 find v(dout2_rx) at=3.248e-05
meas tran p_f064_do1_drv_480 find v(dout1_drv) at=3.248e-05
meas tran p_f064_do1_rx_480 find v(dout1_rx) at=3.248e-05
meas tran p_f064_do0_drv_480 find v(dout0_drv) at=3.248e-05
meas tran p_f064_do0_rx_480 find v(dout0_rx) at=3.248e-05
meas tran p_f065_cmp7_p0 find v(dcmpp) at=3.2686964e-05
meas tran p_f065_cmp7_n0 find v(dcmpn) at=3.2686964e-05
meas tran p_f065_cmp7_p5 find v(dcmpp) at=3.2691964e-05
meas tran p_f065_cmp7_n5 find v(dcmpn) at=3.2691964e-05
meas tran p_f065_cmp6_p0 find v(dcmpp) at=3.2712324e-05
meas tran p_f065_cmp6_n0 find v(dcmpn) at=3.2712324e-05
meas tran p_f065_cmp6_p5 find v(dcmpp) at=3.2717324e-05
meas tran p_f065_cmp6_n5 find v(dcmpn) at=3.2717324e-05
meas tran p_f065_cmp5_p0 find v(dcmpp) at=3.2737867e-05
meas tran p_f065_cmp5_n0 find v(dcmpn) at=3.2737867e-05
meas tran p_f065_cmp5_p5 find v(dcmpp) at=3.2742867e-05
meas tran p_f065_cmp5_n5 find v(dcmpn) at=3.2742867e-05
meas tran p_f065_cmp4_p0 find v(dcmpp) at=3.2763334e-05
meas tran p_f065_cmp4_n0 find v(dcmpn) at=3.2763334e-05
meas tran p_f065_cmp4_p5 find v(dcmpp) at=3.2768334e-05
meas tran p_f065_cmp4_n5 find v(dcmpn) at=3.2768334e-05
meas tran p_f065_cmp3_p0 find v(dcmpp) at=3.2788696e-05
meas tran p_f065_cmp3_n0 find v(dcmpn) at=3.2788696e-05
meas tran p_f065_cmp3_p5 find v(dcmpp) at=3.2793696e-05
meas tran p_f065_cmp3_n5 find v(dcmpn) at=3.2793696e-05
meas tran p_f065_cmp2_p0 find v(dcmpp) at=3.2814134e-05
meas tran p_f065_cmp2_n0 find v(dcmpn) at=3.2814134e-05
meas tran p_f065_cmp2_p5 find v(dcmpp) at=3.2819134e-05
meas tran p_f065_cmp2_n5 find v(dcmpn) at=3.2819134e-05
meas tran p_f065_cmp1_p0 find v(dcmpp) at=3.2839679e-05
meas tran p_f065_cmp1_n0 find v(dcmpn) at=3.2839679e-05
meas tran p_f065_cmp1_p5 find v(dcmpp) at=3.2844679e-05
meas tran p_f065_cmp1_n5 find v(dcmpn) at=3.2844679e-05
meas tran p_f065_cmp0_p0 find v(dcmpp) at=3.2865055e-05
meas tran p_f065_cmp0_n0 find v(dcmpn) at=3.2865055e-05
meas tran p_f065_cmp0_p5 find v(dcmpp) at=3.2870055e-05
meas tran p_f065_cmp0_n5 find v(dcmpn) at=3.2870055e-05
meas tran p_f065_dctrl7_p find v(dctrlp7) at=3.27105e-05
meas tran p_f065_dctrl7_n find v(dctrln7) at=3.27105e-05
meas tran p_f065_dctrl6_p find v(dctrlp6) at=3.2735953e-05
meas tran p_f065_dctrl6_n find v(dctrln6) at=3.2735953e-05
meas tran p_f065_dctrl5_p find v(dctrlp5) at=3.276142e-05
meas tran p_f065_dctrl5_n find v(dctrln5) at=3.276142e-05
meas tran p_f065_dctrl4_p find v(dctrlp4) at=3.2786871e-05
meas tran p_f065_dctrl4_n find v(dctrln4) at=3.2786871e-05
meas tran p_f065_dctrl3_p find v(dctrlp3) at=3.2812309e-05
meas tran p_f065_dctrl3_n find v(dctrln3) at=3.2812309e-05
meas tran p_f065_dctrl2_p find v(dctrlp2) at=3.2837765e-05
meas tran p_f065_dctrl2_n find v(dctrln2) at=3.2837765e-05
meas tran p_f065_dctrl1_p find v(dctrlp1) at=3.2863231e-05
meas tran p_f065_dctrl1_n find v(dctrln1) at=3.2863231e-05
meas tran p_f065_do7_drv_470 find v(dout7_drv) at=3.297e-05
meas tran p_f065_do7_rx_470 find v(dout7_rx) at=3.297e-05
meas tran p_f065_do6_drv_470 find v(dout6_drv) at=3.297e-05
meas tran p_f065_do6_rx_470 find v(dout6_rx) at=3.297e-05
meas tran p_f065_do5_drv_470 find v(dout5_drv) at=3.297e-05
meas tran p_f065_do5_rx_470 find v(dout5_rx) at=3.297e-05
meas tran p_f065_do4_drv_470 find v(dout4_drv) at=3.297e-05
meas tran p_f065_do4_rx_470 find v(dout4_rx) at=3.297e-05
meas tran p_f065_do3_drv_470 find v(dout3_drv) at=3.297e-05
meas tran p_f065_do3_rx_470 find v(dout3_rx) at=3.297e-05
meas tran p_f065_do2_drv_470 find v(dout2_drv) at=3.297e-05
meas tran p_f065_do2_rx_470 find v(dout2_rx) at=3.297e-05
meas tran p_f065_do1_drv_470 find v(dout1_drv) at=3.297e-05
meas tran p_f065_do1_rx_470 find v(dout1_rx) at=3.297e-05
meas tran p_f065_do0_drv_470 find v(dout0_drv) at=3.297e-05
meas tran p_f065_do0_rx_470 find v(dout0_rx) at=3.297e-05
meas tran p_f065_do7_drv_480 find v(dout7_drv) at=3.298e-05
meas tran p_f065_do7_rx_480 find v(dout7_rx) at=3.298e-05
meas tran p_f065_do6_drv_480 find v(dout6_drv) at=3.298e-05
meas tran p_f065_do6_rx_480 find v(dout6_rx) at=3.298e-05
meas tran p_f065_do5_drv_480 find v(dout5_drv) at=3.298e-05
meas tran p_f065_do5_rx_480 find v(dout5_rx) at=3.298e-05
meas tran p_f065_do4_drv_480 find v(dout4_drv) at=3.298e-05
meas tran p_f065_do4_rx_480 find v(dout4_rx) at=3.298e-05
meas tran p_f065_do3_drv_480 find v(dout3_drv) at=3.298e-05
meas tran p_f065_do3_rx_480 find v(dout3_rx) at=3.298e-05
meas tran p_f065_do2_drv_480 find v(dout2_drv) at=3.298e-05
meas tran p_f065_do2_rx_480 find v(dout2_rx) at=3.298e-05
meas tran p_f065_do1_drv_480 find v(dout1_drv) at=3.298e-05
meas tran p_f065_do1_rx_480 find v(dout1_rx) at=3.298e-05
meas tran p_f065_do0_drv_480 find v(dout0_drv) at=3.298e-05
meas tran p_f065_do0_rx_480 find v(dout0_rx) at=3.298e-05
meas tran p_f066_cmp7_p0 find v(dcmpp) at=3.3186964e-05
meas tran p_f066_cmp7_n0 find v(dcmpn) at=3.3186964e-05
meas tran p_f066_cmp7_p5 find v(dcmpp) at=3.3191964e-05
meas tran p_f066_cmp7_n5 find v(dcmpn) at=3.3191964e-05
meas tran p_f066_cmp6_p0 find v(dcmpp) at=3.3212324e-05
meas tran p_f066_cmp6_n0 find v(dcmpn) at=3.3212324e-05
meas tran p_f066_cmp6_p5 find v(dcmpp) at=3.3217324e-05
meas tran p_f066_cmp6_n5 find v(dcmpn) at=3.3217324e-05
meas tran p_f066_cmp5_p0 find v(dcmpp) at=3.3237867e-05
meas tran p_f066_cmp5_n0 find v(dcmpn) at=3.3237867e-05
meas tran p_f066_cmp5_p5 find v(dcmpp) at=3.3242867e-05
meas tran p_f066_cmp5_n5 find v(dcmpn) at=3.3242867e-05
meas tran p_f066_cmp4_p0 find v(dcmpp) at=3.3263334e-05
meas tran p_f066_cmp4_n0 find v(dcmpn) at=3.3263334e-05
meas tran p_f066_cmp4_p5 find v(dcmpp) at=3.3268334e-05
meas tran p_f066_cmp4_n5 find v(dcmpn) at=3.3268334e-05
meas tran p_f066_cmp3_p0 find v(dcmpp) at=3.3288696e-05
meas tran p_f066_cmp3_n0 find v(dcmpn) at=3.3288696e-05
meas tran p_f066_cmp3_p5 find v(dcmpp) at=3.3293696e-05
meas tran p_f066_cmp3_n5 find v(dcmpn) at=3.3293696e-05
meas tran p_f066_cmp2_p0 find v(dcmpp) at=3.3314134e-05
meas tran p_f066_cmp2_n0 find v(dcmpn) at=3.3314134e-05
meas tran p_f066_cmp2_p5 find v(dcmpp) at=3.3319134e-05
meas tran p_f066_cmp2_n5 find v(dcmpn) at=3.3319134e-05
meas tran p_f066_cmp1_p0 find v(dcmpp) at=3.3339679e-05
meas tran p_f066_cmp1_n0 find v(dcmpn) at=3.3339679e-05
meas tran p_f066_cmp1_p5 find v(dcmpp) at=3.3344679e-05
meas tran p_f066_cmp1_n5 find v(dcmpn) at=3.3344679e-05
meas tran p_f066_cmp0_p0 find v(dcmpp) at=3.3365055e-05
meas tran p_f066_cmp0_n0 find v(dcmpn) at=3.3365055e-05
meas tran p_f066_cmp0_p5 find v(dcmpp) at=3.3370055e-05
meas tran p_f066_cmp0_n5 find v(dcmpn) at=3.3370055e-05
meas tran p_f066_dctrl7_p find v(dctrlp7) at=3.32105e-05
meas tran p_f066_dctrl7_n find v(dctrln7) at=3.32105e-05
meas tran p_f066_dctrl6_p find v(dctrlp6) at=3.3235953e-05
meas tran p_f066_dctrl6_n find v(dctrln6) at=3.3235953e-05
meas tran p_f066_dctrl5_p find v(dctrlp5) at=3.326142e-05
meas tran p_f066_dctrl5_n find v(dctrln5) at=3.326142e-05
meas tran p_f066_dctrl4_p find v(dctrlp4) at=3.3286871e-05
meas tran p_f066_dctrl4_n find v(dctrln4) at=3.3286871e-05
meas tran p_f066_dctrl3_p find v(dctrlp3) at=3.3312309e-05
meas tran p_f066_dctrl3_n find v(dctrln3) at=3.3312309e-05
meas tran p_f066_dctrl2_p find v(dctrlp2) at=3.3337765e-05
meas tran p_f066_dctrl2_n find v(dctrln2) at=3.3337765e-05
meas tran p_f066_dctrl1_p find v(dctrlp1) at=3.3363231e-05
meas tran p_f066_dctrl1_n find v(dctrln1) at=3.3363231e-05
meas tran p_f066_do7_drv_470 find v(dout7_drv) at=3.347e-05
meas tran p_f066_do7_rx_470 find v(dout7_rx) at=3.347e-05
meas tran p_f066_do6_drv_470 find v(dout6_drv) at=3.347e-05
meas tran p_f066_do6_rx_470 find v(dout6_rx) at=3.347e-05
meas tran p_f066_do5_drv_470 find v(dout5_drv) at=3.347e-05
meas tran p_f066_do5_rx_470 find v(dout5_rx) at=3.347e-05
meas tran p_f066_do4_drv_470 find v(dout4_drv) at=3.347e-05
meas tran p_f066_do4_rx_470 find v(dout4_rx) at=3.347e-05
meas tran p_f066_do3_drv_470 find v(dout3_drv) at=3.347e-05
meas tran p_f066_do3_rx_470 find v(dout3_rx) at=3.347e-05
meas tran p_f066_do2_drv_470 find v(dout2_drv) at=3.347e-05
meas tran p_f066_do2_rx_470 find v(dout2_rx) at=3.347e-05
meas tran p_f066_do1_drv_470 find v(dout1_drv) at=3.347e-05
meas tran p_f066_do1_rx_470 find v(dout1_rx) at=3.347e-05
meas tran p_f066_do0_drv_470 find v(dout0_drv) at=3.347e-05
meas tran p_f066_do0_rx_470 find v(dout0_rx) at=3.347e-05
meas tran p_f066_do7_drv_480 find v(dout7_drv) at=3.348e-05
meas tran p_f066_do7_rx_480 find v(dout7_rx) at=3.348e-05
meas tran p_f066_do6_drv_480 find v(dout6_drv) at=3.348e-05
meas tran p_f066_do6_rx_480 find v(dout6_rx) at=3.348e-05
meas tran p_f066_do5_drv_480 find v(dout5_drv) at=3.348e-05
meas tran p_f066_do5_rx_480 find v(dout5_rx) at=3.348e-05
meas tran p_f066_do4_drv_480 find v(dout4_drv) at=3.348e-05
meas tran p_f066_do4_rx_480 find v(dout4_rx) at=3.348e-05
meas tran p_f066_do3_drv_480 find v(dout3_drv) at=3.348e-05
meas tran p_f066_do3_rx_480 find v(dout3_rx) at=3.348e-05
meas tran p_f066_do2_drv_480 find v(dout2_drv) at=3.348e-05
meas tran p_f066_do2_rx_480 find v(dout2_rx) at=3.348e-05
meas tran p_f066_do1_drv_480 find v(dout1_drv) at=3.348e-05
meas tran p_f066_do1_rx_480 find v(dout1_rx) at=3.348e-05
meas tran p_f066_do0_drv_480 find v(dout0_drv) at=3.348e-05
meas tran p_f066_do0_rx_480 find v(dout0_rx) at=3.348e-05
meas tran p_f067_cmp7_p0 find v(dcmpp) at=3.3686964e-05
meas tran p_f067_cmp7_n0 find v(dcmpn) at=3.3686964e-05
meas tran p_f067_cmp7_p5 find v(dcmpp) at=3.3691964e-05
meas tran p_f067_cmp7_n5 find v(dcmpn) at=3.3691964e-05
meas tran p_f067_cmp6_p0 find v(dcmpp) at=3.3712324e-05
meas tran p_f067_cmp6_n0 find v(dcmpn) at=3.3712324e-05
meas tran p_f067_cmp6_p5 find v(dcmpp) at=3.3717324e-05
meas tran p_f067_cmp6_n5 find v(dcmpn) at=3.3717324e-05
meas tran p_f067_cmp5_p0 find v(dcmpp) at=3.3737867e-05
meas tran p_f067_cmp5_n0 find v(dcmpn) at=3.3737867e-05
meas tran p_f067_cmp5_p5 find v(dcmpp) at=3.3742867e-05
meas tran p_f067_cmp5_n5 find v(dcmpn) at=3.3742867e-05
meas tran p_f067_cmp4_p0 find v(dcmpp) at=3.3763334e-05
meas tran p_f067_cmp4_n0 find v(dcmpn) at=3.3763334e-05
meas tran p_f067_cmp4_p5 find v(dcmpp) at=3.3768334e-05
meas tran p_f067_cmp4_n5 find v(dcmpn) at=3.3768334e-05
meas tran p_f067_cmp3_p0 find v(dcmpp) at=3.3788696e-05
meas tran p_f067_cmp3_n0 find v(dcmpn) at=3.3788696e-05
meas tran p_f067_cmp3_p5 find v(dcmpp) at=3.3793696e-05
meas tran p_f067_cmp3_n5 find v(dcmpn) at=3.3793696e-05
meas tran p_f067_cmp2_p0 find v(dcmpp) at=3.3814134e-05
meas tran p_f067_cmp2_n0 find v(dcmpn) at=3.3814134e-05
meas tran p_f067_cmp2_p5 find v(dcmpp) at=3.3819134e-05
meas tran p_f067_cmp2_n5 find v(dcmpn) at=3.3819134e-05
meas tran p_f067_cmp1_p0 find v(dcmpp) at=3.3839679e-05
meas tran p_f067_cmp1_n0 find v(dcmpn) at=3.3839679e-05
meas tran p_f067_cmp1_p5 find v(dcmpp) at=3.3844679e-05
meas tran p_f067_cmp1_n5 find v(dcmpn) at=3.3844679e-05
meas tran p_f067_cmp0_p0 find v(dcmpp) at=3.3865055e-05
meas tran p_f067_cmp0_n0 find v(dcmpn) at=3.3865055e-05
meas tran p_f067_cmp0_p5 find v(dcmpp) at=3.3870055e-05
meas tran p_f067_cmp0_n5 find v(dcmpn) at=3.3870055e-05
meas tran p_f067_dctrl7_p find v(dctrlp7) at=3.37105e-05
meas tran p_f067_dctrl7_n find v(dctrln7) at=3.37105e-05
meas tran p_f067_dctrl6_p find v(dctrlp6) at=3.3735953e-05
meas tran p_f067_dctrl6_n find v(dctrln6) at=3.3735953e-05
meas tran p_f067_dctrl5_p find v(dctrlp5) at=3.376142e-05
meas tran p_f067_dctrl5_n find v(dctrln5) at=3.376142e-05
meas tran p_f067_dctrl4_p find v(dctrlp4) at=3.3786871e-05
meas tran p_f067_dctrl4_n find v(dctrln4) at=3.3786871e-05
meas tran p_f067_dctrl3_p find v(dctrlp3) at=3.3812309e-05
meas tran p_f067_dctrl3_n find v(dctrln3) at=3.3812309e-05
meas tran p_f067_dctrl2_p find v(dctrlp2) at=3.3837765e-05
meas tran p_f067_dctrl2_n find v(dctrln2) at=3.3837765e-05
meas tran p_f067_dctrl1_p find v(dctrlp1) at=3.3863231e-05
meas tran p_f067_dctrl1_n find v(dctrln1) at=3.3863231e-05
meas tran p_f067_do7_drv_470 find v(dout7_drv) at=3.397e-05
meas tran p_f067_do7_rx_470 find v(dout7_rx) at=3.397e-05
meas tran p_f067_do6_drv_470 find v(dout6_drv) at=3.397e-05
meas tran p_f067_do6_rx_470 find v(dout6_rx) at=3.397e-05
meas tran p_f067_do5_drv_470 find v(dout5_drv) at=3.397e-05
meas tran p_f067_do5_rx_470 find v(dout5_rx) at=3.397e-05
meas tran p_f067_do4_drv_470 find v(dout4_drv) at=3.397e-05
meas tran p_f067_do4_rx_470 find v(dout4_rx) at=3.397e-05
meas tran p_f067_do3_drv_470 find v(dout3_drv) at=3.397e-05
meas tran p_f067_do3_rx_470 find v(dout3_rx) at=3.397e-05
meas tran p_f067_do2_drv_470 find v(dout2_drv) at=3.397e-05
meas tran p_f067_do2_rx_470 find v(dout2_rx) at=3.397e-05
meas tran p_f067_do1_drv_470 find v(dout1_drv) at=3.397e-05
meas tran p_f067_do1_rx_470 find v(dout1_rx) at=3.397e-05
meas tran p_f067_do0_drv_470 find v(dout0_drv) at=3.397e-05
meas tran p_f067_do0_rx_470 find v(dout0_rx) at=3.397e-05
meas tran p_f067_do7_drv_480 find v(dout7_drv) at=3.398e-05
meas tran p_f067_do7_rx_480 find v(dout7_rx) at=3.398e-05
meas tran p_f067_do6_drv_480 find v(dout6_drv) at=3.398e-05
meas tran p_f067_do6_rx_480 find v(dout6_rx) at=3.398e-05
meas tran p_f067_do5_drv_480 find v(dout5_drv) at=3.398e-05
meas tran p_f067_do5_rx_480 find v(dout5_rx) at=3.398e-05
meas tran p_f067_do4_drv_480 find v(dout4_drv) at=3.398e-05
meas tran p_f067_do4_rx_480 find v(dout4_rx) at=3.398e-05
meas tran p_f067_do3_drv_480 find v(dout3_drv) at=3.398e-05
meas tran p_f067_do3_rx_480 find v(dout3_rx) at=3.398e-05
meas tran p_f067_do2_drv_480 find v(dout2_drv) at=3.398e-05
meas tran p_f067_do2_rx_480 find v(dout2_rx) at=3.398e-05
meas tran p_f067_do1_drv_480 find v(dout1_drv) at=3.398e-05
meas tran p_f067_do1_rx_480 find v(dout1_rx) at=3.398e-05
meas tran p_f067_do0_drv_480 find v(dout0_drv) at=3.398e-05
meas tran p_f067_do0_rx_480 find v(dout0_rx) at=3.398e-05
quit
.endc
.end
