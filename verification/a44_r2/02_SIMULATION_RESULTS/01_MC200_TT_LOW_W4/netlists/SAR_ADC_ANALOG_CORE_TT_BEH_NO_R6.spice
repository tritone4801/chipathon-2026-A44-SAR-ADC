* Campaign-local analog-core composition for timed behavioral SAR control.
* Production sources are not edited. The controller is connected in the testbench.
.subckt SAR_ADC_ANALOG_CORE_TT_BEH_NO_R6
+ VDD GND VREFP VREFN VINP VINN CLKS CMPCK
+ DCTRLP7 DCTRLP6 DCTRLP5 DCTRLP4 DCTRLP3 DCTRLP2 DCTRLP1
+ DCTRLN7 DCTRLN6 DCTRLN5 DCTRLN4 DCTRLN3 DCTRLN2 DCTRLN1
+ DCMPP DCMPN VRESP VRESN

XCDACP VINP CLKS VRESP
+ DCTRLP7 DCTRLP6 DCTRLP5 DCTRLP4 DCTRLP3 DCTRLP2 DCTRLP1
+ VREFP VDD GND VREFN CDAC
XCDACN VINN CLKS VRESN
+ DCTRLN7 DCTRLN6 DCTRLN5 DCTRLN4 DCTRLN3 DCTRLN2 DCTRLN1
+ VREFP VDD GND VREFN CDAC
XCMP CMPCK DCMPP VRESP DCMPN VRESN VDD GND Comparator_StrongARM

.ends SAR_ADC_ANALOG_CORE_TT_BEH_NO_R6
