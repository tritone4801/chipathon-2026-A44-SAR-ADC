** sch_path: /foss/designs/A44_SAR_ADC_CURRENT_CACE_REPRODUCIBLE_20260728_R2/02_SIMULATION_RESULTS/06_RUN_OUTPUTS/PREFLIGHT_20260728T190238Z/cace_runs/RUN_2026-07-28_21-02-39/parameters/A44_PACKAGE_CACE_PREFLIGHT/run_0/tb_package_preflight.sch
**.subckt tb_package_preflight
**** begin user architecture code

* CACE executable-path preflight. Claim-bearing simulations are dispatched by
* the package-owned Python runners after this CACE parameter passes.
V1 out 0 1.25
R1 out 0 1k
.tran 0.1n 1n
.control
run
set wr_singlescale
setplot const
let row_index = unitvec(1)
let row_index[0] = 0
let final_v = unitvec(1)
let final_v[0] = 1.25
setscale row_index
wrdata /foss/designs/A44_SAR_ADC_CURRENT_CACE_REPRODUCIBLE_20260728_R2/02_SIMULATION_RESULTS/06_RUN_OUTPUTS/PREFLIGHT_20260728T190238Z/cace_runs/RUN_2026-07-28_21-02-39/parameters/A44_PACKAGE_CACE_PREFLIGHT/run_0/tb_package_preflight_0.data final_v
quit
.endc

**** end user architecture code
**.ends
.end
