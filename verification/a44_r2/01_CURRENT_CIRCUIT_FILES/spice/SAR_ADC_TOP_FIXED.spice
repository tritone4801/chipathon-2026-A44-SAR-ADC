* Mechanically derived from work/SAR_ADC_TOP_FIXED.sch.
* Repair method: LOCAL_COPY_REPAIR_SUBCKT_BINDING.
* Frozen external interface: VDD GND VREFP VREFN VINP VINN CLKS DOUT[7:0].
.subckt SAR_ADC_TOP_FIXED VDD GND VREFP VREFN VINP VINN CLKS DOUT[7] DOUT[6] DOUT[5] DOUT[4] DOUT[3] DOUT[2] DOUT[1] DOUT[0]

XCDACP VINP CLKS VRESP DCTRLP_7 DCTRLP_6 DCTRLP_5 DCTRLP_4 DCTRLP_3 DCTRLP_2 DCTRLP_1 VREFP VDD GND VREFN CDAC
XCDACN VINN CLKS VRESN DCTRLN_7 DCTRLN_6 DCTRLN_5 DCTRLN_4 DCTRLN_3 DCTRLN_2 DCTRLN_1 VREFP VDD GND VREFN CDAC
XCMP CMPCK DCMPP VRESP DCMPN VRESN VDD GND Comparator_StrongARM
XLOGIC CLKS DCMPP DCMPN CMPCK
+ DCTRLP_7 DCTRLP_6 DCTRLP_5 DCTRLP_4 DCTRLP_3 DCTRLP_2 DCTRLP_1
+ DCTRLN_7 DCTRLN_6 DCTRLN_5 DCTRLN_4 DCTRLN_3 DCTRLN_2 DCTRLN_1
+ DOUT[7] DOUT[6] DOUT[5] DOUT[4] DOUT[3] DOUT[2] DOUT[1] DOUT[0]
+ VDD GND SAR_LOGIC_ACTUAL_RTL

.ends SAR_ADC_TOP_FIXED
