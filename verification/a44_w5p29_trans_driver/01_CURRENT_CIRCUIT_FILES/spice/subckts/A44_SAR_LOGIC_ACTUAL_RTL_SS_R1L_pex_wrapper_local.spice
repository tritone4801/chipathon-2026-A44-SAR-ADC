* A44 W5P29 active header-aware bracket wrapper; lineage=R1L_CANDIDATE.
* Xcore positional nodes were generated from the selected R1L extracted PEX header.
* The prior generic PEX/wrapper pair remains unchanged as historical evidence.
.include "/foss/designs/DESIGN_FILES/CURRENT/A44_W5P29_UNIT_TRANS_DRIVER/01_CIRCUIT_FILES/A44_SAR_LOGIC_ACTUAL_RTL_SS_R1L_pex_core.spice"
.subckt A44_SAR_LOGIC_ACTUAL_RTL CLKS DCMPP DCMPN CMPCK DCTRLP[7] DCTRLP[6] DCTRLP[5] DCTRLP[4]
+ DCTRLP[3] DCTRLP[2] DCTRLP[1] DCTRLN[7] DCTRLN[6] DCTRLN[5] DCTRLN[4] DCTRLN[3]
+ DCTRLN[2] DCTRLN[1] DOUT[7] DOUT[6] DOUT[5] DOUT[4] DOUT[3] DOUT[2]
+ DOUT[1] DOUT[0] VDD GND
Xcore CLKS CMPCK DCMPN DCMPP DOUT[0] DOUT[1] DOUT[2] DOUT[3]
+ DOUT[4] DOUT[5] DOUT[6] DOUT[7] DCTRLN[1] DCTRLN[2] DCTRLN[3] DCTRLN[4]
+ DCTRLN[5] DCTRLN[6] DCTRLN[7] DCTRLP[1] DCTRLP[2] DCTRLP[3] DCTRLP[4] DCTRLP[5]
+ DCTRLP[6] DCTRLP[7] VDD GND SAR_LOGIC_ACTUAL_RTL_SS_R1L_PEX_CORE
.ends A44_SAR_LOGIC_ACTUAL_RTL
