* A44 diagnostic reduction of the frozen official extracted analog pad.
* Primitive resistors <= 0.1 ohm contracted; all nonlinear devices retained.
* Source SHA256: f412508f0efc3e81ad22bf9eeb0310650be4af457d9d921af0686a49e6de0a0c
* DIAGNOSTIC ONLY until port-equivalence checks pass.
.subckt gf180mcu_fd_io__asig_5p0_extracted  DVSS DVDD VSS VDD PAD ASIG5V
RRED1 ASIG5V:101 X46/X26/D0:neg 0.445714
RRED2 ASIG5V:108 X46/X27/D0:neg 0.445714
RRED3 ASIG5V:11 X46/X26/D0:neg 0.445714
RRED4 ASIG5V:110 X46/X27/D0:neg 0.445714
RRED5 ASIG5V:112 X46/X27/D0:neg 0.445714
RRED6 ASIG5V:114 X46/X27/D0:neg 0.445714
RRED7 ASIG5V:116 X46/X27/D0:neg 0.445714
RRED8 ASIG5V:118 X46/X27/D0:neg 0.445714
RRED9 ASIG5V:120 X46/X27/D0:neg 0.445714
RRED10 ASIG5V:122 X46/X27/D0:neg 0.445714
RRED11 ASIG5V:124 X46/X27/D0:neg 0.445714
RRED12 ASIG5V:1257 ASIG5V:1258 0.225
RRED13 ASIG5V:1257 ASIG5V:2941 9.21806
RRED14 ASIG5V:1259 ASIG5V:1260 0.225
RRED15 ASIG5V:1259 ASIG5V:2943 0.283668
RRED16 ASIG5V:126 X46/X27/D0:neg 0.445714
RRED17 ASIG5V:1261 ASIG5V:1262 0.225
RRED18 ASIG5V:1261 ASIG5V:2945 0.283668
RRED19 ASIG5V:1263 ASIG5V:1264 0.225
RRED20 ASIG5V:1263 ASIG5V:2947 0.283668
RRED21 ASIG5V:1265 ASIG5V:1266 0.225
RRED22 ASIG5V:1265 ASIG5V:2949 0.645527
RRED23 ASIG5V:1267 ASIG5V:1268 0.225
RRED24 ASIG5V:1267 ASIG5V:2951 0.283668
RRED25 ASIG5V:1269 ASIG5V:1270 0.225
RRED26 ASIG5V:1269 ASIG5V:2953 0.283668
RRED27 ASIG5V:1271 ASIG5V:1272 0.225
RRED28 ASIG5V:1271 ASIG5V:2955 0.283668
RRED29 ASIG5V:1271 ASIG5V:2957 0.361051
RRED30 ASIG5V:1273 ASIG5V:1274 0.225
RRED31 ASIG5V:1273 ASIG5V:2959 9.39452
RRED32 ASIG5V:1275 ASIG5V:1276 0.225
RRED33 ASIG5V:1275 ASIG5V:2961 0.285008
RRED34 ASIG5V:1277 ASIG5V:1278 0.225
RRED35 ASIG5V:1277 ASIG5V:2963 0.285008
RRED36 ASIG5V:1279 ASIG5V:1280 0.225
RRED37 ASIG5V:1279 ASIG5V:2965 0.285008
RRED38 ASIG5V:128 X46/X27/D0:neg 0.445714
RRED39 ASIG5V:1281 ASIG5V:1282 0.225
RRED40 ASIG5V:1281 ASIG5V:2967 0.648575
RRED41 ASIG5V:1283 ASIG5V:1284 0.225
RRED42 ASIG5V:1283 ASIG5V:2969 0.285008
RRED43 ASIG5V:1285 ASIG5V:1286 0.225
RRED44 ASIG5V:1285 ASIG5V:2971 0.285008
RRED45 ASIG5V:1287 ASIG5V:1288 0.225
RRED46 ASIG5V:1287 ASIG5V:2973 0.285008
RRED47 ASIG5V:1287 ASIG5V:2975 0.362756
RRED48 ASIG5V:1289 ASIG5V:1290 0.225
RRED49 ASIG5V:1289 ASIG5V:2977 9.11067
RRED50 ASIG5V:1291 ASIG5V:1292 0.225
RRED51 ASIG5V:1291 ASIG5V:2979 0.286436
RRED52 ASIG5V:1293 ASIG5V:1294 0.225
RRED53 ASIG5V:1293 ASIG5V:2981 0.286436
RRED54 ASIG5V:1295 ASIG5V:1296 0.225
RRED55 ASIG5V:1295 ASIG5V:2983 0.286436
RRED56 ASIG5V:1297 ASIG5V:1298 0.225
RRED57 ASIG5V:1297 ASIG5V:2985 0.651825
RRED58 ASIG5V:1299 ASIG5V:1300 0.225
RRED59 ASIG5V:1299 ASIG5V:2987 0.286436
RRED60 ASIG5V:13 X46/X26/D0:neg 0.445714
RRED61 ASIG5V:130 X46/X27/D0:neg 0.445714
RRED62 ASIG5V:1301 ASIG5V:1302 0.225
RRED63 ASIG5V:1301 ASIG5V:2989 0.286436
RRED64 ASIG5V:1303 ASIG5V:1304 0.225
RRED65 ASIG5V:1303 ASIG5V:2991 0.286436
RRED66 ASIG5V:1303 ASIG5V:2993 0.364573
RRED67 ASIG5V:1305 ASIG5V:1306 0.225
RRED68 ASIG5V:1305 ASIG5V:2995 8.96285
RRED69 ASIG5V:1307 ASIG5V:1308 0.225
RRED70 ASIG5V:1307 ASIG5V:2997 0.303152
RRED71 ASIG5V:1309 ASIG5V:1310 0.225
RRED72 ASIG5V:1309 ASIG5V:2999 0.303152
RRED73 ASIG5V:1311 ASIG5V:1312 0.225
RRED74 ASIG5V:1311 ASIG5V:3001 0.303152
RRED75 ASIG5V:1313 ASIG5V:1314 0.225
RRED76 ASIG5V:1313 ASIG5V:3003 0.689866
RRED77 ASIG5V:1315 ASIG5V:1316 0.225
RRED78 ASIG5V:1315 ASIG5V:3005 0.303152
RRED79 ASIG5V:1317 ASIG5V:1318 0.225
RRED80 ASIG5V:1317 ASIG5V:3007 0.303152
RRED81 ASIG5V:1319 ASIG5V:1320 0.225
RRED82 ASIG5V:1319 ASIG5V:3009 0.303152
RRED83 ASIG5V:1319 ASIG5V:3011 0.38585
RRED84 ASIG5V:132 X46/X27/D0:neg 0.445714
RRED85 ASIG5V:1321 ASIG5V:1322 0.225
RRED86 ASIG5V:1321 ASIG5V:3013 8.9712
RRED87 ASIG5V:1323 ASIG5V:1324 0.225
RRED88 ASIG5V:1323 ASIG5V:3015 0.30241
RRED89 ASIG5V:1325 ASIG5V:1326 0.225
RRED90 ASIG5V:1325 ASIG5V:3017 0.30241
RRED91 ASIG5V:1327 ASIG5V:1328 0.225
RRED92 ASIG5V:1327 ASIG5V:3019 0.30241
RRED93 ASIG5V:1329 ASIG5V:1330 0.225
RRED94 ASIG5V:1329 ASIG5V:3021 0.688177
RRED95 ASIG5V:1331 ASIG5V:1332 0.225
RRED96 ASIG5V:1331 ASIG5V:3023 0.30241
RRED97 ASIG5V:1333 ASIG5V:1334 0.225
RRED98 ASIG5V:1333 ASIG5V:3025 0.30241
RRED99 ASIG5V:1335 ASIG5V:1336 0.225
RRED100 ASIG5V:1335 ASIG5V:3027 0.30241
RRED101 ASIG5V:1335 ASIG5V:3029 0.384905
RRED102 ASIG5V:1337 ASIG5V:1338 0.225
RRED103 ASIG5V:1337 ASIG5V:3031 9.12149
RRED104 ASIG5V:1339 ASIG5V:1340 0.225
RRED105 ASIG5V:1339 ASIG5V:3033 0.290132
RRED106 ASIG5V:134 X46/X27/D0:neg 0.445714
RRED107 ASIG5V:1341 ASIG5V:1342 0.225
RRED108 ASIG5V:1341 ASIG5V:3035 0.290132
RRED109 ASIG5V:1343 ASIG5V:1344 0.225
RRED110 ASIG5V:1343 ASIG5V:3037 0.290132
RRED111 ASIG5V:1345 ASIG5V:1346 0.225
RRED112 ASIG5V:1345 ASIG5V:3039 0.660235
RRED113 ASIG5V:1347 ASIG5V:1348 0.225
RRED114 ASIG5V:1347 ASIG5V:3041 0.290132
RRED115 ASIG5V:1349 ASIG5V:1350 0.225
RRED116 ASIG5V:1349 ASIG5V:3043 0.290132
RRED117 ASIG5V:1351 ASIG5V:1352 0.225
RRED118 ASIG5V:1351 ASIG5V:3045 0.290132
RRED119 ASIG5V:1351 ASIG5V:3047 0.369277
RRED120 ASIG5V:1353 ASIG5V:1354 0.225
RRED121 ASIG5V:1353 ASIG5V:3049 9.41378
RRED122 ASIG5V:1355 ASIG5V:1356 0.225
RRED123 ASIG5V:1355 ASIG5V:3051 0.285513
RRED124 ASIG5V:1357 ASIG5V:1358 0.225
RRED125 ASIG5V:1357 ASIG5V:3053 0.285513
RRED126 ASIG5V:1359 ASIG5V:1360 0.225
RRED127 ASIG5V:1359 ASIG5V:3055 0.285513
RRED128 ASIG5V:136 X46/X27/D0:neg 0.445714
RRED129 ASIG5V:1361 ASIG5V:1362 0.225
RRED130 ASIG5V:1361 ASIG5V:3057 0.649726
RRED131 ASIG5V:1363 ASIG5V:1364 0.225
RRED132 ASIG5V:1363 ASIG5V:3059 0.285513
RRED133 ASIG5V:1365 ASIG5V:1366 0.225
RRED134 ASIG5V:1365 ASIG5V:3061 0.285513
RRED135 ASIG5V:1367 ASIG5V:1368 0.225
RRED136 ASIG5V:1367 ASIG5V:3063 0.285513
RRED137 ASIG5V:1367 ASIG5V:3065 0.363399
RRED138 ASIG5V:1369 ASIG5V:1370 0.225
RRED139 ASIG5V:1369 ASIG5V:3067 9.27884
RRED140 ASIG5V:1370 X46/X29/D0:neg 0.445714
RRED141 ASIG5V:1371 ASIG5V:1372 0.225
RRED142 ASIG5V:1371 ASIG5V:3069 0.283889
RRED143 ASIG5V:1372 X46/X28/D0:neg 0.445714
RRED144 ASIG5V:1373 ASIG5V:1374 0.225
RRED145 ASIG5V:1373 ASIG5V:3071 0.283889
RRED146 ASIG5V:1374 X46/X27/D0:neg 0.445714
RRED147 ASIG5V:1375 ASIG5V:1376 0.225
RRED148 ASIG5V:1375 ASIG5V:3073 0.283889
RRED149 ASIG5V:1376 X46/X26/D0:neg 0.445714
RRED150 ASIG5V:1377 ASIG5V:1378 0.225
RRED151 ASIG5V:1377 ASIG5V:3075 0.64603
RRED152 ASIG5V:1378 X46/X33/D0:pos 0.445714
RRED153 ASIG5V:1379 ASIG5V:1380 0.225
RRED154 ASIG5V:1379 ASIG5V:3077 0.283889
RRED155 ASIG5V:138 X46/X27/D0:neg 0.445714
RRED156 ASIG5V:1380 X46/X32/D0:pos 0.445714
RRED157 ASIG5V:1381 ASIG5V:1382 0.225
RRED158 ASIG5V:1381 ASIG5V:3079 0.283889
RRED159 ASIG5V:1382 X46/X31/D0:pos 0.445714
RRED160 ASIG5V:1383 ASIG5V:1384 0.225
RRED161 ASIG5V:1383 ASIG5V:3081 0.283889
RRED162 ASIG5V:1383 ASIG5V:3083 0.361332
RRED163 ASIG5V:1384 X46/X30/D0:pos 0.445714
RRED164 ASIG5V:144 X46/X27/D0:neg 0.445714
RRED165 ASIG5V:146 X46/X27/D0:neg 0.445714
RRED166 ASIG5V:148 X46/X27/D0:neg 0.445714
RRED167 ASIG5V:15 X46/X26/D0:neg 0.445714
RRED168 ASIG5V:150 X46/X27/D0:neg 0.445714
RRED169 ASIG5V:152 X46/X27/D0:neg 0.445714
RRED170 ASIG5V:154 X46/X27/D0:neg 0.445714
RRED171 ASIG5V:156 X46/X27/D0:neg 0.445714
RRED172 ASIG5V:158 X46/X27/D0:neg 0.445714
RRED173 ASIG5V:160 X46/X27/D0:neg 0.445714
RRED174 ASIG5V:162 X46/X27/D0:neg 0.445714
RRED175 ASIG5V:164 X46/X27/D0:neg 0.445714
RRED176 ASIG5V:166 X46/X27/D0:neg 0.445714
RRED177 ASIG5V:168 X46/X27/D0:neg 0.445714
RRED178 ASIG5V:17 X46/X26/D0:neg 0.445714
RRED179 ASIG5V:170 X46/X27/D0:neg 0.445714
RRED180 ASIG5V:176 ASIG5V:2261 0.23574
RRED181 ASIG5V:176 X46/X27/D0:neg 0.445714
RRED182 ASIG5V:178 X46/X27/D0:neg 0.445714
RRED183 ASIG5V:180 X46/X27/D0:neg 0.445714
RRED184 ASIG5V:182 X46/X27/D0:neg 0.445714
RRED185 ASIG5V:184 X46/X27/D0:neg 0.445714
RRED186 ASIG5V:186 X46/X27/D0:neg 0.445714
RRED187 ASIG5V:188 X46/X27/D0:neg 0.445714
RRED188 ASIG5V:19 X46/X26/D0:neg 0.445714
RRED189 ASIG5V:190 X46/X27/D0:neg 0.445714
RRED190 ASIG5V:192 X46/X27/D0:neg 0.445714
RRED191 ASIG5V:194 X46/X27/D0:neg 0.445714
RRED192 ASIG5V:196 X46/X27/D0:neg 0.445714
RRED193 ASIG5V:198 X46/X27/D0:neg 0.445714
RRED194 ASIG5V:200 X46/X27/D0:neg 0.445714
RRED195 ASIG5V:202 X46/X27/D0:neg 0.445714
RRED196 ASIG5V:204 X46/X27/D0:neg 0.445714
RRED197 ASIG5V:2057 X46/X26/D0:neg 0.445714
RRED198 ASIG5V:2059 ASIG5V:2151 0.2388
RRED199 ASIG5V:2059 X46/X26/D0:neg 0.445714
RRED200 ASIG5V:206 X46/X27/D0:neg 0.445714
RRED201 ASIG5V:2061 X46/X26/D0:neg 0.445714
RRED202 ASIG5V:2063 X46/X26/D0:neg 0.445714
RRED203 ASIG5V:2065 X46/X26/D0:neg 0.445714
RRED204 ASIG5V:2069 X46/X26/D0:neg 0.445714
RRED205 ASIG5V:2071 X46/X26/D0:neg 0.445714
RRED206 ASIG5V:2079 X46/X26/D0:neg 0.445714
RRED207 ASIG5V:2087 X46/X26/D0:neg 0.445714
RRED208 ASIG5V:2091 X46/X26/D0:neg 0.445714
RRED209 ASIG5V:2093 X46/X26/D0:neg 0.445714
RRED210 ASIG5V:2095 X46/X26/D0:neg 0.445714
RRED211 ASIG5V:2097 X46/X26/D0:neg 0.445714
RRED212 ASIG5V:2099 X46/X26/D0:neg 0.445714
RRED213 ASIG5V:2101 X46/X26/D0:neg 0.445714
RRED214 ASIG5V:2103 X46/X26/D0:neg 0.445714
RRED215 ASIG5V:2105 X46/X26/D0:neg 0.445714
RRED216 ASIG5V:2107 X46/X26/D0:neg 0.445714
RRED217 ASIG5V:2109 X46/X26/D0:neg 0.445714
RRED218 ASIG5V:2111 X46/X26/D0:neg 0.445714
RRED219 ASIG5V:2113 X46/X26/D0:neg 0.445714
RRED220 ASIG5V:2115 X46/X26/D0:neg 0.445714
RRED221 ASIG5V:2117 X46/X26/D0:neg 0.274391
RRED222 ASIG5V:2121 X46/X26/D0:neg 0.445714
RRED223 ASIG5V:2125 X46/X26/D0:neg 0.445714
RRED224 ASIG5V:2127 X46/X26/D0:neg 0.445714
RRED225 ASIG5V:2129 X46/X26/D0:neg 0.445714
RRED226 ASIG5V:213 X46/X28/D0:neg 0.445714
RRED227 ASIG5V:2131 X46/X26/D0:neg 0.445714
RRED228 ASIG5V:2133 X46/X26/D0:neg 0.445714
RRED229 ASIG5V:2135 X46/X26/D0:neg 0.445714
RRED230 ASIG5V:2137 X46/X26/D0:neg 0.445714
RRED231 ASIG5V:2139 X46/X26/D0:neg 0.445714
RRED232 ASIG5V:2141 X46/X26/D0:neg 0.445714
RRED233 ASIG5V:2143 X46/X26/D0:neg 0.445714
RRED234 ASIG5V:2145 X46/X26/D0:neg 0.445714
RRED235 ASIG5V:2147 X46/X26/D0:neg 0.445714
RRED236 ASIG5V:2149 X46/X26/D0:neg 0.445714
RRED237 ASIG5V:215 X46/X28/D0:neg 0.445714
RRED238 ASIG5V:2153 X46/X26/D0:neg 0.445714
RRED239 ASIG5V:2155 X46/X26/D0:neg 0.445714
RRED240 ASIG5V:2157 X46/X26/D0:neg 0.445714
RRED241 ASIG5V:217 X46/X28/D0:neg 0.445714
RRED242 ASIG5V:219 X46/X28/D0:neg 0.445714
RRED243 ASIG5V:221 X46/X28/D0:neg 0.445714
RRED244 ASIG5V:2227 X46/X27/D0:neg 0.271523
RRED245 ASIG5V:223 X46/X28/D0:neg 0.445714
RRED246 ASIG5V:225 X46/X28/D0:neg 0.445714
RRED247 ASIG5V:227 X46/X28/D0:neg 0.445714
RRED248 ASIG5V:2279 ASIG5V:2367 0.230481
RRED249 ASIG5V:2279 X46/X28/D0:neg 0.445714
RRED250 ASIG5V:2283 X46/X28/D0:neg 0.445714
RRED251 ASIG5V:229 X46/X28/D0:neg 0.445714
RRED252 ASIG5V:2291 X46/X28/D0:neg 0.445714
RRED253 ASIG5V:2299 X46/X28/D0:neg 0.445714
RRED254 ASIG5V:2307 X46/X28/D0:neg 0.445714
RRED255 ASIG5V:231 X46/X28/D0:neg 0.445714
RRED256 ASIG5V:2311 X46/X28/D0:neg 0.445714
RRED257 ASIG5V:2315 X46/X28/D0:neg 0.445714
RRED258 ASIG5V:2317 X46/X28/D0:neg 0.445714
RRED259 ASIG5V:2319 X46/X28/D0:neg 0.445714
RRED260 ASIG5V:2321 X46/X28/D0:neg 0.445714
RRED261 ASIG5V:2323 X46/X28/D0:neg 0.445714
RRED262 ASIG5V:2325 X46/X28/D0:neg 0.445714
RRED263 ASIG5V:2327 X46/X28/D0:neg 0.445714
RRED264 ASIG5V:2329 X46/X28/D0:neg 0.445714
RRED265 ASIG5V:2331 X46/X28/D0:neg 0.445714
RRED266 ASIG5V:2333 X46/X28/D0:neg 0.445714
RRED267 ASIG5V:2335 X46/X28/D0:neg 0.445714
RRED268 ASIG5V:2337 X46/X28/D0:neg 0.445714
RRED269 ASIG5V:2341 X46/X28/D0:neg 0.445714
RRED270 ASIG5V:2343 X46/X28/D0:neg 0.445714
RRED271 ASIG5V:2345 X46/X28/D0:neg 0.445714
RRED272 ASIG5V:2347 X46/X28/D0:neg 0.445714
RRED273 ASIG5V:2349 X46/X28/D0:neg 0.445714
RRED274 ASIG5V:2351 X46/X28/D0:neg 0.445714
RRED275 ASIG5V:2353 X46/X28/D0:neg 0.445714
RRED276 ASIG5V:2355 X46/X28/D0:neg 0.445714
RRED277 ASIG5V:2357 X46/X28/D0:neg 0.445714
RRED278 ASIG5V:2359 X46/X28/D0:neg 0.445714
RRED279 ASIG5V:2361 X46/X28/D0:neg 0.445714
RRED280 ASIG5V:2363 X46/X28/D0:neg 0.445714
RRED281 ASIG5V:2365 X46/X28/D0:neg 0.445714
RRED282 ASIG5V:2369 X46/X28/D0:neg 0.445714
RRED283 ASIG5V:2371 X46/X28/D0:neg 0.445714
RRED284 ASIG5V:2373 X46/X28/D0:neg 0.445714
RRED285 ASIG5V:2381 X46/X28/D0:neg 0.20208
RRED286 ASIG5V:2385 X46/X29/D0:neg 0.445714
RRED287 ASIG5V:2387 ASIG5V:2475 0.23064
RRED288 ASIG5V:2387 X46/X29/D0:neg 0.445714
RRED289 ASIG5V:2389 X46/X29/D0:neg 0.445714
RRED290 ASIG5V:2391 X46/X29/D0:neg 0.445714
RRED291 ASIG5V:2393 X46/X29/D0:neg 0.445714
RRED292 ASIG5V:2397 X46/X29/D0:neg 0.445714
RRED293 ASIG5V:2399 X46/X29/D0:neg 0.445714
RRED294 ASIG5V:2401 X46/X29/D0:neg 0.445714
RRED295 ASIG5V:2405 X46/X29/D0:neg 0.445714
RRED296 ASIG5V:2407 X46/X29/D0:neg 0.445714
RRED297 ASIG5V:2409 X46/X29/D0:neg 0.445714
RRED298 ASIG5V:2413 X46/X29/D0:neg 0.445714
RRED299 ASIG5V:2415 X46/X29/D0:neg 0.445714
RRED300 ASIG5V:2417 X46/X29/D0:neg 0.445714
RRED301 ASIG5V:2419 X46/X29/D0:neg 0.445714
RRED302 ASIG5V:2421 X46/X29/D0:neg 0.445714
RRED303 ASIG5V:2423 X46/X29/D0:neg 0.445714
RRED304 ASIG5V:2425 X46/X29/D0:neg 0.445714
RRED305 ASIG5V:2427 X46/X29/D0:neg 0.445714
RRED306 ASIG5V:2429 X46/X29/D0:neg 0.445714
RRED307 ASIG5V:2431 X46/X29/D0:neg 0.445714
RRED308 ASIG5V:2433 X46/X29/D0:neg 0.445714
RRED309 ASIG5V:2435 X46/X29/D0:neg 0.445714
RRED310 ASIG5V:2437 X46/X29/D0:neg 0.445714
RRED311 ASIG5V:2439 X46/X29/D0:neg 0.445714
RRED312 ASIG5V:2441 X46/X29/D0:neg 0.445714
RRED313 ASIG5V:2443 X46/X29/D0:neg 0.445714
RRED314 ASIG5V:2445 X46/X29/D0:neg 0.445714
RRED315 ASIG5V:2449 X46/X29/D0:neg 0.445714
RRED316 ASIG5V:2451 X46/X29/D0:neg 0.445714
RRED317 ASIG5V:2453 X46/X29/D0:neg 0.445714
RRED318 ASIG5V:2455 X46/X29/D0:neg 0.445714
RRED319 ASIG5V:2457 X46/X29/D0:neg 0.445714
RRED320 ASIG5V:2459 X46/X29/D0:neg 0.445714
RRED321 ASIG5V:2461 X46/X29/D0:neg 0.445714
RRED322 ASIG5V:2463 X46/X29/D0:neg 0.445714
RRED323 ASIG5V:2465 X46/X29/D0:neg 0.445714
RRED324 ASIG5V:2467 X46/X29/D0:neg 0.445714
RRED325 ASIG5V:2469 X46/X29/D0:neg 0.445714
RRED326 ASIG5V:2471 X46/X29/D0:neg 0.445714
RRED327 ASIG5V:2473 X46/X29/D0:neg 0.445714
RRED328 ASIG5V:2477 X46/X29/D0:neg 0.445714
RRED329 ASIG5V:2479 X46/X29/D0:neg 0.445714
RRED330 ASIG5V:2481 X46/X29/D0:neg 0.445714
RRED331 ASIG5V:2489 X46/X29/D0:neg 0.20226
RRED332 ASIG5V:2493 X46/X30/D0:pos 0.445714
RRED333 ASIG5V:2495 X46/X30/D0:pos 0.445714
RRED334 ASIG5V:2497 X46/X30/D0:pos 0.445714
RRED335 ASIG5V:2499 X46/X30/D0:pos 0.445714
RRED336 ASIG5V:2501 X46/X30/D0:pos 0.445714
RRED337 ASIG5V:2505 X46/X30/D0:pos 0.445714
RRED338 ASIG5V:2507 X46/X30/D0:pos 0.445714
RRED339 ASIG5V:2509 X46/X30/D0:pos 0.445714
RRED340 ASIG5V:2513 X46/X30/D0:pos 0.445714
RRED341 ASIG5V:2515 X46/X30/D0:pos 0.445714
RRED342 ASIG5V:2517 X46/X30/D0:pos 0.445714
RRED343 ASIG5V:2521 X46/X30/D0:pos 0.445714
RRED344 ASIG5V:2523 X46/X30/D0:pos 0.445714
RRED345 ASIG5V:2525 X46/X30/D0:pos 0.445714
RRED346 ASIG5V:2527 X46/X30/D0:pos 0.445714
RRED347 ASIG5V:2529 X46/X30/D0:pos 0.445714
RRED348 ASIG5V:2531 X46/X30/D0:pos 0.445714
RRED349 ASIG5V:2533 X46/X30/D0:pos 0.445714
RRED350 ASIG5V:2535 X46/X30/D0:pos 0.445714
RRED351 ASIG5V:2537 X46/X30/D0:pos 0.445714
RRED352 ASIG5V:2539 X46/X30/D0:pos 0.445714
RRED353 ASIG5V:2541 X46/X30/D0:pos 0.445714
RRED354 ASIG5V:2543 X46/X30/D0:pos 0.445714
RRED355 ASIG5V:2545 X46/X30/D0:pos 0.445714
RRED356 ASIG5V:2547 X46/X30/D0:pos 0.445714
RRED357 ASIG5V:2549 X46/X30/D0:pos 0.445714
RRED358 ASIG5V:2551 X46/X30/D0:pos 0.445714
RRED359 ASIG5V:2553 X46/X30/D0:pos 0.272624
RRED360 ASIG5V:2555 X46/X30/D0:pos 0.445714
RRED361 ASIG5V:2557 ASIG5V:2559 0.353527
RRED362 ASIG5V:2559 X46/X30/D0:pos 0.445714
RRED363 ASIG5V:2561 X46/X30/D0:pos 0.445714
RRED364 ASIG5V:2565 X46/X30/D0:pos 0.445714
RRED365 ASIG5V:2567 X46/X30/D0:pos 0.445714
RRED366 ASIG5V:2569 X46/X30/D0:pos 0.445714
RRED367 ASIG5V:2571 X46/X30/D0:pos 0.445714
RRED368 ASIG5V:2573 X46/X30/D0:pos 0.445714
RRED369 ASIG5V:2575 X46/X30/D0:pos 0.445714
RRED370 ASIG5V:2577 X46/X30/D0:pos 0.445714
RRED371 ASIG5V:2579 X46/X30/D0:pos 0.445714
RRED372 ASIG5V:2581 X46/X30/D0:pos 0.445714
RRED373 ASIG5V:2583 X46/X30/D0:pos 0.445714
RRED374 ASIG5V:2585 X46/X30/D0:pos 0.445714
RRED375 ASIG5V:2587 X46/X30/D0:pos 0.445714
RRED376 ASIG5V:2589 X46/X30/D0:pos 0.445714
RRED377 ASIG5V:2591 X46/X30/D0:pos 0.445714
RRED378 ASIG5V:2593 X46/X30/D0:pos 0.445714
RRED379 ASIG5V:2595 X46/X30/D0:pos 0.445714
RRED380 ASIG5V:2605 X46/X31/D0:pos 0.445714
RRED381 ASIG5V:2607 X46/X31/D0:pos 0.445714
RRED382 ASIG5V:2609 X46/X31/D0:pos 0.445714
RRED383 ASIG5V:2611 X46/X31/D0:pos 0.445714
RRED384 ASIG5V:2613 X46/X31/D0:pos 0.445714
RRED385 ASIG5V:2617 X46/X31/D0:pos 0.445714
RRED386 ASIG5V:2619 X46/X31/D0:pos 0.445714
RRED387 ASIG5V:2621 X46/X31/D0:pos 0.445714
RRED388 ASIG5V:2625 X46/X31/D0:pos 0.445714
RRED389 ASIG5V:2627 X46/X31/D0:pos 0.445714
RRED390 ASIG5V:2629 X46/X31/D0:pos 0.445714
RRED391 ASIG5V:2633 X46/X31/D0:pos 0.445714
RRED392 ASIG5V:2635 X46/X31/D0:pos 0.445714
RRED393 ASIG5V:2637 X46/X31/D0:pos 0.445714
RRED394 ASIG5V:2639 X46/X31/D0:pos 0.445714
RRED395 ASIG5V:2641 X46/X31/D0:pos 0.445714
RRED396 ASIG5V:2643 X46/X31/D0:pos 0.445714
RRED397 ASIG5V:2645 X46/X31/D0:pos 0.445714
RRED398 ASIG5V:2647 X46/X31/D0:pos 0.445714
RRED399 ASIG5V:2649 X46/X31/D0:pos 0.445714
RRED400 ASIG5V:2651 X46/X31/D0:pos 0.445714
RRED401 ASIG5V:2653 X46/X31/D0:pos 0.445714
RRED402 ASIG5V:2655 X46/X31/D0:pos 0.445714
RRED403 ASIG5V:2657 X46/X31/D0:pos 0.445714
RRED404 ASIG5V:2659 X46/X31/D0:pos 0.445714
RRED405 ASIG5V:2661 X46/X31/D0:pos 0.445714
RRED406 ASIG5V:2663 X46/X31/D0:pos 0.445714
RRED407 ASIG5V:2665 X46/X31/D0:pos 0.269401
RRED408 ASIG5V:2667 X46/X31/D0:pos 0.445714
RRED409 ASIG5V:2669 ASIG5V:2671 0.350818
RRED410 ASIG5V:2671 X46/X31/D0:pos 0.445714
RRED411 ASIG5V:2673 X46/X31/D0:pos 0.445714
RRED412 ASIG5V:2677 X46/X31/D0:pos 0.445714
RRED413 ASIG5V:2679 X46/X31/D0:pos 0.445714
RRED414 ASIG5V:2681 X46/X31/D0:pos 0.445714
RRED415 ASIG5V:2683 X46/X31/D0:pos 0.445714
RRED416 ASIG5V:2685 X46/X31/D0:pos 0.445714
RRED417 ASIG5V:2687 X46/X31/D0:pos 0.445714
RRED418 ASIG5V:2689 X46/X31/D0:pos 0.445714
RRED419 ASIG5V:2691 X46/X31/D0:pos 0.445714
RRED420 ASIG5V:2693 X46/X31/D0:pos 0.445714
RRED421 ASIG5V:2695 X46/X31/D0:pos 0.445714
RRED422 ASIG5V:2697 X46/X31/D0:pos 0.445714
RRED423 ASIG5V:2699 X46/X31/D0:pos 0.445714
RRED424 ASIG5V:2701 X46/X31/D0:pos 0.445714
RRED425 ASIG5V:2703 X46/X31/D0:pos 0.445714
RRED426 ASIG5V:2705 X46/X31/D0:pos 0.445714
RRED427 ASIG5V:2707 X46/X31/D0:pos 0.445714
RRED428 ASIG5V:2717 X46/X32/D0:pos 0.445714
RRED429 ASIG5V:2719 X46/X32/D0:pos 0.445714
RRED430 ASIG5V:2721 X46/X32/D0:pos 0.445714
RRED431 ASIG5V:2723 X46/X32/D0:pos 0.445714
RRED432 ASIG5V:2725 X46/X32/D0:pos 0.445714
RRED433 ASIG5V:2729 X46/X32/D0:pos 0.445714
RRED434 ASIG5V:2731 X46/X32/D0:pos 0.445714
RRED435 ASIG5V:2733 X46/X32/D0:pos 0.445714
RRED436 ASIG5V:2737 X46/X32/D0:pos 0.445714
RRED437 ASIG5V:2739 X46/X32/D0:pos 0.445714
RRED438 ASIG5V:2741 X46/X32/D0:pos 0.445714
RRED439 ASIG5V:2745 X46/X32/D0:pos 0.445714
RRED440 ASIG5V:2747 X46/X32/D0:pos 0.445714
RRED441 ASIG5V:2749 X46/X32/D0:pos 0.445714
RRED442 ASIG5V:2751 X46/X32/D0:pos 0.445714
RRED443 ASIG5V:2753 X46/X32/D0:pos 0.445714
RRED444 ASIG5V:2755 X46/X32/D0:pos 0.445714
RRED445 ASIG5V:2757 X46/X32/D0:pos 0.445714
RRED446 ASIG5V:2759 X46/X32/D0:pos 0.445714
RRED447 ASIG5V:2761 X46/X32/D0:pos 0.445714
RRED448 ASIG5V:2763 X46/X32/D0:pos 0.445714
RRED449 ASIG5V:2765 X46/X32/D0:pos 0.445714
RRED450 ASIG5V:2767 X46/X32/D0:pos 0.445714
RRED451 ASIG5V:2769 X46/X32/D0:pos 0.445714
RRED452 ASIG5V:2771 X46/X32/D0:pos 0.445714
RRED453 ASIG5V:2773 X46/X32/D0:pos 0.445714
RRED454 ASIG5V:2775 X46/X32/D0:pos 0.445714
RRED455 ASIG5V:2777 X46/X32/D0:pos 0.26886
RRED456 ASIG5V:2779 X46/X32/D0:pos 0.445714
RRED457 ASIG5V:2781 ASIG5V:2783 0.350364
RRED458 ASIG5V:2783 X46/X32/D0:pos 0.445714
RRED459 ASIG5V:2785 X46/X32/D0:pos 0.445714
RRED460 ASIG5V:2789 X46/X32/D0:pos 0.445714
RRED461 ASIG5V:2791 X46/X32/D0:pos 0.445714
RRED462 ASIG5V:2793 X46/X32/D0:pos 0.445714
RRED463 ASIG5V:2795 X46/X32/D0:pos 0.445714
RRED464 ASIG5V:2797 X46/X32/D0:pos 0.445714
RRED465 ASIG5V:2799 X46/X32/D0:pos 0.445714
RRED466 ASIG5V:2801 X46/X32/D0:pos 0.445714
RRED467 ASIG5V:2803 X46/X32/D0:pos 0.445714
RRED468 ASIG5V:2805 X46/X32/D0:pos 0.445714
RRED469 ASIG5V:2807 X46/X32/D0:pos 0.445714
RRED470 ASIG5V:2809 X46/X32/D0:pos 0.445714
RRED471 ASIG5V:2811 X46/X32/D0:pos 0.445714
RRED472 ASIG5V:2813 X46/X32/D0:pos 0.445714
RRED473 ASIG5V:2815 X46/X32/D0:pos 0.445714
RRED474 ASIG5V:2817 X46/X32/D0:pos 0.445714
RRED475 ASIG5V:2819 X46/X32/D0:pos 0.445714
RRED476 ASIG5V:2829 X46/X33/D0:pos 0.445714
RRED477 ASIG5V:2831 X46/X33/D0:pos 0.445714
RRED478 ASIG5V:2833 X46/X33/D0:pos 0.445714
RRED479 ASIG5V:2835 X46/X33/D0:pos 0.445714
RRED480 ASIG5V:2837 X46/X33/D0:pos 0.445714
RRED481 ASIG5V:2841 X46/X33/D0:pos 0.445714
RRED482 ASIG5V:2843 X46/X33/D0:pos 0.445714
RRED483 ASIG5V:2845 X46/X33/D0:pos 0.445714
RRED484 ASIG5V:2849 X46/X33/D0:pos 0.445714
RRED485 ASIG5V:2851 X46/X33/D0:pos 0.445714
RRED486 ASIG5V:2853 X46/X33/D0:pos 0.445714
RRED487 ASIG5V:2857 X46/X33/D0:pos 0.445714
RRED488 ASIG5V:2859 X46/X33/D0:pos 0.445714
RRED489 ASIG5V:2861 X46/X33/D0:pos 0.445714
RRED490 ASIG5V:2863 X46/X33/D0:pos 0.445714
RRED491 ASIG5V:2865 X46/X33/D0:pos 0.445714
RRED492 ASIG5V:2867 X46/X33/D0:pos 0.445714
RRED493 ASIG5V:2869 X46/X33/D0:pos 0.445714
RRED494 ASIG5V:2871 X46/X33/D0:pos 0.445714
RRED495 ASIG5V:2873 X46/X33/D0:pos 0.445714
RRED496 ASIG5V:2875 X46/X33/D0:pos 0.445714
RRED497 ASIG5V:2877 X46/X33/D0:pos 0.445714
RRED498 ASIG5V:2879 X46/X33/D0:pos 0.445714
RRED499 ASIG5V:2881 X46/X33/D0:pos 0.445714
RRED500 ASIG5V:2883 X46/X33/D0:pos 0.445714
RRED501 ASIG5V:2885 X46/X33/D0:pos 0.445714
RRED502 ASIG5V:2887 X46/X33/D0:pos 0.445714
RRED503 ASIG5V:2889 X46/X33/D0:pos 0.270865
RRED504 ASIG5V:2891 X46/X33/D0:pos 0.445714
RRED505 ASIG5V:2893 ASIG5V:2895 0.352049
RRED506 ASIG5V:2895 X46/X33/D0:pos 0.445714
RRED507 ASIG5V:2897 X46/X33/D0:pos 0.445714
RRED508 ASIG5V:2901 X46/X33/D0:pos 0.445714
RRED509 ASIG5V:2903 X46/X33/D0:pos 0.445714
RRED510 ASIG5V:2905 X46/X33/D0:pos 0.445714
RRED511 ASIG5V:2907 X46/X33/D0:pos 0.445714
RRED512 ASIG5V:2909 X46/X33/D0:pos 0.445714
RRED513 ASIG5V:2911 X46/X33/D0:pos 0.445714
RRED514 ASIG5V:2913 X46/X33/D0:pos 0.445714
RRED515 ASIG5V:2915 X46/X33/D0:pos 0.445714
RRED516 ASIG5V:2917 X46/X33/D0:pos 0.445714
RRED517 ASIG5V:2919 X46/X33/D0:pos 0.445714
RRED518 ASIG5V:2921 X46/X33/D0:pos 0.445714
RRED519 ASIG5V:2923 X46/X33/D0:pos 0.445714
RRED520 ASIG5V:2925 X46/X33/D0:pos 0.445714
RRED521 ASIG5V:2927 X46/X33/D0:pos 0.445714
RRED522 ASIG5V:2929 X46/X33/D0:pos 0.445714
RRED523 ASIG5V:2931 X46/X33/D0:pos 0.445714
RRED524 ASIG5V:311 X46/X28/D0:neg 0.445714
RRED525 ASIG5V:33 X46/X26/D0:neg 0.445714
RRED526 ASIG5V:416 X46/X29/D0:neg 0.445714
RRED527 ASIG5V:453 X46/X30/D0:pos 0.445714
RRED528 ASIG5V:558 X46/X31/D0:pos 0.445714
RRED529 ASIG5V:663 X46/X32/D0:pos 0.445714
RRED530 ASIG5V:768 X46/X33/D0:pos 0.445714
RRED531 D8:neg DVDD:10 0.00460993092651137
RRED532 DVDD DVDD:10658 0.0138888891365644
RRED533 DVDD DVDD:10717 0.102272740702475
RRED534 DVDD DVDD:11333 0.3
RRED535 DVDD DVDD:11359 0.1875
RRED536 DVDD DVDD:11386 0.75
RRED537 DVDD DVDD:11392 0.75
RRED538 DVDD DVDD:11398 0.75
RRED539 DVDD DVDD:11404 1.5
RRED540 DVDD DVDD:11427 0.204545454545455
RRED541 DVDD DVDD:11536 0.043269233173076
RRED542 DVDD DVDD:11562 0.00858779757881225
RRED543 DVDD DVDD:11588 0.00858779757881225
RRED544 DVDD DVDD:11612 0.043269233173076
RRED545 DVDD DVDD:11632 0.0107142860090702
RRED546 DVDD DVDD:11708 0.0107142860090702
RRED547 DVDD DVDD:12060 0.0340909105831032
RRED548 DVDD DVDD:12130 0.102272770661118
RRED549 DVDD DVDD:12200 0.102272770661118
RRED550 DVDD DVDD:12481 0.0340909240128557
RRED551 DVDD DVDD:12551 0.102272770661118
RRED552 DVDD DVDD:12621 0.102272770661118
RRED553 DVDD DVDD:12796 0.0340909240128557
RRED554 DVDD DVDD:12866 0.102272770661118
RRED555 DVDD DVDD:12936 0.102272770661118
RRED556 DVDD DVDD:13111 0.0340909105831032
RRED557 DVDD DVDD:13181 0.102272770661118
RRED558 DVDD DVDD:13251 0.102272770661118
RRED559 DVDD DVDD:13286 0.01388888938424
RRED560 DVDD DVDD:13426 0.0340909105831032
RRED561 DVDD DVDD:13496 0.102272770661118
RRED562 DVDD DVDD:13566 0.102272770661118
RRED563 DVDD DVDD:13599 0.102272740702475
RRED564 DVDD DVDD:13607 0.0432692307692308
RRED565 DVDD DVDD:13626 0.046875
RRED566 DVDD DVDD:13770 0.75
RRED567 DVDD DVDD:13915 0.102272770661118
RRED568 DVDD DVDD:13924 0.0535715
RRED569 DVDD DVDD:13943 0.040178625
RRED570 DVDD DVDD:13967 0.0459184285714286
RRED571 DVDD DVDD:13988 0.0500000622222167
RRED572 DVDD DVDD:14009 0.107143
RRED573 DVDD DVDD:14018 0.0459184285714286
RRED574 DVDD DVDD:14039 0.0865385
RRED575 DVDD DVDD:14051 0.0562500243749997
RRED576 DVDD DVDD:14072 0.0953191535780075
RRED577 DVDD DVDD:14100 0.102272770661118
RRED578 DVDD DVDD:14379 0.102272770661118
RRED579 DVDD DVDD:14664 0.102272770661118
RRED580 DVDD DVDD:14949 0.102272770661118
RRED581 DVDD DVDD:15249 0.102272770661118
RRED582 DVDD DVDD:15258 0.0535715
RRED583 DVDD DVDD:15277 0.040178625
RRED584 DVDD DVDD:15301 0.0459184285714286
RRED585 DVDD DVDD:15322 0.0500000622222167
RRED586 DVDD DVDD:15343 0.107143
RRED587 DVDD DVDD:15352 0.0459184285714286
RRED588 DVDD DVDD:15373 0.0865385
RRED589 DVDD DVDD:15385 0.0562500243749997
RRED590 DVDD DVDD:15406 0.0953191535780075
RRED591 DVDD DVDD:15435 0.0401020297354516
RRED592 DVDD DVDD:15456 0.046875
RRED593 DVDD:10 DVDD:11536 0.299999968888885
RRED594 DVDD:10 DVDD:11562 0.149999984444443
RRED595 DVDD:10 DVDD:11588 0.149999984444443
RRED596 DVDD:10 DVDD:11612 0.299999968888885
RRED597 DVDD:10 DVDD:11632 0.299999968888885
RRED598 DVDD:10 DVDD:11708 0.299999968888885
RRED599 DVDD:101 DVDD:11536 0.45
RRED600 DVDD:101 DVDD:11562 0.45
RRED601 DVDD:101 DVDD:11588 0.45
RRED602 DVDD:101 DVDD:11612 0.45
RRED603 DVDD:101 X27/D0:neg 0.032550227793788
RRED604 DVDD:1029 DVDD:1483 0.114324
RRED605 DVDD:1029 DVDD:1551 0.119278
RRED606 DVDD:1029 DVDD:1791 0.114324
RRED607 DVDD:1029 DVDD:1859 0.119278
RRED608 DVDD:1029 DVDD:3979 0.0433240500881425
RRED609 DVDD:1029 DVDD:4059 0.299999968888885
RRED610 DVDD:1029 DVDD:4061 0.299999968888885
RRED611 DVDD:1029 DVDD:4063 0.299999968888885
RRED612 DVDD:1029 DVDD:4091 0.299999968888885
RRED613 DVDD:1029 DVDD:4093 0.299999968888885
RRED614 DVDD:1029 DVDD:4095 0.299999968888885
RRED615 DVDD:1029 DVDD:4123 0.299999968888885
RRED616 DVDD:1029 DVDD:4125 0.299999968888885
RRED617 DVDD:1029 DVDD:4127 0.299999968888885
RRED618 DVDD:1029 DVDD:4155 0.299999968888885
RRED619 DVDD:1029 DVDD:4157 0.299999968888885
RRED620 DVDD:1029 DVDD:4159 0.299999968888885
RRED621 DVDD:1029 DVDD:4167 0.0433240500881425
RRED622 DVDD:1029 X46/D1:neg 0.00423452498964958
RRED623 DVDD:10658 DVDD:10659 0.0576923076923077
RRED624 DVDD:10658 DVDD:10664 0.0576923076923077
RRED625 DVDD:10658 DVDD:10684 0.0576923076923077
RRED626 DVDD:10658 DVDD:10688 0.228015
RRED627 DVDD:10658 DVDD:13626 0.269139
RRED628 DVDD:10659 DVDD:5283 0.490911
RRED629 DVDD:10659 DVDD:5294 0.490893
RRED630 DVDD:10659 DVDD:5309 0.433333
RRED631 DVDD:10659 DVDD:5317 0.433333
RRED632 DVDD:10664 DVDD:5733 0.490911
RRED633 DVDD:10664 DVDD:5744 0.490893
RRED634 DVDD:10664 DVDD:5759 0.433333
RRED635 DVDD:10664 DVDD:5767 0.433333
RRED636 DVDD:10684 DVDD:6327 0.490911
RRED637 DVDD:10684 DVDD:6338 0.490893
RRED638 DVDD:10684 DVDD:6353 0.433333
RRED639 DVDD:10684 DVDD:6361 0.433333
RRED640 DVDD:10688 DVDD:10689 0.0576923076923077
RRED641 DVDD:10688 DVDD:11300 0.392617
RRED642 DVDD:10689 DVDD:6777 0.490911
RRED643 DVDD:10689 DVDD:6788 0.490893
RRED644 DVDD:10689 DVDD:6803 0.433333
RRED645 DVDD:10689 DVDD:6811 0.433333
RRED646 DVDD:10717 DVDD:10718 0.0586254661913102
RRED647 DVDD:10717 DVDD:11522 0.371457
RRED648 DVDD:10718 DVDD:4833 0.490911
RRED649 DVDD:10718 DVDD:4844 0.490893
RRED650 DVDD:10718 DVDD:4859 0.433333
RRED651 DVDD:10718 DVDD:4867 0.433333
RRED652 DVDD:11299 DVDD:11300 1.5
RRED653 DVDD:11299 DVDD:11303 0.75
RRED654 DVDD:11299 DVDD:11309 0.75
RRED655 DVDD:11299 DVDD:11315 0.75
RRED656 DVDD:11299 DVDD:11321 0.75
RRED657 DVDD:11299 DVDD:11327 0.75
RRED658 DVDD:11299 DVDD:11333 0.236842105263158
RRED659 DVDD:11299 DVDD:7371 0.490911
RRED660 DVDD:11299 DVDD:7382 0.490893
RRED661 DVDD:11299 DVDD:7397 0.433333
RRED662 DVDD:11299 DVDD:7405 0.433333
RRED663 DVDD:11300 DVDD:11303 0.1116
RRED664 DVDD:11303 DVDD:11309 0.1116
RRED665 DVDD:11309 DVDD:11315 0.1116
RRED666 DVDD:11315 DVDD:11321 0.1116
RRED667 DVDD:11321 DVDD:11327 0.1116
RRED668 DVDD:11327 DVDD:11333 0.1116
RRED669 DVDD:11333 DVDD:13770 0.1116
RRED670 DVDD:11358 DVDD:11359 0.166666666666667
RRED671 DVDD:11358 DVDD:11386 0.75
RRED672 DVDD:11358 DVDD:11392 0.75
RRED673 DVDD:11358 DVDD:11398 0.75
RRED674 DVDD:11358 DVDD:11404 0.642857142857143
RRED675 DVDD:11358 DVDD:7821 0.490911
RRED676 DVDD:11358 DVDD:7832 0.490893
RRED677 DVDD:11358 DVDD:7847 0.433333
RRED678 DVDD:11358 DVDD:7855 0.433333
RRED679 DVDD:11359 DVDD:11386 0.1116
RRED680 DVDD:11359 DVDD:13770 0.20745
RRED681 DVDD:11386 DVDD:11392 0.1116
RRED682 DVDD:11392 DVDD:11398 0.1116
RRED683 DVDD:11398 DVDD:11404 0.1116
RRED684 DVDD:11404 DVDD:11418 0.3816
RRED685 DVDD:11417 DVDD:11418 1.5
RRED686 DVDD:11417 DVDD:11421 0.75
RRED687 DVDD:11417 DVDD:11427 0.15
RRED688 DVDD:11417 DVDD:11457 0.75
RRED689 DVDD:11417 DVDD:11463 0.642857142857143
RRED690 DVDD:11417 DVDD:8415 0.490911
RRED691 DVDD:11417 DVDD:8426 0.490893
RRED692 DVDD:11417 DVDD:8441 0.433333
RRED693 DVDD:11417 DVDD:8449 0.433333
RRED694 DVDD:11418 DVDD:11421 0.1116
RRED695 DVDD:11421 DVDD:11427 0.1116
RRED696 DVDD:11427 DVDD:11457 0.1116
RRED697 DVDD:11457 DVDD:11463 0.1116
RRED698 DVDD:11463 DVDD:11477 0.3816
RRED699 DVDD:11476 DVDD:11477 1.5
RRED700 DVDD:11476 DVDD:11480 0.75
RRED701 DVDD:11476 DVDD:11486 0.75
RRED702 DVDD:11476 DVDD:11492 0.75
RRED703 DVDD:11476 DVDD:11498 0.75
RRED704 DVDD:11476 DVDD:11504 0.75
RRED705 DVDD:11476 DVDD:11510 0.75
RRED706 DVDD:11476 DVDD:11516 0.75
RRED707 DVDD:11476 DVDD:11522 0.642857142857143
RRED708 DVDD:11476 DVDD:8865 0.490911
RRED709 DVDD:11476 DVDD:8876 0.490893
RRED710 DVDD:11476 DVDD:8891 0.433333
RRED711 DVDD:11476 DVDD:8899 0.433333
RRED712 DVDD:11477 DVDD:11480 0.1116
RRED713 DVDD:11480 DVDD:11486 0.1116
RRED714 DVDD:11486 DVDD:11492 0.1116
RRED715 DVDD:11492 DVDD:11498 0.1116
RRED716 DVDD:11498 DVDD:11504 0.1116
RRED717 DVDD:11504 DVDD:11510 0.1116
RRED718 DVDD:11510 DVDD:11516 0.1116
RRED719 DVDD:11516 DVDD:11522 0.1116
RRED720 DVDD:11536 DVDD:11632 0.121004
RRED721 DVDD:11536 DVDD:14100 0.412087
RRED722 DVDD:11536 DVDD:1943 0.28125
RRED723 DVDD:11562 DVDD:11631 0.45
RRED724 DVDD:11562 DVDD:11727 0.45
RRED725 DVDD:11562 DVDD:11823 0.45
RRED726 DVDD:11562 DVDD:12340 0.155172413793103
RRED727 DVDD:11562 DVDD:12375 0.155172413793103
RRED728 DVDD:11562 DVDD:12410 0.155172413793103
RRED729 DVDD:11562 DVDD:12446 0.14687
RRED730 DVDD:11562 DVDD:14379 0.412087
RRED731 DVDD:11562 DVDD:1943 0.28125
RRED732 DVDD:11588 DVDD:11631 0.45
RRED733 DVDD:11588 DVDD:11727 0.45
RRED734 DVDD:11588 DVDD:11823 0.45
RRED735 DVDD:11588 DVDD:12655 0.155172413793103
RRED736 DVDD:11588 DVDD:12690 0.155172413793103
RRED737 DVDD:11588 DVDD:12725 0.155172413793103
RRED738 DVDD:11588 DVDD:12761 0.14687
RRED739 DVDD:11588 DVDD:14664 0.412087
RRED740 DVDD:11588 DVDD:1943 0.28125
RRED741 DVDD:11612 DVDD:11708 0.121004
RRED742 DVDD:11612 DVDD:14949 0.412087
RRED743 DVDD:11612 DVDD:1943 0.28125
RRED744 DVDD:11631 DVDD:11632 0.45
RRED745 DVDD:11631 DVDD:11708 0.45
RRED746 DVDD:11631 X28/D0:neg 0.032550227793788
RRED747 DVDD:11632 DVDD:11727 0.45
RRED748 DVDD:11632 DVDD:11823 0.45
RRED749 DVDD:11632 DVDD:11919 0.155172413793103
RRED750 DVDD:11632 DVDD:11954 0.155172413793103
RRED751 DVDD:11632 DVDD:11989 0.155172413793103
RRED752 DVDD:11632 DVDD:12025 0.14687
RRED753 DVDD:11708 DVDD:11727 0.45
RRED754 DVDD:11708 DVDD:11823 0.45
RRED755 DVDD:11708 DVDD:12970 0.155172413793103
RRED756 DVDD:11708 DVDD:13005 0.155172413793103
RRED757 DVDD:11708 DVDD:13040 0.155172413793103
RRED758 DVDD:11708 DVDD:13076 0.14687
RRED759 DVDD:11727 X29/D0:neg 0.032550227793788
RRED760 DVDD:11823 X30/D0:neg 0.032550227793788
RRED761 DVDD:11919 DVDD:5289 0.236794
RRED762 DVDD:11919 DVDD:5300 0.236776
RRED763 DVDD:11919 DVDD:5309 0.52
RRED764 DVDD:11919 DVDD:5317 0.52
RRED765 DVDD:11954 DVDD:5739 0.236794
RRED766 DVDD:11954 DVDD:5750 0.236776
RRED767 DVDD:11954 DVDD:5759 0.52
RRED768 DVDD:11954 DVDD:5767 0.52
RRED769 DVDD:11989 DVDD:6333 0.236794
RRED770 DVDD:11989 DVDD:6344 0.236776
RRED771 DVDD:11989 DVDD:6353 0.52
RRED772 DVDD:11989 DVDD:6361 0.52
RRED773 DVDD:12024 DVDD:12025 0.155172413793103
RRED774 DVDD:12024 DVDD:6783 0.236794
RRED775 DVDD:12024 DVDD:6794 0.236776
RRED776 DVDD:12024 DVDD:6803 0.52
RRED777 DVDD:12024 DVDD:6811 0.52
RRED778 DVDD:12025 DVDD:12060 0.201969
RRED779 DVDD:12059 DVDD:12060 0.155172413793103
RRED780 DVDD:12059 DVDD:7377 0.236794
RRED781 DVDD:12059 DVDD:7388 0.236776
RRED782 DVDD:12059 DVDD:7397 0.52
RRED783 DVDD:12059 DVDD:7405 0.52
RRED784 DVDD:12060 DVDD:12094 0.155172413793103
RRED785 DVDD:12060 DVDD:12130 0.201969
RRED786 DVDD:12094 DVDD:7827 0.236794
RRED787 DVDD:12094 DVDD:7838 0.236776
RRED788 DVDD:12094 DVDD:7847 0.52
RRED789 DVDD:12094 DVDD:7855 0.52
RRED790 DVDD:12129 DVDD:12130 0.155172413793103
RRED791 DVDD:12129 DVDD:8421 0.236794
RRED792 DVDD:12129 DVDD:8432 0.236776
RRED793 DVDD:12129 DVDD:8441 0.52
RRED794 DVDD:12129 DVDD:8449 0.52
RRED795 DVDD:12130 DVDD:12165 0.201969
RRED796 DVDD:12164 DVDD:12165 0.155172413793103
RRED797 DVDD:12164 DVDD:8871 0.236794
RRED798 DVDD:12164 DVDD:8882 0.236776
RRED799 DVDD:12164 DVDD:8891 0.52
RRED800 DVDD:12164 DVDD:8899 0.52
RRED801 DVDD:12165 DVDD:12200 0.201969
RRED802 DVDD:12199 DVDD:12200 0.155351597665113
RRED803 DVDD:12199 DVDD:4839 0.236794
RRED804 DVDD:12199 DVDD:4850 0.236776
RRED805 DVDD:12199 DVDD:4859 0.52
RRED806 DVDD:12199 DVDD:4867 0.52
RRED807 DVDD:12340 DVDD:5351 0.236794
RRED808 DVDD:12340 DVDD:5362 0.236776
RRED809 DVDD:12340 DVDD:5371 0.52
RRED810 DVDD:12340 DVDD:5379 0.52
RRED811 DVDD:12375 DVDD:5801 0.236794
RRED812 DVDD:12375 DVDD:5812 0.236776
RRED813 DVDD:12375 DVDD:5821 0.52
RRED814 DVDD:12375 DVDD:5829 0.52
RRED815 DVDD:12410 DVDD:6395 0.236794
RRED816 DVDD:12410 DVDD:6406 0.236776
RRED817 DVDD:12410 DVDD:6415 0.52
RRED818 DVDD:12410 DVDD:6423 0.52
RRED819 DVDD:12445 DVDD:12446 0.155172413793103
RRED820 DVDD:12445 DVDD:6845 0.236794
RRED821 DVDD:12445 DVDD:6856 0.236776
RRED822 DVDD:12445 DVDD:6865 0.52
RRED823 DVDD:12445 DVDD:6873 0.52
RRED824 DVDD:12446 DVDD:12481 0.201969
RRED825 DVDD:12480 DVDD:12481 0.155172413793103
RRED826 DVDD:12480 DVDD:7439 0.236794
RRED827 DVDD:12480 DVDD:7450 0.236776
RRED828 DVDD:12480 DVDD:7459 0.52
RRED829 DVDD:12480 DVDD:7467 0.52
RRED830 DVDD:12481 DVDD:12515 0.155172413793103
RRED831 DVDD:12481 DVDD:12551 0.201969
RRED832 DVDD:12515 DVDD:7889 0.236794
RRED833 DVDD:12515 DVDD:7900 0.236776
RRED834 DVDD:12515 DVDD:7909 0.52
RRED835 DVDD:12515 DVDD:7917 0.52
RRED836 DVDD:12550 DVDD:12551 0.155172413793103
RRED837 DVDD:12550 DVDD:8483 0.236794
RRED838 DVDD:12550 DVDD:8494 0.236776
RRED839 DVDD:12550 DVDD:8503 0.52
RRED840 DVDD:12550 DVDD:8511 0.52
RRED841 DVDD:12551 DVDD:12586 0.201969
RRED842 DVDD:12585 DVDD:12586 0.155172413793103
RRED843 DVDD:12585 DVDD:8933 0.236794
RRED844 DVDD:12585 DVDD:8944 0.236776
RRED845 DVDD:12585 DVDD:8953 0.52
RRED846 DVDD:12585 DVDD:8961 0.52
RRED847 DVDD:12586 DVDD:12621 0.201969
RRED848 DVDD:12620 DVDD:12621 0.155351597665113
RRED849 DVDD:12620 DVDD:4901 0.236794
RRED850 DVDD:12620 DVDD:4912 0.236776
RRED851 DVDD:12620 DVDD:4921 0.52
RRED852 DVDD:12620 DVDD:4929 0.52
RRED853 DVDD:12655 DVDD:5455 0.490911
RRED854 DVDD:12655 DVDD:5466 0.490893
RRED855 DVDD:12655 DVDD:5481 0.433333
RRED856 DVDD:12655 DVDD:5489 0.433333
RRED857 DVDD:12690 DVDD:5905 0.490911
RRED858 DVDD:12690 DVDD:5916 0.490893
RRED859 DVDD:12690 DVDD:5931 0.433333
RRED860 DVDD:12690 DVDD:5939 0.433333
RRED861 DVDD:12725 DVDD:6499 0.490911
RRED862 DVDD:12725 DVDD:6510 0.490893
RRED863 DVDD:12725 DVDD:6525 0.433333
RRED864 DVDD:12725 DVDD:6533 0.433333
RRED865 DVDD:12760 DVDD:12761 0.155172413793103
RRED866 DVDD:12760 DVDD:6949 0.490911
RRED867 DVDD:12760 DVDD:6960 0.490893
RRED868 DVDD:12760 DVDD:6975 0.433333
RRED869 DVDD:12760 DVDD:6983 0.433333
RRED870 DVDD:12761 DVDD:12796 0.201969
RRED871 DVDD:12795 DVDD:12796 0.155172413793103
RRED872 DVDD:12795 DVDD:7543 0.490911
RRED873 DVDD:12795 DVDD:7554 0.490893
RRED874 DVDD:12795 DVDD:7569 0.433333
RRED875 DVDD:12795 DVDD:7577 0.433333
RRED876 DVDD:12796 DVDD:12830 0.155172413793103
RRED877 DVDD:12796 DVDD:12866 0.201969
RRED878 DVDD:12830 DVDD:7993 0.490911
RRED879 DVDD:12830 DVDD:8004 0.490893
RRED880 DVDD:12830 DVDD:8019 0.433333
RRED881 DVDD:12830 DVDD:8027 0.433333
RRED882 DVDD:12865 DVDD:12866 0.155172413793103
RRED883 DVDD:12865 DVDD:8587 0.490911
RRED884 DVDD:12865 DVDD:8598 0.490893
RRED885 DVDD:12865 DVDD:8613 0.433333
RRED886 DVDD:12865 DVDD:8621 0.433333
RRED887 DVDD:12866 DVDD:12901 0.201969
RRED888 DVDD:12900 DVDD:12901 0.155172413793103
RRED889 DVDD:12900 DVDD:9037 0.490911
RRED890 DVDD:12900 DVDD:9048 0.490893
RRED891 DVDD:12900 DVDD:9063 0.433333
RRED892 DVDD:12900 DVDD:9071 0.433333
RRED893 DVDD:12901 DVDD:12936 0.201969
RRED894 DVDD:12935 DVDD:12936 0.155351597665113
RRED895 DVDD:12935 DVDD:5005 0.490911
RRED896 DVDD:12935 DVDD:5016 0.490893
RRED897 DVDD:12935 DVDD:5031 0.433333
RRED898 DVDD:12935 DVDD:5039 0.433333
RRED899 DVDD:12970 DVDD:5517 0.490911
RRED900 DVDD:12970 DVDD:5528 0.490893
RRED901 DVDD:12970 DVDD:5543 0.433333
RRED902 DVDD:12970 DVDD:5551 0.433333
RRED903 DVDD:13005 DVDD:5967 0.490911
RRED904 DVDD:13005 DVDD:5978 0.490893
RRED905 DVDD:13005 DVDD:5993 0.433333
RRED906 DVDD:13005 DVDD:6001 0.433333
RRED907 DVDD:13040 DVDD:6561 0.490911
RRED908 DVDD:13040 DVDD:6572 0.490893
RRED909 DVDD:13040 DVDD:6587 0.433333
RRED910 DVDD:13040 DVDD:6595 0.433333
RRED911 DVDD:13075 DVDD:13076 0.155172413793103
RRED912 DVDD:13075 DVDD:7011 0.490911
RRED913 DVDD:13075 DVDD:7022 0.490893
RRED914 DVDD:13075 DVDD:7037 0.433333
RRED915 DVDD:13075 DVDD:7045 0.433333
RRED916 DVDD:13076 DVDD:13111 0.201969
RRED917 DVDD:13110 DVDD:13111 0.155172413793103
RRED918 DVDD:13110 DVDD:7605 0.490911
RRED919 DVDD:13110 DVDD:7616 0.490893
RRED920 DVDD:13110 DVDD:7631 0.433333
RRED921 DVDD:13110 DVDD:7639 0.433333
RRED922 DVDD:13111 DVDD:13145 0.155172413793103
RRED923 DVDD:13111 DVDD:13181 0.201969
RRED924 DVDD:13145 DVDD:8055 0.490911
RRED925 DVDD:13145 DVDD:8066 0.490893
RRED926 DVDD:13145 DVDD:8081 0.433333
RRED927 DVDD:13145 DVDD:8089 0.433333
RRED928 DVDD:13180 DVDD:13181 0.155172413793103
RRED929 DVDD:13180 DVDD:8649 0.490911
RRED930 DVDD:13180 DVDD:8660 0.490893
RRED931 DVDD:13180 DVDD:8675 0.433333
RRED932 DVDD:13180 DVDD:8683 0.433333
RRED933 DVDD:13181 DVDD:13216 0.201969
RRED934 DVDD:13215 DVDD:13216 0.155172413793103
RRED935 DVDD:13215 DVDD:9099 0.490911
RRED936 DVDD:13215 DVDD:9110 0.490893
RRED937 DVDD:13215 DVDD:9125 0.433333
RRED938 DVDD:13215 DVDD:9133 0.433333
RRED939 DVDD:13216 DVDD:13251 0.201969
RRED940 DVDD:13250 DVDD:13251 0.155351597665113
RRED941 DVDD:13250 DVDD:5067 0.490911
RRED942 DVDD:13250 DVDD:5078 0.490893
RRED943 DVDD:13250 DVDD:5093 0.433333
RRED944 DVDD:13250 DVDD:5101 0.433333
RRED945 DVDD:13285 DVDD:13286 0.0576923076923077
RRED946 DVDD:13285 DVDD:5523 0.236794
RRED947 DVDD:13285 DVDD:5534 0.236776
RRED948 DVDD:13285 DVDD:5543 0.52
RRED949 DVDD:13285 DVDD:5551 0.52
RRED950 DVDD:13286 DVDD:13320 0.0576923076923077
RRED951 DVDD:13286 DVDD:13355 0.0576923076923077
RRED952 DVDD:13286 DVDD:13391 0.142972
RRED953 DVDD:13286 DVDD:15456 0.127559
RRED954 DVDD:13320 DVDD:5973 0.236794
RRED955 DVDD:13320 DVDD:5984 0.236776
RRED956 DVDD:13320 DVDD:5993 0.52
RRED957 DVDD:13320 DVDD:6001 0.52
RRED958 DVDD:13355 DVDD:6567 0.236794
RRED959 DVDD:13355 DVDD:6578 0.236776
RRED960 DVDD:13355 DVDD:6587 0.52
RRED961 DVDD:13355 DVDD:6595 0.52
RRED962 DVDD:13390 DVDD:13391 0.0576923076923077
RRED963 DVDD:13390 DVDD:7017 0.236794
RRED964 DVDD:13390 DVDD:7028 0.236776
RRED965 DVDD:13390 DVDD:7037 0.52
RRED966 DVDD:13390 DVDD:7045 0.52
RRED967 DVDD:13391 DVDD:13426 0.194173
RRED968 DVDD:13425 DVDD:13426 0.0576923076923077
RRED969 DVDD:13425 DVDD:7611 0.236794
RRED970 DVDD:13425 DVDD:7622 0.236776
RRED971 DVDD:13425 DVDD:7631 0.52
RRED972 DVDD:13425 DVDD:7639 0.52
RRED973 DVDD:13426 DVDD:13460 0.0576923076923077
RRED974 DVDD:13426 DVDD:13496 0.194173
RRED975 DVDD:13460 DVDD:8061 0.236794
RRED976 DVDD:13460 DVDD:8072 0.236776
RRED977 DVDD:13460 DVDD:8081 0.52
RRED978 DVDD:13460 DVDD:8089 0.52
RRED979 DVDD:13495 DVDD:13496 0.0576923076923077
RRED980 DVDD:13495 DVDD:8655 0.236794
RRED981 DVDD:13495 DVDD:8666 0.236776
RRED982 DVDD:13495 DVDD:8675 0.52
RRED983 DVDD:13495 DVDD:8683 0.52
RRED984 DVDD:13496 DVDD:13531 0.194173
RRED985 DVDD:13530 DVDD:13531 0.0576923076923077
RRED986 DVDD:13530 DVDD:9105 0.236794
RRED987 DVDD:13530 DVDD:9116 0.236776
RRED988 DVDD:13530 DVDD:9125 0.52
RRED989 DVDD:13530 DVDD:9133 0.52
RRED990 DVDD:13531 DVDD:13566 0.194173
RRED991 DVDD:13565 DVDD:13566 0.0579389523105611
RRED992 DVDD:13565 DVDD:5073 0.236794
RRED993 DVDD:13565 DVDD:5084 0.236776
RRED994 DVDD:13565 DVDD:5093 0.52
RRED995 DVDD:13565 DVDD:5101 0.52
RRED996 DVDD:13599 DVDD:13607 0.921797
RRED997 DVDD:13607 DVDD:13626 0.269139
RRED998 DVDD:13915 DVDD:13924 0.412087
RRED999 DVDD:13915 DVDD:4037 0.464528
RRED1000 DVDD:13924 DVDD:13943 0.109843
RRED1001 DVDD:13924 DVDD:1943 0.28125
RRED1002 DVDD:13943 DVDD:13967 0.105591
RRED1003 DVDD:13967 DVDD:13988 0.105591
RRED1004 DVDD:13988 DVDD:14009 0.36815
RRED1005 DVDD:14009 DVDD:14018 0.106654
RRED1006 DVDD:14018 DVDD:14039 1.26248
RRED1007 DVDD:14039 DVDD:14051 0.129685
RRED1008 DVDD:14051 DVDD:14072 0.369213
RRED1009 DVDD:14100 DVDD:4055 0.464528
RRED1010 DVDD:14379 DVDD:4087 0.464528
RRED1011 DVDD:14664 DVDD:4119 0.464528
RRED1012 DVDD:1483 DVDD:1485 0.114324
RRED1013 DVDD:1483 X46/D1:neg 0.866667
RRED1014 DVDD:1485 DVDD:1487 0.114324
RRED1015 DVDD:1485 X46/D1:neg 0.866667
RRED1016 DVDD:1487 DVDD:1495 0.114324
RRED1017 DVDD:1487 DVDD:4153 0.45
RRED1018 DVDD:1487 X46/D1:neg 0.21666675
RRED1019 DVDD:14949 DVDD:4151 0.464528
RRED1020 DVDD:1495 DVDD:1497 0.114324
RRED1021 DVDD:1495 X46/D1:neg 0.866667
RRED1022 DVDD:1497 DVDD:1499 0.114324
RRED1023 DVDD:1497 X46/D1:neg 0.866667
RRED1024 DVDD:1499 DVDD:1501 0.114324
RRED1025 DVDD:1499 X46/D1:neg 0.866667
RRED1026 DVDD:1501 DVDD:1503 0.114324
RRED1027 DVDD:1501 X46/D1:neg 0.866667
RRED1028 DVDD:1503 DVDD:1511 0.114324
RRED1029 DVDD:1503 DVDD:4121 0.45
RRED1030 DVDD:1503 X46/D1:neg 0.21666675
RRED1031 DVDD:1511 DVDD:1513 0.114324
RRED1032 DVDD:1511 X46/D1:neg 0.866667
RRED1033 DVDD:1513 DVDD:1515 0.114324
RRED1034 DVDD:1513 X46/D1:neg 0.866667
RRED1035 DVDD:1515 DVDD:1517 0.114243
RRED1036 DVDD:1515 X46/D1:neg 0.866667
RRED1037 DVDD:1517 DVDD:1519 0.114324
RRED1038 DVDD:1517 X46/D1:neg 0.866667
RRED1039 DVDD:1519 DVDD:1521 0.114324
RRED1040 DVDD:1519 X46/D1:neg 0.866667
RRED1041 DVDD:1521 DVDD:1523 0.114324
RRED1042 DVDD:1521 X46/D1:neg 0.866667
RRED1043 DVDD:1523 DVDD:1529 0.114324
RRED1044 DVDD:1523 DVDD:4089 0.45
RRED1045 DVDD:1523 X46/D1:neg 0.288889
RRED1046 DVDD:15249 DVDD:15258 0.412087
RRED1047 DVDD:15249 DVDD:4225 0.464528
RRED1048 DVDD:15258 DVDD:15277 0.109843
RRED1049 DVDD:15258 DVDD:1943 0.28125
RRED1050 DVDD:15277 DVDD:15301 0.105591
RRED1051 DVDD:1529 DVDD:1531 0.114324
RRED1052 DVDD:1529 X46/D1:neg 0.866667
RRED1053 DVDD:15301 DVDD:15322 0.105591
RRED1054 DVDD:1531 DVDD:1533 0.114324
RRED1055 DVDD:1531 X46/D1:neg 0.866667
RRED1056 DVDD:15322 DVDD:15343 0.36815
RRED1057 DVDD:1533 DVDD:1535 0.114324
RRED1058 DVDD:1533 X46/D1:neg 0.866667
RRED1059 DVDD:15343 DVDD:15352 0.106654
RRED1060 DVDD:1535 DVDD:1537 0.114324
RRED1061 DVDD:1535 X46/D1:neg 0.866667
RRED1062 DVDD:15352 DVDD:15373 1.26248
RRED1063 DVDD:1537 DVDD:1539 0.114324
RRED1064 DVDD:1537 X46/D1:neg 0.866667
RRED1065 DVDD:15373 DVDD:15385 0.129685
RRED1066 DVDD:15385 DVDD:15406 0.369213
RRED1067 DVDD:1539 DVDD:1545 0.114324
RRED1068 DVDD:1539 DVDD:4057 0.45
RRED1069 DVDD:1539 X46/D1:neg 0.288889
RRED1070 DVDD:15435 DVDD:15456 0.127559
RRED1071 DVDD:1545 DVDD:1547 0.114324
RRED1072 DVDD:1545 X46/D1:neg 0.866667
RRED1073 DVDD:1547 DVDD:1549 0.114324
RRED1074 DVDD:1547 X46/D1:neg 0.866667
RRED1075 DVDD:1549 DVDD:1551 0.114324
RRED1076 DVDD:1549 X46/D1:neg 0.866667
RRED1077 DVDD:1551 X46/D1:neg 0.866667
RRED1078 DVDD:1791 DVDD:1793 0.114324
RRED1079 DVDD:1791 X46/D1:neg 0.866667
RRED1080 DVDD:1793 DVDD:1795 0.114324
RRED1081 DVDD:1793 X46/D1:neg 0.866667
RRED1082 DVDD:1795 DVDD:1803 0.114324
RRED1083 DVDD:1795 DVDD:4161 0.45
RRED1084 DVDD:1795 X46/D1:neg 0.21666675
RRED1085 DVDD:1803 DVDD:1805 0.114324
RRED1086 DVDD:1803 X46/D1:neg 0.866667
RRED1087 DVDD:1805 DVDD:1807 0.114324
RRED1088 DVDD:1805 X46/D1:neg 0.866667
RRED1089 DVDD:1807 DVDD:1809 0.114324
RRED1090 DVDD:1807 X46/D1:neg 0.866667
RRED1091 DVDD:1809 DVDD:1811 0.114324
RRED1092 DVDD:1809 X46/D1:neg 0.866667
RRED1093 DVDD:1811 DVDD:1819 0.114324
RRED1094 DVDD:1811 DVDD:4129 0.45
RRED1095 DVDD:1811 X46/D1:neg 0.21666675
RRED1096 DVDD:1819 DVDD:1821 0.114324
RRED1097 DVDD:1819 X46/D1:neg 0.866667
RRED1098 DVDD:1821 DVDD:1823 0.114324
RRED1099 DVDD:1821 X46/D1:neg 0.866667
RRED1100 DVDD:1823 DVDD:1825 0.114243
RRED1101 DVDD:1823 X46/D1:neg 0.866667
RRED1102 DVDD:1825 DVDD:1827 0.114324
RRED1103 DVDD:1825 X46/D1:neg 0.866667
RRED1104 DVDD:1827 DVDD:1829 0.114324
RRED1105 DVDD:1827 X46/D1:neg 0.866667
RRED1106 DVDD:1829 DVDD:1831 0.114324
RRED1107 DVDD:1829 X46/D1:neg 0.866667
RRED1108 DVDD:1831 DVDD:1837 0.114324
RRED1109 DVDD:1831 DVDD:4097 0.45
RRED1110 DVDD:1831 X46/D1:neg 0.288889
RRED1111 DVDD:1837 DVDD:1839 0.114324
RRED1112 DVDD:1837 X46/D1:neg 0.866667
RRED1113 DVDD:1839 DVDD:1841 0.114324
RRED1114 DVDD:1839 X46/D1:neg 0.866667
RRED1115 DVDD:1841 DVDD:1843 0.114324
RRED1116 DVDD:1841 X46/D1:neg 0.866667
RRED1117 DVDD:1843 DVDD:1845 0.114324
RRED1118 DVDD:1843 X46/D1:neg 0.866667
RRED1119 DVDD:1845 DVDD:1847 0.114324
RRED1120 DVDD:1845 X46/D1:neg 0.866667
RRED1121 DVDD:1847 DVDD:1853 0.114324
RRED1122 DVDD:1847 DVDD:4065 0.45
RRED1123 DVDD:1847 X46/D1:neg 0.288889
RRED1124 DVDD:1853 DVDD:1855 0.114324
RRED1125 DVDD:1853 X46/D1:neg 0.866667
RRED1126 DVDD:1855 DVDD:1857 0.114324
RRED1127 DVDD:1855 X46/D1:neg 0.866667
RRED1128 DVDD:1857 DVDD:1859 0.114324
RRED1129 DVDD:1857 X46/D1:neg 0.866667
RRED1130 DVDD:1859 X46/D1:neg 0.866667
RRED1131 DVDD:1943 DVDD:4037 0.28125
RRED1132 DVDD:1943 DVDD:4055 0.28125
RRED1133 DVDD:1943 DVDD:4087 0.28125
RRED1134 DVDD:1943 DVDD:4119 0.28125
RRED1135 DVDD:1943 DVDD:4151 0.28125
RRED1136 DVDD:1943 DVDD:4225 0.28125
RRED1137 DVDD:1943 X46/D0:neg 0.00287292952331006
RRED1138 DVDD:3979 DVDD:4037 0.256713
RRED1139 DVDD:4055 DVDD:4057 0.232087
RRED1140 DVDD:4057 DVDD:4059 0.225531
RRED1141 DVDD:4059 DVDD:4061 0.24874
RRED1142 DVDD:4061 DVDD:4063 0.24874
RRED1143 DVDD:4063 DVDD:4065 0.225531
RRED1144 DVDD:4087 DVDD:4089 0.232087
RRED1145 DVDD:4089 DVDD:4091 0.225531
RRED1146 DVDD:4091 DVDD:4093 0.24874
RRED1147 DVDD:4093 DVDD:4095 0.24874
RRED1148 DVDD:4095 DVDD:4097 0.225531
RRED1149 DVDD:4119 DVDD:4121 0.232087
RRED1150 DVDD:4121 DVDD:4123 0.225531
RRED1151 DVDD:4123 DVDD:4125 0.24874
RRED1152 DVDD:4125 DVDD:4127 0.24874
RRED1153 DVDD:4127 DVDD:4129 0.225531
RRED1154 DVDD:4151 DVDD:4153 0.232087
RRED1155 DVDD:4153 DVDD:4155 0.225531
RRED1156 DVDD:4155 DVDD:4157 0.24874
RRED1157 DVDD:4157 DVDD:4159 0.24874
RRED1158 DVDD:4159 DVDD:4161 0.225531
RRED1159 DVDD:4167 DVDD:4225 0.256713
RRED1160 DVDD:4833 DVDD:4836 0.377206
RRED1161 DVDD:4833 DVDD:4859 1.73333
RRED1162 DVDD:4836 DVDD:4839 0.377206
RRED1163 DVDD:4836 DVDD:4859 1.73333
RRED1164 DVDD:4839 DVDD:4859 1.73333
RRED1165 DVDD:4844 DVDD:4847 0.377206
RRED1166 DVDD:4844 DVDD:4867 1.73333
RRED1167 DVDD:4847 DVDD:4850 0.377206
RRED1168 DVDD:4847 DVDD:4867 1.73333
RRED1169 DVDD:4850 DVDD:4867 1.73333
RRED1170 DVDD:4859 X48/X1/X0/C0:pos 3.65613
RRED1171 DVDD:4867 X48/X1/X0/C0:pos 3.6566
RRED1172 DVDD:4895 DVDD:4898 0.377206
RRED1173 DVDD:4895 DVDD:4920 0.490911
RRED1174 DVDD:4895 DVDD:4921 1.73333
RRED1175 DVDD:4898 DVDD:4901 0.377206
RRED1176 DVDD:4898 DVDD:4921 1.73333
RRED1177 DVDD:4901 DVDD:4921 1.73333
RRED1178 DVDD:4906 DVDD:4909 0.377206
RRED1179 DVDD:4906 DVDD:4928 0.490893
RRED1180 DVDD:4906 DVDD:4929 1.73333
RRED1181 DVDD:4909 DVDD:4912 0.377206
RRED1182 DVDD:4909 DVDD:4929 1.73333
RRED1183 DVDD:4912 DVDD:4929 1.73333
RRED1184 DVDD:4920 DVDD:4921 0.433333
RRED1185 DVDD:4920 DVDD:4928 0.280062
RRED1186 DVDD:4921 X48/X1/X1/C0:pos 3.65613
RRED1187 DVDD:4928 DVDD:4929 0.433333
RRED1188 DVDD:4929 X48/X1/X1/C0:pos 3.6566
RRED1189 DVDD:5005 DVDD:5008 0.377206
RRED1190 DVDD:5005 DVDD:5031 1.73333
RRED1191 DVDD:5008 DVDD:5011 0.377206
RRED1192 DVDD:5008 DVDD:5031 1.73333
RRED1193 DVDD:5011 DVDD:5031 1.73333
RRED1194 DVDD:5011 DVDD:5046 0.236794
RRED1195 DVDD:5016 DVDD:5019 0.377206
RRED1196 DVDD:5016 DVDD:5039 1.73333
RRED1197 DVDD:5019 DVDD:5022 0.377206
RRED1198 DVDD:5019 DVDD:5039 1.73333
RRED1199 DVDD:5022 DVDD:5039 1.73333
RRED1200 DVDD:5022 DVDD:5054 0.236776
RRED1201 DVDD:5031 DVDD:5046 0.52
RRED1202 DVDD:5031 X48/X2/X0/C0:pos 3.65613
RRED1203 DVDD:5039 DVDD:5054 0.52
RRED1204 DVDD:5039 X48/X2/X0/C0:pos 3.6566
RRED1205 DVDD:5046 DVDD:5054 0.280062
RRED1206 DVDD:5067 DVDD:5070 0.377206
RRED1207 DVDD:5067 DVDD:5093 1.73333
RRED1208 DVDD:5070 DVDD:5073 0.377206
RRED1209 DVDD:5070 DVDD:5093 1.73333
RRED1210 DVDD:5073 DVDD:5093 1.73333
RRED1211 DVDD:5078 DVDD:5081 0.377206
RRED1212 DVDD:5078 DVDD:5101 1.73333
RRED1213 DVDD:5081 DVDD:5084 0.377206
RRED1214 DVDD:5081 DVDD:5101 1.73333
RRED1215 DVDD:5084 DVDD:5101 1.73333
RRED1216 DVDD:5093 X48/X2/X1/C0:pos 3.65613
RRED1217 DVDD:5101 X48/X2/X1/C0:pos 3.6566
RRED1218 DVDD:5283 DVDD:5286 0.377206
RRED1219 DVDD:5283 DVDD:5309 1.73333
RRED1220 DVDD:5286 DVDD:5289 0.377206
RRED1221 DVDD:5286 DVDD:5309 1.73333
RRED1222 DVDD:5289 DVDD:5309 1.73333
RRED1223 DVDD:5294 DVDD:5297 0.377206
RRED1224 DVDD:5294 DVDD:5317 1.73333
RRED1225 DVDD:5297 DVDD:5300 0.377206
RRED1226 DVDD:5297 DVDD:5317 1.73333
RRED1227 DVDD:5300 DVDD:5317 1.73333
RRED1228 DVDD:5309 X49/X0/X1/X0/C0:pos 3.65613
RRED1229 DVDD:5317 X49/X0/X1/X0/C0:pos 3.6566
RRED1230 DVDD:5345 DVDD:5348 0.377206
RRED1231 DVDD:5345 DVDD:5370 0.490911
RRED1232 DVDD:5345 DVDD:5371 1.73333
RRED1233 DVDD:5348 DVDD:5351 0.377206
RRED1234 DVDD:5348 DVDD:5371 1.73333
RRED1235 DVDD:5351 DVDD:5371 1.73333
RRED1236 DVDD:5356 DVDD:5359 0.377206
RRED1237 DVDD:5356 DVDD:5378 0.490893
RRED1238 DVDD:5356 DVDD:5379 1.73333
RRED1239 DVDD:5359 DVDD:5362 0.377206
RRED1240 DVDD:5359 DVDD:5379 1.73333
RRED1241 DVDD:5362 DVDD:5379 1.73333
RRED1242 DVDD:5370 DVDD:5371 0.433333
RRED1243 DVDD:5370 DVDD:5378 0.280062
RRED1244 DVDD:5371 X49/X0/X1/X1/C0:pos 3.65613
RRED1245 DVDD:5378 DVDD:5379 0.433333
RRED1246 DVDD:5379 X49/X0/X1/X1/C0:pos 3.6566
RRED1247 DVDD:5455 DVDD:5458 0.377206
RRED1248 DVDD:5455 DVDD:5481 1.73333
RRED1249 DVDD:5458 DVDD:5461 0.377206
RRED1250 DVDD:5458 DVDD:5481 1.73333
RRED1251 DVDD:5461 DVDD:5481 1.73333
RRED1252 DVDD:5461 DVDD:5496 0.236794
RRED1253 DVDD:5466 DVDD:5469 0.377206
RRED1254 DVDD:5466 DVDD:5489 1.73333
RRED1255 DVDD:5469 DVDD:5472 0.377206
RRED1256 DVDD:5469 DVDD:5489 1.73333
RRED1257 DVDD:5472 DVDD:5489 1.73333
RRED1258 DVDD:5472 DVDD:5504 0.236776
RRED1259 DVDD:5481 DVDD:5496 0.52
RRED1260 DVDD:5481 X49/X0/X2/X0/C0:pos 3.65613
RRED1261 DVDD:5489 DVDD:5504 0.52
RRED1262 DVDD:5489 X49/X0/X2/X0/C0:pos 3.6566
RRED1263 DVDD:5496 DVDD:5504 0.280062
RRED1264 DVDD:5517 DVDD:5520 0.377206
RRED1265 DVDD:5517 DVDD:5543 1.73333
RRED1266 DVDD:5520 DVDD:5523 0.377206
RRED1267 DVDD:5520 DVDD:5543 1.73333
RRED1268 DVDD:5523 DVDD:5543 1.73333
RRED1269 DVDD:5528 DVDD:5531 0.377206
RRED1270 DVDD:5528 DVDD:5551 1.73333
RRED1271 DVDD:5531 DVDD:5534 0.377206
RRED1272 DVDD:5531 DVDD:5551 1.73333
RRED1273 DVDD:5534 DVDD:5551 1.73333
RRED1274 DVDD:5543 X49/X0/X2/X1/C0:pos 3.65613
RRED1275 DVDD:5551 X49/X0/X2/X1/C0:pos 3.6566
RRED1276 DVDD:5733 DVDD:5736 0.377206
RRED1277 DVDD:5733 DVDD:5759 1.73333
RRED1278 DVDD:5736 DVDD:5739 0.377206
RRED1279 DVDD:5736 DVDD:5759 1.73333
RRED1280 DVDD:5739 DVDD:5759 1.73333
RRED1281 DVDD:5744 DVDD:5747 0.377206
RRED1282 DVDD:5744 DVDD:5767 1.73333
RRED1283 DVDD:5747 DVDD:5750 0.377206
RRED1284 DVDD:5747 DVDD:5767 1.73333
RRED1285 DVDD:5750 DVDD:5767 1.73333
RRED1286 DVDD:5759 X49/X1/X1/X0/C0:pos 3.65613
RRED1287 DVDD:5767 X49/X1/X1/X0/C0:pos 3.6566
RRED1288 DVDD:5795 DVDD:5798 0.377206
RRED1289 DVDD:5795 DVDD:5820 0.490911
RRED1290 DVDD:5795 DVDD:5821 1.73333
RRED1291 DVDD:5798 DVDD:5801 0.377206
RRED1292 DVDD:5798 DVDD:5821 1.73333
RRED1293 DVDD:5801 DVDD:5821 1.73333
RRED1294 DVDD:5806 DVDD:5809 0.377206
RRED1295 DVDD:5806 DVDD:5828 0.490893
RRED1296 DVDD:5806 DVDD:5829 1.73333
RRED1297 DVDD:5809 DVDD:5812 0.377206
RRED1298 DVDD:5809 DVDD:5829 1.73333
RRED1299 DVDD:5812 DVDD:5829 1.73333
RRED1300 DVDD:5820 DVDD:5821 0.433333
RRED1301 DVDD:5820 DVDD:5828 0.280062
RRED1302 DVDD:5821 X49/X1/X1/X1/C0:pos 3.65613
RRED1303 DVDD:5828 DVDD:5829 0.433333
RRED1304 DVDD:5829 X49/X1/X1/X1/C0:pos 3.6566
RRED1305 DVDD:5905 DVDD:5908 0.377206
RRED1306 DVDD:5905 DVDD:5931 1.73333
RRED1307 DVDD:5908 DVDD:5911 0.377206
RRED1308 DVDD:5908 DVDD:5931 1.73333
RRED1309 DVDD:5911 DVDD:5931 1.73333
RRED1310 DVDD:5911 DVDD:5946 0.236794
RRED1311 DVDD:5916 DVDD:5919 0.377206
RRED1312 DVDD:5916 DVDD:5939 1.73333
RRED1313 DVDD:5919 DVDD:5922 0.377206
RRED1314 DVDD:5919 DVDD:5939 1.73333
RRED1315 DVDD:5922 DVDD:5939 1.73333
RRED1316 DVDD:5922 DVDD:5954 0.236776
RRED1317 DVDD:5931 DVDD:5946 0.52
RRED1318 DVDD:5931 X49/X1/X2/X0/C0:pos 3.65613
RRED1319 DVDD:5939 DVDD:5954 0.52
RRED1320 DVDD:5939 X49/X1/X2/X0/C0:pos 3.6566
RRED1321 DVDD:5946 DVDD:5954 0.280062
RRED1322 DVDD:5967 DVDD:5970 0.377206
RRED1323 DVDD:5967 DVDD:5993 1.73333
RRED1324 DVDD:5970 DVDD:5973 0.377206
RRED1325 DVDD:5970 DVDD:5993 1.73333
RRED1326 DVDD:5973 DVDD:5993 1.73333
RRED1327 DVDD:5978 DVDD:5981 0.377206
RRED1328 DVDD:5978 DVDD:6001 1.73333
RRED1329 DVDD:5981 DVDD:5984 0.377206
RRED1330 DVDD:5981 DVDD:6001 1.73333
RRED1331 DVDD:5984 DVDD:6001 1.73333
RRED1332 DVDD:5993 X49/X1/X2/X1/C0:pos 3.65613
RRED1333 DVDD:6001 X49/X1/X2/X1/C0:pos 3.6566
RRED1334 DVDD:6327 DVDD:6330 0.377206
RRED1335 DVDD:6327 DVDD:6353 1.73333
RRED1336 DVDD:6330 DVDD:6333 0.377206
RRED1337 DVDD:6330 DVDD:6353 1.73333
RRED1338 DVDD:6333 DVDD:6353 1.73333
RRED1339 DVDD:6338 DVDD:6341 0.377206
RRED1340 DVDD:6338 DVDD:6361 1.73333
RRED1341 DVDD:6341 DVDD:6344 0.377206
RRED1342 DVDD:6341 DVDD:6361 1.73333
RRED1343 DVDD:6344 DVDD:6361 1.73333
RRED1344 DVDD:6353 X50/X0/X1/X0/C0:pos 3.65613
RRED1345 DVDD:6361 X50/X0/X1/X0/C0:pos 3.6566
RRED1346 DVDD:6389 DVDD:6392 0.377206
RRED1347 DVDD:6389 DVDD:6414 0.490911
RRED1348 DVDD:6389 DVDD:6415 1.73333
RRED1349 DVDD:6392 DVDD:6395 0.377206
RRED1350 DVDD:6392 DVDD:6415 1.73333
RRED1351 DVDD:6395 DVDD:6415 1.73333
RRED1352 DVDD:6400 DVDD:6403 0.377206
RRED1353 DVDD:6400 DVDD:6422 0.490893
RRED1354 DVDD:6400 DVDD:6423 1.73333
RRED1355 DVDD:6403 DVDD:6406 0.377206
RRED1356 DVDD:6403 DVDD:6423 1.73333
RRED1357 DVDD:6406 DVDD:6423 1.73333
RRED1358 DVDD:6414 DVDD:6415 0.433333
RRED1359 DVDD:6414 DVDD:6422 0.280062
RRED1360 DVDD:6415 X50/X0/X1/X1/C0:pos 3.65613
RRED1361 DVDD:6422 DVDD:6423 0.433333
RRED1362 DVDD:6423 X50/X0/X1/X1/C0:pos 3.6566
RRED1363 DVDD:6499 DVDD:6502 0.377206
RRED1364 DVDD:6499 DVDD:6525 1.73333
RRED1365 DVDD:6502 DVDD:6505 0.377206
RRED1366 DVDD:6502 DVDD:6525 1.73333
RRED1367 DVDD:6505 DVDD:6525 1.73333
RRED1368 DVDD:6505 DVDD:6540 0.236794
RRED1369 DVDD:6510 DVDD:6513 0.377206
RRED1370 DVDD:6510 DVDD:6533 1.73333
RRED1371 DVDD:6513 DVDD:6516 0.377206
RRED1372 DVDD:6513 DVDD:6533 1.73333
RRED1373 DVDD:6516 DVDD:6533 1.73333
RRED1374 DVDD:6516 DVDD:6548 0.236776
RRED1375 DVDD:6525 DVDD:6540 0.52
RRED1376 DVDD:6525 X50/X0/X2/X0/C0:pos 3.65613
RRED1377 DVDD:6533 DVDD:6548 0.52
RRED1378 DVDD:6533 X50/X0/X2/X0/C0:pos 3.6566
RRED1379 DVDD:6540 DVDD:6548 0.280062
RRED1380 DVDD:6561 DVDD:6564 0.377206
RRED1381 DVDD:6561 DVDD:6587 1.73333
RRED1382 DVDD:6564 DVDD:6567 0.377206
RRED1383 DVDD:6564 DVDD:6587 1.73333
RRED1384 DVDD:6567 DVDD:6587 1.73333
RRED1385 DVDD:6572 DVDD:6575 0.377206
RRED1386 DVDD:6572 DVDD:6595 1.73333
RRED1387 DVDD:6575 DVDD:6578 0.377206
RRED1388 DVDD:6575 DVDD:6595 1.73333
RRED1389 DVDD:6578 DVDD:6595 1.73333
RRED1390 DVDD:6587 X50/X0/X2/X1/C0:pos 3.65613
RRED1391 DVDD:6595 X50/X0/X2/X1/C0:pos 3.6566
RRED1392 DVDD:6777 DVDD:6780 0.377206
RRED1393 DVDD:6777 DVDD:6803 1.73333
RRED1394 DVDD:6780 DVDD:6783 0.377206
RRED1395 DVDD:6780 DVDD:6803 1.73333
RRED1396 DVDD:6783 DVDD:6803 1.73333
RRED1397 DVDD:6788 DVDD:6791 0.377206
RRED1398 DVDD:6788 DVDD:6811 1.73333
RRED1399 DVDD:6791 DVDD:6794 0.377206
RRED1400 DVDD:6791 DVDD:6811 1.73333
RRED1401 DVDD:6794 DVDD:6811 1.73333
RRED1402 DVDD:6803 X50/X1/X1/X0/C0:pos 3.65613
RRED1403 DVDD:6811 X50/X1/X1/X0/C0:pos 3.6566
RRED1404 DVDD:6839 DVDD:6842 0.377206
RRED1405 DVDD:6839 DVDD:6864 0.490911
RRED1406 DVDD:6839 DVDD:6865 1.73333
RRED1407 DVDD:6842 DVDD:6845 0.377206
RRED1408 DVDD:6842 DVDD:6865 1.73333
RRED1409 DVDD:6845 DVDD:6865 1.73333
RRED1410 DVDD:6850 DVDD:6853 0.377206
RRED1411 DVDD:6850 DVDD:6872 0.490893
RRED1412 DVDD:6850 DVDD:6873 1.73333
RRED1413 DVDD:6853 DVDD:6856 0.377206
RRED1414 DVDD:6853 DVDD:6873 1.73333
RRED1415 DVDD:6856 DVDD:6873 1.73333
RRED1416 DVDD:6864 DVDD:6865 0.433333
RRED1417 DVDD:6864 DVDD:6872 0.280062
RRED1418 DVDD:6865 X50/X1/X1/X1/C0:pos 3.65613
RRED1419 DVDD:6872 DVDD:6873 0.433333
RRED1420 DVDD:6873 X50/X1/X1/X1/C0:pos 3.6566
RRED1421 DVDD:6949 DVDD:6952 0.377206
RRED1422 DVDD:6949 DVDD:6975 1.73333
RRED1423 DVDD:6952 DVDD:6955 0.377206
RRED1424 DVDD:6952 DVDD:6975 1.73333
RRED1425 DVDD:6955 DVDD:6975 1.73333
RRED1426 DVDD:6955 DVDD:6990 0.236794
RRED1427 DVDD:6960 DVDD:6963 0.377206
RRED1428 DVDD:6960 DVDD:6983 1.73333
RRED1429 DVDD:6963 DVDD:6966 0.377206
RRED1430 DVDD:6963 DVDD:6983 1.73333
RRED1431 DVDD:6966 DVDD:6983 1.73333
RRED1432 DVDD:6966 DVDD:6998 0.236776
RRED1433 DVDD:6975 DVDD:6990 0.52
RRED1434 DVDD:6975 X50/X1/X2/X0/C0:pos 3.65613
RRED1435 DVDD:6983 DVDD:6998 0.52
RRED1436 DVDD:6983 X50/X1/X2/X0/C0:pos 3.6566
RRED1437 DVDD:6990 DVDD:6998 0.280062
RRED1438 DVDD:7011 DVDD:7014 0.377206
RRED1439 DVDD:7011 DVDD:7037 1.73333
RRED1440 DVDD:7014 DVDD:7017 0.377206
RRED1441 DVDD:7014 DVDD:7037 1.73333
RRED1442 DVDD:7017 DVDD:7037 1.73333
RRED1443 DVDD:7022 DVDD:7025 0.377206
RRED1444 DVDD:7022 DVDD:7045 1.73333
RRED1445 DVDD:7025 DVDD:7028 0.377206
RRED1446 DVDD:7025 DVDD:7045 1.73333
RRED1447 DVDD:7028 DVDD:7045 1.73333
RRED1448 DVDD:7037 X50/X1/X2/X1/C0:pos 3.65613
RRED1449 DVDD:7045 X50/X1/X2/X1/C0:pos 3.6566
RRED1450 DVDD:7371 DVDD:7374 0.377206
RRED1451 DVDD:7371 DVDD:7397 1.73333
RRED1452 DVDD:7374 DVDD:7377 0.377206
RRED1453 DVDD:7374 DVDD:7397 1.73333
RRED1454 DVDD:7377 DVDD:7397 1.73333
RRED1455 DVDD:7382 DVDD:7385 0.377206
RRED1456 DVDD:7382 DVDD:7405 1.73333
RRED1457 DVDD:7385 DVDD:7388 0.377206
RRED1458 DVDD:7385 DVDD:7405 1.73333
RRED1459 DVDD:7388 DVDD:7405 1.73333
RRED1460 DVDD:7397 X51/X0/X1/X0/C0:pos 3.65613
RRED1461 DVDD:7405 X51/X0/X1/X0/C0:pos 3.6566
RRED1462 DVDD:7433 DVDD:7436 0.377206
RRED1463 DVDD:7433 DVDD:7458 0.490911
RRED1464 DVDD:7433 DVDD:7459 1.73333
RRED1465 DVDD:7436 DVDD:7439 0.377206
RRED1466 DVDD:7436 DVDD:7459 1.73333
RRED1467 DVDD:7439 DVDD:7459 1.73333
RRED1468 DVDD:7444 DVDD:7447 0.377206
RRED1469 DVDD:7444 DVDD:7466 0.490893
RRED1470 DVDD:7444 DVDD:7467 1.73333
RRED1471 DVDD:7447 DVDD:7450 0.377206
RRED1472 DVDD:7447 DVDD:7467 1.73333
RRED1473 DVDD:7450 DVDD:7467 1.73333
RRED1474 DVDD:7458 DVDD:7459 0.433333
RRED1475 DVDD:7458 DVDD:7466 0.280062
RRED1476 DVDD:7459 X51/X0/X1/X1/C0:pos 3.65613
RRED1477 DVDD:7466 DVDD:7467 0.433333
RRED1478 DVDD:7467 X51/X0/X1/X1/C0:pos 3.6566
RRED1479 DVDD:7543 DVDD:7546 0.377206
RRED1480 DVDD:7543 DVDD:7569 1.73333
RRED1481 DVDD:7546 DVDD:7549 0.377206
RRED1482 DVDD:7546 DVDD:7569 1.73333
RRED1483 DVDD:7549 DVDD:7569 1.73333
RRED1484 DVDD:7549 DVDD:7584 0.236794
RRED1485 DVDD:7554 DVDD:7557 0.377206
RRED1486 DVDD:7554 DVDD:7577 1.73333
RRED1487 DVDD:7557 DVDD:7560 0.377206
RRED1488 DVDD:7557 DVDD:7577 1.73333
RRED1489 DVDD:7560 DVDD:7577 1.73333
RRED1490 DVDD:7560 DVDD:7592 0.236776
RRED1491 DVDD:7569 DVDD:7584 0.52
RRED1492 DVDD:7569 X51/X0/X2/X0/C0:pos 3.65613
RRED1493 DVDD:7577 DVDD:7592 0.52
RRED1494 DVDD:7577 X51/X0/X2/X0/C0:pos 3.6566
RRED1495 DVDD:7584 DVDD:7592 0.280062
RRED1496 DVDD:7605 DVDD:7608 0.377206
RRED1497 DVDD:7605 DVDD:7631 1.73333
RRED1498 DVDD:7608 DVDD:7611 0.377206
RRED1499 DVDD:7608 DVDD:7631 1.73333
RRED1500 DVDD:7611 DVDD:7631 1.73333
RRED1501 DVDD:7616 DVDD:7619 0.377206
RRED1502 DVDD:7616 DVDD:7639 1.73333
RRED1503 DVDD:7619 DVDD:7622 0.377206
RRED1504 DVDD:7619 DVDD:7639 1.73333
RRED1505 DVDD:7622 DVDD:7639 1.73333
RRED1506 DVDD:7631 X51/X0/X2/X1/C0:pos 3.65613
RRED1507 DVDD:7639 X51/X0/X2/X1/C0:pos 3.6566
RRED1508 DVDD:7821 DVDD:7824 0.377206
RRED1509 DVDD:7821 DVDD:7847 1.73333
RRED1510 DVDD:7824 DVDD:7827 0.377206
RRED1511 DVDD:7824 DVDD:7847 1.73333
RRED1512 DVDD:7827 DVDD:7847 1.73333
RRED1513 DVDD:7832 DVDD:7835 0.377206
RRED1514 DVDD:7832 DVDD:7855 1.73333
RRED1515 DVDD:7835 DVDD:7838 0.377206
RRED1516 DVDD:7835 DVDD:7855 1.73333
RRED1517 DVDD:7838 DVDD:7855 1.73333
RRED1518 DVDD:7847 X51/X1/X1/X0/C0:pos 3.65613
RRED1519 DVDD:7855 X51/X1/X1/X0/C0:pos 3.6566
RRED1520 DVDD:7883 DVDD:7886 0.377206
RRED1521 DVDD:7883 DVDD:7908 0.490911
RRED1522 DVDD:7883 DVDD:7909 1.73333
RRED1523 DVDD:7886 DVDD:7889 0.377206
RRED1524 DVDD:7886 DVDD:7909 1.73333
RRED1525 DVDD:7889 DVDD:7909 1.73333
RRED1526 DVDD:7894 DVDD:7897 0.377206
RRED1527 DVDD:7894 DVDD:7916 0.490893
RRED1528 DVDD:7894 DVDD:7917 1.73333
RRED1529 DVDD:7897 DVDD:7900 0.377206
RRED1530 DVDD:7897 DVDD:7917 1.73333
RRED1531 DVDD:7900 DVDD:7917 1.73333
RRED1532 DVDD:7908 DVDD:7909 0.433333
RRED1533 DVDD:7908 DVDD:7916 0.280062
RRED1534 DVDD:7909 X51/X1/X1/X1/C0:pos 3.65613
RRED1535 DVDD:7916 DVDD:7917 0.433333
RRED1536 DVDD:7917 X51/X1/X1/X1/C0:pos 3.6566
RRED1537 DVDD:7993 DVDD:7996 0.377206
RRED1538 DVDD:7993 DVDD:8019 1.73333
RRED1539 DVDD:7996 DVDD:7999 0.377206
RRED1540 DVDD:7996 DVDD:8019 1.73333
RRED1541 DVDD:7999 DVDD:8019 1.73333
RRED1542 DVDD:7999 DVDD:8034 0.236794
RRED1543 DVDD:8004 DVDD:8007 0.377206
RRED1544 DVDD:8004 DVDD:8027 1.73333
RRED1545 DVDD:8007 DVDD:8010 0.377206
RRED1546 DVDD:8007 DVDD:8027 1.73333
RRED1547 DVDD:8010 DVDD:8027 1.73333
RRED1548 DVDD:8010 DVDD:8042 0.236776
RRED1549 DVDD:8019 DVDD:8034 0.52
RRED1550 DVDD:8019 X51/X1/X2/X0/C0:pos 3.65613
RRED1551 DVDD:8027 DVDD:8042 0.52
RRED1552 DVDD:8027 X51/X1/X2/X0/C0:pos 3.6566
RRED1553 DVDD:8034 DVDD:8042 0.280062
RRED1554 DVDD:8055 DVDD:8058 0.377206
RRED1555 DVDD:8055 DVDD:8081 1.73333
RRED1556 DVDD:8058 DVDD:8061 0.377206
RRED1557 DVDD:8058 DVDD:8081 1.73333
RRED1558 DVDD:8061 DVDD:8081 1.73333
RRED1559 DVDD:8066 DVDD:8069 0.377206
RRED1560 DVDD:8066 DVDD:8089 1.73333
RRED1561 DVDD:8069 DVDD:8072 0.377206
RRED1562 DVDD:8069 DVDD:8089 1.73333
RRED1563 DVDD:8072 DVDD:8089 1.73333
RRED1564 DVDD:8081 X51/X1/X2/X1/C0:pos 3.65613
RRED1565 DVDD:8089 X51/X1/X2/X1/C0:pos 3.6566
RRED1566 DVDD:8415 DVDD:8418 0.377206
RRED1567 DVDD:8415 DVDD:8441 1.73333
RRED1568 DVDD:8418 DVDD:8421 0.377206
RRED1569 DVDD:8418 DVDD:8441 1.73333
RRED1570 DVDD:8421 DVDD:8441 1.73333
RRED1571 DVDD:8426 DVDD:8429 0.377206
RRED1572 DVDD:8426 DVDD:8449 1.73333
RRED1573 DVDD:8429 DVDD:8432 0.377206
RRED1574 DVDD:8429 DVDD:8449 1.73333
RRED1575 DVDD:8432 DVDD:8449 1.73333
RRED1576 DVDD:8441 X52/X0/X1/X0/C0:pos 3.65613
RRED1577 DVDD:8449 X52/X0/X1/X0/C0:pos 3.6566
RRED1578 DVDD:8477 DVDD:8480 0.377206
RRED1579 DVDD:8477 DVDD:8502 0.490911
RRED1580 DVDD:8477 DVDD:8503 1.73333
RRED1581 DVDD:8480 DVDD:8483 0.377206
RRED1582 DVDD:8480 DVDD:8503 1.73333
RRED1583 DVDD:8483 DVDD:8503 1.73333
RRED1584 DVDD:8488 DVDD:8491 0.377206
RRED1585 DVDD:8488 DVDD:8510 0.490893
RRED1586 DVDD:8488 DVDD:8511 1.73333
RRED1587 DVDD:8491 DVDD:8494 0.377206
RRED1588 DVDD:8491 DVDD:8511 1.73333
RRED1589 DVDD:8494 DVDD:8511 1.73333
RRED1590 DVDD:8502 DVDD:8503 0.433333
RRED1591 DVDD:8502 DVDD:8510 0.280062
RRED1592 DVDD:8503 X52/X0/X1/X1/C0:pos 3.65613
RRED1593 DVDD:8510 DVDD:8511 0.433333
RRED1594 DVDD:8511 X52/X0/X1/X1/C0:pos 3.6566
RRED1595 DVDD:8587 DVDD:8590 0.377206
RRED1596 DVDD:8587 DVDD:8613 1.73333
RRED1597 DVDD:8590 DVDD:8593 0.377206
RRED1598 DVDD:8590 DVDD:8613 1.73333
RRED1599 DVDD:8593 DVDD:8613 1.73333
RRED1600 DVDD:8593 DVDD:8628 0.236794
RRED1601 DVDD:8598 DVDD:8601 0.377206
RRED1602 DVDD:8598 DVDD:8621 1.73333
RRED1603 DVDD:8601 DVDD:8604 0.377206
RRED1604 DVDD:8601 DVDD:8621 1.73333
RRED1605 DVDD:8604 DVDD:8621 1.73333
RRED1606 DVDD:8604 DVDD:8636 0.236776
RRED1607 DVDD:8613 DVDD:8628 0.52
RRED1608 DVDD:8613 X52/X0/X2/X0/C0:pos 3.65613
RRED1609 DVDD:8621 DVDD:8636 0.52
RRED1610 DVDD:8621 X52/X0/X2/X0/C0:pos 3.6566
RRED1611 DVDD:8628 DVDD:8636 0.280062
RRED1612 DVDD:8649 DVDD:8652 0.377206
RRED1613 DVDD:8649 DVDD:8675 1.73333
RRED1614 DVDD:8652 DVDD:8655 0.377206
RRED1615 DVDD:8652 DVDD:8675 1.73333
RRED1616 DVDD:8655 DVDD:8675 1.73333
RRED1617 DVDD:8660 DVDD:8663 0.377206
RRED1618 DVDD:8660 DVDD:8683 1.73333
RRED1619 DVDD:8663 DVDD:8666 0.377206
RRED1620 DVDD:8663 DVDD:8683 1.73333
RRED1621 DVDD:8666 DVDD:8683 1.73333
RRED1622 DVDD:8675 X52/X0/X2/X1/C0:pos 3.65613
RRED1623 DVDD:8683 X52/X0/X2/X1/C0:pos 3.6566
RRED1624 DVDD:8865 DVDD:8868 0.377206
RRED1625 DVDD:8865 DVDD:8891 1.73333
RRED1626 DVDD:8868 DVDD:8871 0.377206
RRED1627 DVDD:8868 DVDD:8891 1.73333
RRED1628 DVDD:8871 DVDD:8891 1.73333
RRED1629 DVDD:8876 DVDD:8879 0.377206
RRED1630 DVDD:8876 DVDD:8899 1.73333
RRED1631 DVDD:8879 DVDD:8882 0.377206
RRED1632 DVDD:8879 DVDD:8899 1.73333
RRED1633 DVDD:8882 DVDD:8899 1.73333
RRED1634 DVDD:8891 X52/X1/X1/X0/C0:pos 3.65613
RRED1635 DVDD:8899 X52/X1/X1/X0/C0:pos 3.6566
RRED1636 DVDD:8927 DVDD:8930 0.377206
RRED1637 DVDD:8927 DVDD:8952 0.490911
RRED1638 DVDD:8927 DVDD:8953 1.73333
RRED1639 DVDD:8930 DVDD:8933 0.377206
RRED1640 DVDD:8930 DVDD:8953 1.73333
RRED1641 DVDD:8933 DVDD:8953 1.73333
RRED1642 DVDD:8938 DVDD:8941 0.377206
RRED1643 DVDD:8938 DVDD:8960 0.490893
RRED1644 DVDD:8938 DVDD:8961 1.73333
RRED1645 DVDD:8941 DVDD:8944 0.377206
RRED1646 DVDD:8941 DVDD:8961 1.73333
RRED1647 DVDD:8944 DVDD:8961 1.73333
RRED1648 DVDD:8952 DVDD:8953 0.433333
RRED1649 DVDD:8952 DVDD:8960 0.280062
RRED1650 DVDD:8953 X52/X1/X1/X1/C0:pos 3.65613
RRED1651 DVDD:8960 DVDD:8961 0.433333
RRED1652 DVDD:8961 X52/X1/X1/X1/C0:pos 3.6566
RRED1653 DVDD:9037 DVDD:9040 0.377206
RRED1654 DVDD:9037 DVDD:9063 1.73333
RRED1655 DVDD:9040 DVDD:9043 0.377206
RRED1656 DVDD:9040 DVDD:9063 1.73333
RRED1657 DVDD:9043 DVDD:9063 1.73333
RRED1658 DVDD:9043 DVDD:9078 0.236794
RRED1659 DVDD:9048 DVDD:9051 0.377206
RRED1660 DVDD:9048 DVDD:9071 1.73333
RRED1661 DVDD:9051 DVDD:9054 0.377206
RRED1662 DVDD:9051 DVDD:9071 1.73333
RRED1663 DVDD:9054 DVDD:9071 1.73333
RRED1664 DVDD:9054 DVDD:9086 0.236776
RRED1665 DVDD:9063 DVDD:9078 0.52
RRED1666 DVDD:9063 X52/X1/X2/X0/C0:pos 3.65613
RRED1667 DVDD:9071 DVDD:9086 0.52
RRED1668 DVDD:9071 X52/X1/X2/X0/C0:pos 3.6566
RRED1669 DVDD:9078 DVDD:9086 0.280062
RRED1670 DVDD:9099 DVDD:9102 0.377206
RRED1671 DVDD:9099 DVDD:9125 1.73333
RRED1672 DVDD:9102 DVDD:9105 0.377206
RRED1673 DVDD:9102 DVDD:9125 1.73333
RRED1674 DVDD:9105 DVDD:9125 1.73333
RRED1675 DVDD:9110 DVDD:9113 0.377206
RRED1676 DVDD:9110 DVDD:9133 1.73333
RRED1677 DVDD:9113 DVDD:9116 0.377206
RRED1678 DVDD:9113 DVDD:9133 1.73333
RRED1679 DVDD:9116 DVDD:9133 1.73333
RRED1680 DVDD:9125 X52/X1/X2/X1/C0:pos 3.65613
RRED1681 DVDD:9133 X52/X1/X2/X1/C0:pos 3.6566
RRED1682 PAD PAD:100 0.000696163298797598
RRED1683 PAD:100 PAD:10009 0.000696163298797596
RRED1684 PAD:10009 PAD:3766 0.00069623970902395
RRED1685 VDD VDD:218 0.35669441556066
RRED1686 VDD VDD:221 1.5
RRED1687 VDD VDD:224 0.75
RRED1688 VDD VDD:230 0.75
RRED1689 VDD VDD:236 0.643983942101097
RRED1690 VDD:218 VDD:221 4.482
RRED1691 VDD:221 VDD:224 0.1116
RRED1692 VDD:224 VDD:230 0.1116
RRED1693 VDD:230 VDD:236 0.1116
CRED1 ASIG5V VSS 5.90404e-13
CRED2 ASIG5V:1257 VSS 3.69812e-14
CRED3 ASIG5V:1271 VSS 2.87583e-14
CRED4 ASIG5V:1273 VSS 3.68821e-14
CRED5 ASIG5V:1287 VSS 2.87596e-14
CRED6 ASIG5V:1289 VSS 3.60371e-14
CRED7 ASIG5V:1303 VSS 2.87583e-14
CRED8 ASIG5V:1305 VSS 3.67911e-14
CRED9 ASIG5V:1319 VSS 2.87295e-14
CRED10 ASIG5V:1321 VSS 3.67911e-14
CRED11 ASIG5V:1335 VSS 2.87295e-14
CRED12 ASIG5V:1337 VSS 3.60371e-14
CRED13 ASIG5V:1351 VSS 2.87583e-14
CRED14 ASIG5V:1353 VSS 3.68883e-14
CRED15 ASIG5V:1367 VSS 2.87641e-14
CRED16 ASIG5V:1369 VSS 3.69812e-14
CRED17 ASIG5V:138 VSS 7.73761e-15
CRED18 ASIG5V:1383 VSS 2.87583e-14
CRED19 ASIG5V:311 VSS 6.54488e-15
CRED20 ASIG5V:33 VSS 7.52148e-15
CRED21 ASIG5V:416 VSS 6.51082e-15
CRED22 ASIG5V:453 VSS 7.58192e-15
CRED23 ASIG5V:558 VSS 7.75131e-15
CRED24 ASIG5V:663 VSS 7.77059e-15
CRED25 ASIG5V:768 VSS 7.64287e-15
CRED26 D8:neg VSS 8.45741e-16
CRED27 DVDD VSS 6.3162421e-13
CRED28 DVDD:10 VSS 2.04786939e-14
CRED29 DVDD:101 VSS 6.35822e-15
CRED30 DVDD:1029 VSS 4.67570375e-14
CRED31 DVDD:10658 VSS 1.3718407e-14
CRED32 DVDD:10688 VSS 4.718475e-15
CRED33 DVDD:10717 VSS 3.212124e-15
CRED34 DVDD:11300 VSS 1.63982e-14
CRED35 DVDD:11562 VSS 2.66155e-14
CRED36 DVDD:11588 VSS 2.66155e-14
CRED37 DVDD:11631 VSS 6.45956e-15
CRED38 DVDD:11632 VSS 3.27132e-14
CRED39 DVDD:11708 VSS 3.27136e-14
CRED40 DVDD:11727 VSS 6.45956e-15
CRED41 DVDD:11823 VSS 6.35693e-15
CRED42 DVDD:11919 VSS 1.34269e-14
CRED43 DVDD:11954 VSS 1.37264e-14
CRED44 DVDD:11989 VSS 1.34264e-14
CRED45 DVDD:12024 VSS 1.39735e-14
CRED46 DVDD:12059 VSS 1.44612e-14
CRED47 DVDD:12060 VSS 3.66052e-14
CRED48 DVDD:12094 VSS 1.43236e-14
CRED49 DVDD:12129 VSS 1.44709e-14
CRED50 DVDD:12164 VSS 1.43793e-14
CRED51 DVDD:12199 VSS 1.38491e-14
CRED52 DVDD:12340 VSS 1.66536567e-14
CRED53 DVDD:12375 VSS 1.68309278e-14
CRED54 DVDD:12410 VSS 1.66579567e-14
CRED55 DVDD:12445 VSS 1.69765918e-14
CRED56 DVDD:12480 VSS 1.68959567e-14
CRED57 DVDD:12481 VSS 3.00321e-14
CRED58 DVDD:12515 VSS 1.6692491e-14
CRED59 DVDD:12550 VSS 1.68263369e-14
CRED60 DVDD:12585 VSS 1.6987223e-14
CRED61 DVDD:12620 VSS 1.68219369e-14
CRED62 DVDD:12796 VSS 3.00321e-14
CRED63 DVDD:13111 VSS 3.6606e-14
CRED64 DVDD:13285 VSS 1.2749258e-14
CRED65 DVDD:13320 VSS 1.2966329e-14
CRED66 DVDD:13355 VSS 1.2751658e-14
CRED67 DVDD:13390 VSS 1.3122993e-14
CRED68 DVDD:13425 VSS 1.2996658e-14
CRED69 DVDD:13426 VSS 3.19204e-14
CRED70 DVDD:13460 VSS 1.2750189e-14
CRED71 DVDD:13495 VSS 1.2915438e-14
CRED72 DVDD:13530 VSS 1.3089422e-14
CRED73 DVDD:13565 VSS 1.3039553e-14
CRED74 DVDD:13599 VSS 1.5884516e-14
CRED75 DVDD:13607 VSS 6.797878e-15
CRED76 DVDD:13626 VSS 4.50008e-15
CRED77 DVDD:13943 VSS 1.71363e-14
CRED78 DVDD:14039 VSS 2.34037e-14
CRED79 DVDD:14072 VSS 1.62203e-15
CRED80 DVDD:15277 VSS 1.71363e-14
CRED81 DVDD:15373 VSS 2.31914e-14
CRED82 DVDD:15406 VSS 1.61205e-15
CRED83 DVDD:15435 VSS 5.38399e-15
CRED84 DVDD:15456 VSS 2.82397e-14
CRED85 DVDD:1943 VSS 3.4583374e-14
CRED86 DVDD:3979 VSS 3.30042e-14
CRED87 DVDD:4065 VSS 3.71817e-14
CRED88 DVDD:4097 VSS 3.7308e-14
CRED89 DVDD:4129 VSS 3.7308e-14
CRED90 DVDD:4161 VSS 3.71713e-14
CRED91 DVDD:4167 VSS 3.30042e-14
CRED92 DVDD:4859 VSS 2.42548e-15
CRED93 DVDD:4867 VSS 2.39465e-15
CRED94 DVDD:4912 VSS 7.52146e-17
CRED95 DVDD:4921 VSS 2.44179e-15
CRED96 DVDD:4929 VSS 2.39663e-15
CRED97 DVDD:5022 VSS 7.52146e-17
CRED98 DVDD:5031 VSS 2.44179e-15
CRED99 DVDD:5039 VSS 2.39663e-15
CRED100 DVDD:5046 VSS 1.67651e-14
CRED101 DVDD:5054 VSS 5.68369e-17
CRED102 DVDD:5084 VSS 5.17893e-16
CRED103 DVDD:5093 VSS 2.42012e-15
CRED104 DVDD:5101 VSS 2.38986e-15
CRED105 DVDD:5309 VSS 2.40762e-15
CRED106 DVDD:5317 VSS 2.40119e-15
CRED107 DVDD:5362 VSS 7.24618e-17
CRED108 DVDD:5371 VSS 2.44391e-15
CRED109 DVDD:5379 VSS 2.40613e-15
CRED110 DVDD:5472 VSS 7.24618e-17
CRED111 DVDD:5481 VSS 2.43417e-15
CRED112 DVDD:5489 VSS 2.40796e-15
CRED113 DVDD:5496 VSS 1.65989e-14
CRED114 DVDD:5504 VSS 5.47567e-17
CRED115 DVDD:5534 VSS 6.02991e-16
CRED116 DVDD:5543 VSS 2.40762e-15
CRED117 DVDD:5551 VSS 2.40119e-15
CRED118 DVDD:5759 VSS 2.40979e-15
CRED119 DVDD:5767 VSS 2.40119e-15
CRED120 DVDD:5812 VSS 7.57318e-17
CRED121 DVDD:5821 VSS 2.44121e-15
CRED122 DVDD:5829 VSS 2.40429e-15
CRED123 DVDD:5922 VSS 7.57318e-17
CRED124 DVDD:5931 VSS 2.43633e-15
CRED125 DVDD:5939 VSS 2.40613e-15
CRED126 DVDD:5946 VSS 1.67737e-14
CRED127 DVDD:5954 VSS 5.72278e-17
CRED128 DVDD:5984 VSS 6.06261e-16
CRED129 DVDD:5993 VSS 2.40979e-15
CRED130 DVDD:6001 VSS 2.40119e-15
CRED131 DVDD:6353 VSS 2.40979e-15
CRED132 DVDD:6361 VSS 2.40119e-15
CRED133 DVDD:6406 VSS 7.24618e-17
CRED134 DVDD:6415 VSS 2.44121e-15
CRED135 DVDD:6423 VSS 2.40429e-15
CRED136 DVDD:6516 VSS 7.24618e-17
CRED137 DVDD:6525 VSS 2.43633e-15
CRED138 DVDD:6533 VSS 2.40613e-15
CRED139 DVDD:6540 VSS 1.66032e-14
CRED140 DVDD:6548 VSS 5.47567e-17
CRED141 DVDD:6578 VSS 6.02991e-16
CRED142 DVDD:6587 VSS 2.40979e-15
CRED143 DVDD:6595 VSS 2.39752e-15
CRED144 DVDD:6803 VSS 2.40359e-15
CRED145 DVDD:6811 VSS 2.39422e-15
CRED146 DVDD:6856 VSS 7.81985e-17
CRED147 DVDD:6865 VSS 2.44121e-15
CRED148 DVDD:6873 VSS 2.3988e-15
CRED149 DVDD:6966 VSS 7.81985e-17
CRED150 DVDD:6975 VSS 2.43633e-15
CRED151 DVDD:6983 VSS 2.3988e-15
CRED152 DVDD:6990 VSS 1.69175e-14
CRED153 DVDD:6998 VSS 5.90918e-17
CRED154 DVDD:7028 VSS 6.08728e-16
CRED155 DVDD:7037 VSS 2.40979e-15
CRED156 DVDD:7045 VSS 2.39209e-15
CRED157 DVDD:7397 VSS 2.40362e-15
CRED158 DVDD:7405 VSS 2.39809e-15
CRED159 DVDD:7450 VSS 7.24618e-17
CRED160 DVDD:7459 VSS 2.43633e-15
CRED161 DVDD:7467 VSS 2.3988e-15
CRED162 DVDD:7560 VSS 7.24618e-17
CRED163 DVDD:7569 VSS 2.43633e-15
CRED164 DVDD:7577 VSS 2.3988e-15
CRED165 DVDD:7584 VSS 1.68412e-14
CRED166 DVDD:7592 VSS 5.47567e-17
CRED167 DVDD:7622 VSS 6.02991e-16
CRED168 DVDD:7631 VSS 2.40438e-15
CRED169 DVDD:7639 VSS 2.39209e-15
CRED170 DVDD:7847 VSS 2.41038e-15
CRED171 DVDD:7855 VSS 2.39813e-15
CRED172 DVDD:7900 VSS 7.47568e-17
CRED173 DVDD:7909 VSS 2.43633e-15
CRED174 DVDD:7917 VSS 2.39888e-15
CRED175 DVDD:8010 VSS 7.47568e-17
CRED176 DVDD:8019 VSS 2.43633e-15
CRED177 DVDD:8027 VSS 2.39888e-15
CRED178 DVDD:8034 VSS 1.6636e-14
CRED179 DVDD:8042 VSS 5.6491e-17
CRED180 DVDD:8072 VSS 6.05149e-16
CRED181 DVDD:8081 VSS 2.40438e-15
CRED182 DVDD:8089 VSS 2.39213e-15
CRED183 DVDD:8441 VSS 2.42619e-15
CRED184 DVDD:8449 VSS 2.39809e-15
CRED185 DVDD:8494 VSS 7.52146e-17
CRED186 DVDD:8503 VSS 2.44179e-15
CRED187 DVDD:8511 VSS 2.3988e-15
CRED188 DVDD:8604 VSS 7.52146e-17
CRED189 DVDD:8613 VSS 2.44179e-15
CRED190 DVDD:8621 VSS 2.3988e-15
CRED191 DVDD:8628 VSS 1.67695e-14
CRED192 DVDD:8636 VSS 5.68369e-17
CRED193 DVDD:8666 VSS 6.05744e-16
CRED194 DVDD:8675 VSS 2.42019e-15
CRED195 DVDD:8683 VSS 2.39209e-15
CRED196 DVDD:8891 VSS 2.42622e-15
CRED197 DVDD:8899 VSS 2.39421e-15
CRED198 DVDD:8944 VSS 7.71812e-17
CRED199 DVDD:8953 VSS 2.44184e-15
CRED200 DVDD:8961 VSS 2.39888e-15
CRED201 DVDD:9054 VSS 7.71812e-17
CRED202 DVDD:9063 VSS 2.44184e-15
CRED203 DVDD:9071 VSS 2.39888e-15
CRED204 DVDD:9078 VSS 1.69289e-14
CRED205 DVDD:9086 VSS 5.8323e-17
CRED206 DVDD:9116 VSS 6.07574e-16
CRED207 DVDD:9125 VSS 2.42021e-15
CRED208 DVDD:9133 VSS 2.45177e-15
CRED209 PAD VSS 5.31154e-15
CRED210 PAD:100 VSS 2.22345e-15
CRED211 PAD:10009 VSS 4.702694e-15
CRED212 PAD:3766 VSS 7.63403149999999e-14
CRED213 VDD VSS 1.334407e-13
CRED214 VSS X27/D0:neg 2.43328e-15
CRED215 VSS X28/D0:neg 2.50438e-15
CRED216 VSS X29/D0:neg 2.50438e-15
CRED217 VSS X30/D0:neg 2.43325e-15
CRED218 VSS X46/D0:neg 3.92581e-15
CRED219 VSS X46/D1:neg 1.06063e-14
CRED220 VSS X46/X26/D0:neg 2.99591e-15
CRED221 VSS X46/X27/D0:neg 2.97197e-15
CRED222 VSS X46/X28/D0:neg 4.18183e-15
CRED223 VSS X46/X29/D0:neg 4.13411e-15
CRED224 VSS X46/X30/D0:pos 2.93548e-15
CRED225 VSS X46/X31/D0:pos 2.88048e-15
CRED226 VSS X46/X33/D0:pos 2.87453e-15
CRED227 VSS X48/X1/X0/C0:pos 4.17947e-15
CRED228 VSS X48/X1/X1/C0:pos 4.95799e-15
CRED229 VSS X48/X2/X0/C0:pos 4.95799e-15
CRED230 VSS X48/X2/X1/C0:pos 4.16124e-15
CRED231 VSS X49/X0/X1/X0/C0:pos 4.16349e-15
CRED232 VSS X49/X0/X1/X1/C0:pos 4.95654e-15
CRED233 VSS X49/X0/X2/X0/C0:pos 4.95654e-15
CRED234 VSS X49/X0/X2/X1/C0:pos 4.16054e-15
CRED235 VSS X49/X1/X1/X0/C0:pos 4.18159e-15
CRED236 VSS X49/X1/X1/X1/C0:pos 4.95794e-15
CRED237 VSS X49/X1/X2/X0/C0:pos 4.95794e-15
CRED238 VSS X49/X1/X2/X1/C0:pos 4.16126e-15
CRED239 VSS X50/X0/X1/X0/C0:pos 4.16355e-15
CRED240 VSS X50/X0/X1/X1/C0:pos 4.95654e-15
CRED241 VSS X50/X0/X2/X0/C0:pos 4.95654e-15
CRED242 VSS X50/X0/X2/X1/C0:pos 4.16054e-15
CRED243 VSS X50/X1/X1/X0/C0:pos 4.19337e-15
CRED244 VSS X50/X1/X1/X1/C0:pos 4.95727e-15
CRED245 VSS X50/X1/X2/X0/C0:pos 4.95727e-15
CRED246 VSS X50/X1/X2/X1/C0:pos 4.1609e-15
CRED247 VSS X51/X0/X1/X0/C0:pos 4.20829e-15
CRED248 VSS X51/X0/X1/X1/C0:pos 4.95798e-15
CRED249 VSS X51/X0/X2/X0/C0:pos 4.95798e-15
CRED250 VSS X51/X0/X2/X1/C0:pos 4.16126e-15
CRED251 VSS X51/X1/X1/X0/C0:pos 4.20739e-15
CRED252 VSS X51/X1/X1/X1/C0:pos 4.95687e-15
CRED253 VSS X51/X1/X2/X0/C0:pos 4.95687e-15
CRED254 VSS X51/X1/X2/X1/C0:pos 4.16073e-15
CRED255 VSS X52/X0/X1/X0/C0:pos 4.20791e-15
CRED256 VSS X52/X0/X1/X1/C0:pos 4.95799e-15
CRED257 VSS X52/X0/X2/X0/C0:pos 4.95799e-15
CRED258 VSS X52/X0/X2/X1/C0:pos 4.16126e-15
CRED259 VSS X52/X1/X1/X0/C0:pos 4.20338e-15
CRED260 VSS X52/X1/X1/X1/C0:pos 4.95726e-15
CRED261 VSS X52/X1/X2/X0/C0:pos 4.95726e-15
CRED262 VSS X52/X1/X2/X1/C0:pos 4.1609e-15
LRED1 ASIG5V ASIG5V:2941 9.98948e-11
LRED2 ASIG5V ASIG5V:2959 1.02413e-10
LRED3 ASIG5V ASIG5V:2977 1.18347e-10
LRED4 ASIG5V ASIG5V:2995 1.18329e-10
LRED5 ASIG5V ASIG5V:3013 1.11621e-10
LRED6 ASIG5V ASIG5V:3031 1.1172e-10
LRED7 ASIG5V ASIG5V:3049 9.57151e-11
LRED8 ASIG5V ASIG5V:3067 9.64828e-11
LRED9 ASIG5V:101 ASIG5V:1376 5.6599e-13
LRED10 ASIG5V:101 ASIG5V:33 4.72438e-13
LRED11 ASIG5V:108 ASIG5V:1262 5.35008e-14
LRED12 ASIG5V:108 ASIG5V:176 4.4584e-13
LRED13 ASIG5V:11 ASIG5V:1296 9.35521e-15
LRED14 ASIG5V:11 ASIG5V:2131 7.01641e-13
LRED15 ASIG5V:110 ASIG5V:146 4.4584e-13
LRED16 ASIG5V:110 ASIG5V:178 4.4584e-13
LRED17 ASIG5V:112 ASIG5V:1278 8.91681e-14
LRED18 ASIG5V:112 ASIG5V:148 4.4584e-13
LRED19 ASIG5V:114 ASIG5V:150 4.4584e-13
LRED20 ASIG5V:114 ASIG5V:182 4.4584e-13
LRED21 ASIG5V:116 ASIG5V:1294 8.91681e-15
LRED22 ASIG5V:116 ASIG5V:152 6.68761e-13
LRED23 ASIG5V:118 ASIG5V:154 4.4584e-13
LRED24 ASIG5V:118 ASIG5V:186 4.4584e-13
LRED25 ASIG5V:120 ASIG5V:1310 1.51586e-13
LRED26 ASIG5V:120 ASIG5V:156 4.4584e-13
LRED27 ASIG5V:122 ASIG5V:158 4.4584e-13
LRED28 ASIG5V:122 ASIG5V:190 4.4584e-13
LRED29 ASIG5V:124 ASIG5V:160 4.4584e-13
LRED30 ASIG5V:124 ASIG5V:192 4.4584e-13
LRED31 ASIG5V:1257 ASIG5V:2943 3.44162e-12
LRED32 ASIG5V:1258 ASIG5V:2385 5.03918e-14
LRED33 ASIG5V:1258 ASIG5V:2445 3.6954e-13
LRED34 ASIG5V:1259 ASIG5V:2945 3.44162e-12
LRED35 ASIG5V:126 ASIG5V:162 4.4584e-13
LRED36 ASIG5V:126 ASIG5V:194 4.4584e-13
LRED37 ASIG5V:1260 ASIG5V:213 4.83502e-14
LRED38 ASIG5V:1260 ASIG5V:2337 3.54568e-13
LRED39 ASIG5V:1261 ASIG5V:2947 3.44162e-12
LRED40 ASIG5V:1262 ASIG5V:144 3.92339e-13
LRED41 ASIG5V:1263 ASIG5V:2949 7.83188e-12
LRED42 ASIG5V:1264 ASIG5V:2057 5.61313e-14
LRED43 ASIG5V:1264 ASIG5V:2121 4.11629e-13
LRED44 ASIG5V:1265 ASIG5V:2951 3.44162e-12
LRED45 ASIG5V:1266 ASIG5V:2829 7.4357e-14
LRED46 ASIG5V:1266 ASIG5V:2897 5.45285e-13
LRED47 ASIG5V:1267 ASIG5V:2953 3.44162e-12
LRED48 ASIG5V:1268 ASIG5V:2717 8.49197e-14
LRED49 ASIG5V:1268 ASIG5V:2785 6.22745e-13
LRED50 ASIG5V:1269 ASIG5V:2955 3.44162e-12
LRED51 ASIG5V:1270 ASIG5V:2605 8.57545e-14
LRED52 ASIG5V:1270 ASIG5V:2673 6.28866e-13
LRED53 ASIG5V:1272 ASIG5V:2493 7.59133e-14
LRED54 ASIG5V:1272 ASIG5V:2561 5.56698e-13
LRED55 ASIG5V:1273 ASIG5V:2961 3.54206e-12
LRED56 ASIG5V:1274 ASIG5V:2393 8.39864e-14
LRED57 ASIG5V:1274 ASIG5V:2477 3.35945e-13
LRED58 ASIG5V:1275 ASIG5V:2963 3.54206e-12
LRED59 ASIG5V:1276 ASIG5V:217 8.05837e-14
LRED60 ASIG5V:1276 ASIG5V:2369 3.22335e-13
LRED61 ASIG5V:1277 ASIG5V:2965 3.54206e-12
LRED62 ASIG5V:1278 ASIG5V:180 3.56672e-13
LRED63 ASIG5V:1279 ASIG5V:2967 8.06045e-12
LRED64 ASIG5V:128 ASIG5V:164 6.68761e-13
LRED65 ASIG5V:128 ASIG5V:196 2.2292e-13
LRED66 ASIG5V:1280 ASIG5V:2065 9.35521e-14
LRED67 ASIG5V:1280 ASIG5V:2153 3.74209e-13
LRED68 ASIG5V:1281 ASIG5V:2969 3.54206e-12
LRED69 ASIG5V:1282 ASIG5V:2837 1.23928e-13
LRED70 ASIG5V:1282 ASIG5V:2927 4.95713e-13
LRED71 ASIG5V:1283 ASIG5V:2971 3.54206e-12
LRED72 ASIG5V:1284 ASIG5V:2725 1.41533e-13
LRED73 ASIG5V:1284 ASIG5V:2815 5.66132e-13
LRED74 ASIG5V:1285 ASIG5V:2973 3.54206e-12
LRED75 ASIG5V:1286 ASIG5V:2613 1.42924e-13
LRED76 ASIG5V:1286 ASIG5V:2703 5.71696e-13
LRED77 ASIG5V:1288 ASIG5V:2501 1.26522e-13
LRED78 ASIG5V:1288 ASIG5V:2591 5.06089e-13
LRED79 ASIG5V:1289 ASIG5V:2979 3.82398e-12
LRED80 ASIG5V:1290 ASIG5V:2401 8.39864e-15
LRED81 ASIG5V:1290 ASIG5V:2479 2.01567e-13
LRED82 ASIG5V:1291 ASIG5V:2981 3.82398e-12
LRED83 ASIG5V:1292 ASIG5V:221 8.05837e-15
LRED84 ASIG5V:1292 ASIG5V:2371 1.93401e-13
LRED85 ASIG5V:1293 ASIG5V:2983 3.82398e-12
LRED86 ASIG5V:1294 ASIG5V:184 2.14003e-13
LRED87 ASIG5V:1295 ASIG5V:2985 8.70201e-12
LRED88 ASIG5V:1296 ASIG5V:2155 2.24525e-13
LRED89 ASIG5V:1297 ASIG5V:2987 3.82398e-12
LRED90 ASIG5V:1298 ASIG5V:2845 1.23928e-14
LRED91 ASIG5V:1298 ASIG5V:2929 2.97428e-13
LRED92 ASIG5V:1299 ASIG5V:2989 3.82398e-12
LRED93 ASIG5V:13 ASIG5V:2079 4.67761e-13
LRED94 ASIG5V:13 ASIG5V:2133 4.67761e-13
LRED95 ASIG5V:130 ASIG5V:166 4.50299e-13
LRED96 ASIG5V:130 ASIG5V:198 4.4584e-13
LRED97 ASIG5V:1300 ASIG5V:2733 1.41533e-14
LRED98 ASIG5V:1300 ASIG5V:2817 3.39679e-13
LRED99 ASIG5V:1301 ASIG5V:2991 3.82398e-12
LRED100 ASIG5V:1302 ASIG5V:2621 1.42924e-14
LRED101 ASIG5V:1302 ASIG5V:2705 3.43018e-13
LRED102 ASIG5V:1304 ASIG5V:2509 1.26522e-14
LRED103 ASIG5V:1304 ASIG5V:2593 3.03653e-13
LRED104 ASIG5V:1305 ASIG5V:2997 3.87526e-12
LRED105 ASIG5V:1306 ASIG5V:2409 1.42777e-13
LRED106 ASIG5V:1306 ASIG5V:2481 2.77155e-13
LRED107 ASIG5V:1307 ASIG5V:2999 3.87526e-12
LRED108 ASIG5V:1308 ASIG5V:225 1.36992e-13
LRED109 ASIG5V:1308 ASIG5V:2373 2.65926e-13
LRED110 ASIG5V:1309 ASIG5V:3001 3.87526e-12
LRED111 ASIG5V:1310 ASIG5V:188 2.94255e-13
LRED112 ASIG5V:1311 ASIG5V:3003 8.8187e-12
LRED113 ASIG5V:1312 ASIG5V:15 1.59039e-13
LRED114 ASIG5V:1312 ASIG5V:2157 3.08722e-13
LRED115 ASIG5V:1313 ASIG5V:3005 3.87526e-12
LRED116 ASIG5V:1314 ASIG5V:2853 2.10678e-13
LRED117 ASIG5V:1314 ASIG5V:2931 4.08963e-13
LRED118 ASIG5V:1315 ASIG5V:3007 3.87526e-12
LRED119 ASIG5V:1316 ASIG5V:2741 2.40606e-13
LRED120 ASIG5V:1316 ASIG5V:2819 4.67059e-13
LRED121 ASIG5V:1317 ASIG5V:3009 3.87526e-12
LRED122 ASIG5V:1318 ASIG5V:2629 2.42971e-13
LRED123 ASIG5V:1318 ASIG5V:2707 4.7165e-13
LRED124 ASIG5V:132 ASIG5V:168 4.50299e-13
LRED125 ASIG5V:132 ASIG5V:200 4.50299e-13
LRED126 ASIG5V:1320 ASIG5V:2517 2.15088e-13
LRED127 ASIG5V:1320 ASIG5V:2595 4.17523e-13
LRED128 ASIG5V:1321 ASIG5V:3015 3.81448e-12
LRED129 ASIG5V:1322 ASIG5V:2423 2.68756e-13
LRED130 ASIG5V:1322 ASIG5V:2463 1.51175e-13
LRED131 ASIG5V:1323 ASIG5V:3017 3.81448e-12
LRED132 ASIG5V:1324 ASIG5V:2315 2.57868e-13
LRED133 ASIG5V:1324 ASIG5V:2355 1.45051e-13
LRED134 ASIG5V:1325 ASIG5V:3019 3.81448e-12
LRED135 ASIG5V:1326 ASIG5V:160 1.60503e-13
LRED136 ASIG5V:1326 ASIG5V:194 2.85338e-13
LRED137 ASIG5V:1327 ASIG5V:3021 8.68038e-12
LRED138 ASIG5V:1328 ASIG5V:2095 2.99367e-13
LRED139 ASIG5V:1328 ASIG5V:2139 1.68394e-13
LRED140 ASIG5V:1329 ASIG5V:3023 3.81448e-12
LRED141 ASIG5V:1330 ASIG5V:2867 3.96571e-13
LRED142 ASIG5V:1330 ASIG5V:2915 2.23071e-13
LRED143 ASIG5V:1331 ASIG5V:3025 3.81448e-12
LRED144 ASIG5V:1332 ASIG5V:2755 4.52905e-13
LRED145 ASIG5V:1332 ASIG5V:2803 2.54759e-13
LRED146 ASIG5V:1333 ASIG5V:3027 3.81448e-12
LRED147 ASIG5V:1334 ASIG5V:2643 4.57357e-13
LRED148 ASIG5V:1334 ASIG5V:2691 2.57263e-13
LRED149 ASIG5V:1336 ASIG5V:2531 4.04871e-13
LRED150 ASIG5V:1336 ASIG5V:2579 2.2774e-13
LRED151 ASIG5V:1337 ASIG5V:3033 4.76974e-12
LRED152 ASIG5V:1338 ASIG5V:2431 1.93169e-13
LRED153 ASIG5V:1338 ASIG5V:2467 1.67973e-14
LRED154 ASIG5V:1339 ASIG5V:3035 4.76974e-12
LRED155 ASIG5V:134 ASIG5V:170 4.50299e-13
LRED156 ASIG5V:134 ASIG5V:202 4.50299e-13
LRED157 ASIG5V:1340 ASIG5V:2323 1.85343e-13
LRED158 ASIG5V:1340 ASIG5V:2359 1.61167e-14
LRED159 ASIG5V:1341 ASIG5V:3037 4.76974e-12
LRED160 ASIG5V:1342 ASIG5V:164 1.78336e-14
LRED161 ASIG5V:1342 ASIG5V:198 2.05087e-13
LRED162 ASIG5V:1343 ASIG5V:3039 1.08542e-11
LRED163 ASIG5V:1344 ASIG5V:2103 2.1517e-13
LRED164 ASIG5V:1344 ASIG5V:2143 1.87104e-14
LRED165 ASIG5V:1345 ASIG5V:3041 4.76974e-12
LRED166 ASIG5V:1346 ASIG5V:2875 2.85035e-13
LRED167 ASIG5V:1346 ASIG5V:2919 2.47857e-14
LRED168 ASIG5V:1347 ASIG5V:3043 4.76974e-12
LRED169 ASIG5V:1348 ASIG5V:2763 3.25526e-13
LRED170 ASIG5V:1348 ASIG5V:2807 2.83066e-14
LRED171 ASIG5V:1349 ASIG5V:3045 4.76974e-12
LRED172 ASIG5V:1350 ASIG5V:2651 3.28725e-13
LRED173 ASIG5V:1350 ASIG5V:2695 2.85848e-14
LRED174 ASIG5V:1352 ASIG5V:2539 2.91001e-13
LRED175 ASIG5V:1352 ASIG5V:2583 2.53044e-14
LRED176 ASIG5V:1353 ASIG5V:3051 3.78125e-12
LRED177 ASIG5V:1354 ASIG5V:2439 3.48543e-13
LRED178 ASIG5V:1354 ASIG5V:2471 7.55877e-14
LRED179 ASIG5V:1355 ASIG5V:3053 3.78125e-12
LRED180 ASIG5V:1356 ASIG5V:2331 3.34423e-13
LRED181 ASIG5V:1356 ASIG5V:2363 7.25254e-14
LRED182 ASIG5V:1357 ASIG5V:3055 3.78125e-12
LRED183 ASIG5V:1358 ASIG5V:168 8.02513e-14
LRED184 ASIG5V:1358 ASIG5V:202 3.70047e-13
LRED185 ASIG5V:1359 ASIG5V:3057 8.60476e-12
LRED186 ASIG5V:136 ASIG5V:1374 3.61131e-13
LRED187 ASIG5V:136 ASIG5V:204 4.50299e-13
LRED188 ASIG5V:1360 ASIG5V:2111 3.88241e-13
LRED189 ASIG5V:1360 ASIG5V:2147 8.41969e-14
LRED190 ASIG5V:1361 ASIG5V:3059 3.78125e-12
LRED191 ASIG5V:1362 ASIG5V:2883 5.14303e-13
LRED192 ASIG5V:1362 ASIG5V:2923 1.11535e-13
LRED193 ASIG5V:1363 ASIG5V:3061 3.78125e-12
LRED194 ASIG5V:1364 ASIG5V:2771 5.87361e-13
LRED195 ASIG5V:1364 ASIG5V:2811 1.2738e-13
LRED196 ASIG5V:1365 ASIG5V:3063 3.78125e-12
LRED197 ASIG5V:1366 ASIG5V:2659 5.93135e-13
LRED198 ASIG5V:1366 ASIG5V:2699 1.28632e-13
LRED199 ASIG5V:1368 ASIG5V:2547 5.25067e-13
LRED200 ASIG5V:1368 ASIG5V:2587 1.1387e-13
LRED201 ASIG5V:1369 ASIG5V:3069 3.67204e-12
LRED202 ASIG5V:1370 ASIG5V:2441 3.40145e-13
LRED203 ASIG5V:1370 ASIG5V:416 5.08117e-13
LRED204 ASIG5V:1371 ASIG5V:3071 3.67204e-12
LRED205 ASIG5V:1372 ASIG5V:2333 3.26364e-13
LRED206 ASIG5V:1372 ASIG5V:311 4.87532e-13
LRED207 ASIG5V:1373 ASIG5V:3073 3.67204e-12
LRED208 ASIG5V:1374 ASIG5V:206 5.39467e-13
LRED209 ASIG5V:1375 ASIG5V:3075 8.35625e-12
LRED210 ASIG5V:1376 ASIG5V:2113 3.78886e-13
LRED211 ASIG5V:1377 ASIG5V:3077 3.67204e-12
LRED212 ASIG5V:1378 ASIG5V:2885 5.0191e-13
LRED213 ASIG5V:1378 ASIG5V:2891 7.49766e-13
LRED214 ASIG5V:1379 ASIG5V:3079 3.67204e-12
LRED215 ASIG5V:138 ASIG5V:206 4.50299e-13
LRED216 ASIG5V:138 ASIG5V:2227 4.50299e-13
LRED217 ASIG5V:1380 ASIG5V:2773 5.73208e-13
LRED218 ASIG5V:1380 ASIG5V:2779 8.56274e-13
LRED219 ASIG5V:1381 ASIG5V:3081 3.67204e-12
LRED220 ASIG5V:1382 ASIG5V:2661 5.78843e-13
LRED221 ASIG5V:1382 ASIG5V:2667 8.64691e-13
LRED222 ASIG5V:1384 ASIG5V:2549 5.12415e-13
LRED223 ASIG5V:1384 ASIG5V:2555 7.65459e-13
LRED224 ASIG5V:144 ASIG5V:178 4.4584e-13
LRED225 ASIG5V:146 ASIG5V:180 4.4584e-13
LRED226 ASIG5V:148 ASIG5V:182 4.4584e-13
LRED227 ASIG5V:15 ASIG5V:2135 4.67761e-13
LRED228 ASIG5V:150 ASIG5V:184 4.4584e-13
LRED229 ASIG5V:152 ASIG5V:186 2.2292e-13
LRED230 ASIG5V:154 ASIG5V:188 4.4584e-13
LRED231 ASIG5V:156 ASIG5V:190 4.4584e-13
LRED232 ASIG5V:158 ASIG5V:192 4.4584e-13
LRED233 ASIG5V:162 ASIG5V:196 4.4584e-13
LRED234 ASIG5V:166 ASIG5V:200 4.50299e-13
LRED235 ASIG5V:17 ASIG5V:2087 4.67761e-13
LRED236 ASIG5V:17 ASIG5V:2137 4.67761e-13
LRED237 ASIG5V:170 ASIG5V:204 4.50299e-13
LRED238 ASIG5V:19 ASIG5V:2091 4.67761e-13
LRED239 ASIG5V:19 ASIG5V:2139 4.67761e-13
LRED240 ASIG5V:2057 ASIG5V:2059 4.67761e-13
LRED241 ASIG5V:2061 ASIG5V:2063 4.67761e-13
LRED242 ASIG5V:2061 ASIG5V:2125 4.67761e-13
LRED243 ASIG5V:2063 ASIG5V:2121 4.67761e-13
LRED244 ASIG5V:2065 ASIG5V:2127 4.67761e-13
LRED245 ASIG5V:2069 ASIG5V:2071 4.67761e-13
LRED246 ASIG5V:2069 ASIG5V:2129 4.67761e-13
LRED247 ASIG5V:2071 ASIG5V:2127 4.67761e-13
LRED248 ASIG5V:2079 ASIG5V:2131 2.3388e-13
LRED249 ASIG5V:2087 ASIG5V:2135 4.67761e-13
LRED250 ASIG5V:2091 ASIG5V:2137 4.67761e-13
LRED251 ASIG5V:2093 ASIG5V:2095 4.67761e-13
LRED252 ASIG5V:2093 ASIG5V:2141 4.67761e-13
LRED253 ASIG5V:2097 ASIG5V:2099 2.3388e-13
LRED254 ASIG5V:2097 ASIG5V:2143 7.01641e-13
LRED255 ASIG5V:2099 ASIG5V:2141 4.67761e-13
LRED256 ASIG5V:2101 ASIG5V:2103 4.67761e-13
LRED257 ASIG5V:2101 ASIG5V:2145 4.72438e-13
LRED258 ASIG5V:2105 ASIG5V:2107 4.72438e-13
LRED259 ASIG5V:2105 ASIG5V:2147 4.72438e-13
LRED260 ASIG5V:2107 ASIG5V:2145 4.72438e-13
LRED261 ASIG5V:2109 ASIG5V:2111 4.72438e-13
LRED262 ASIG5V:2109 ASIG5V:2149 4.72438e-13
LRED263 ASIG5V:2113 ASIG5V:2115 4.72438e-13
LRED264 ASIG5V:2115 ASIG5V:2149 4.72438e-13
LRED265 ASIG5V:2117 ASIG5V:33 4.72438e-13
LRED266 ASIG5V:2125 ASIG5V:2153 4.67761e-13
LRED267 ASIG5V:2129 ASIG5V:2155 4.67761e-13
LRED268 ASIG5V:213 ASIG5V:2279 4.02919e-13
LRED269 ASIG5V:2133 ASIG5V:2157 4.67761e-13
LRED270 ASIG5V:215 ASIG5V:2283 4.02919e-13
LRED271 ASIG5V:215 ASIG5V:2341 4.02919e-13
LRED272 ASIG5V:2151 X46/X26/D0:neg 4.67761e-13
LRED273 ASIG5V:217 ASIG5V:2343 4.02919e-13
LRED274 ASIG5V:219 ASIG5V:2291 4.02919e-13
LRED275 ASIG5V:219 ASIG5V:2345 4.02919e-13
LRED276 ASIG5V:221 ASIG5V:2347 6.04378e-13
LRED277 ASIG5V:223 ASIG5V:2299 4.02919e-13
LRED278 ASIG5V:223 ASIG5V:2349 4.02919e-13
LRED279 ASIG5V:225 ASIG5V:2351 4.02919e-13
LRED280 ASIG5V:2261 X46/X27/D0:neg 4.4584e-13
LRED281 ASIG5V:227 ASIG5V:2307 4.02919e-13
LRED282 ASIG5V:227 ASIG5V:2353 4.02919e-13
LRED283 ASIG5V:2283 ASIG5V:2337 4.02919e-13
LRED284 ASIG5V:229 ASIG5V:2311 4.02919e-13
LRED285 ASIG5V:229 ASIG5V:2355 4.02919e-13
LRED286 ASIG5V:2291 ASIG5V:2343 4.02919e-13
LRED287 ASIG5V:2299 ASIG5V:2347 2.01459e-13
LRED288 ASIG5V:2307 ASIG5V:2351 4.02919e-13
LRED289 ASIG5V:231 ASIG5V:2315 4.02919e-13
LRED290 ASIG5V:231 ASIG5V:2357 4.02919e-13
LRED291 ASIG5V:2311 ASIG5V:2353 4.02919e-13
LRED292 ASIG5V:2317 ASIG5V:2319 2.01459e-13
LRED293 ASIG5V:2317 ASIG5V:2359 6.04378e-13
LRED294 ASIG5V:2319 ASIG5V:2357 4.02919e-13
LRED295 ASIG5V:2321 ASIG5V:2323 4.02919e-13
LRED296 ASIG5V:2321 ASIG5V:2361 4.06948e-13
LRED297 ASIG5V:2325 ASIG5V:2327 4.06948e-13
LRED298 ASIG5V:2325 ASIG5V:2363 4.06948e-13
LRED299 ASIG5V:2327 ASIG5V:2361 4.06948e-13
LRED300 ASIG5V:2329 ASIG5V:2331 4.06948e-13
LRED301 ASIG5V:2329 ASIG5V:2365 4.06948e-13
LRED302 ASIG5V:2333 ASIG5V:2335 4.06948e-13
LRED303 ASIG5V:2335 ASIG5V:2365 4.06948e-13
LRED304 ASIG5V:2341 ASIG5V:2369 4.02919e-13
LRED305 ASIG5V:2345 ASIG5V:2371 4.02919e-13
LRED306 ASIG5V:2349 ASIG5V:2373 4.02919e-13
LRED307 ASIG5V:2367 X46/X28/D0:neg 4.02919e-13
LRED308 ASIG5V:2381 ASIG5V:311 4.06948e-13
LRED309 ASIG5V:2385 ASIG5V:2387 4.19932e-13
LRED310 ASIG5V:2389 ASIG5V:2391 4.19932e-13
LRED311 ASIG5V:2389 ASIG5V:2449 4.19932e-13
LRED312 ASIG5V:2391 ASIG5V:2445 4.19932e-13
LRED313 ASIG5V:2393 ASIG5V:2451 4.19932e-13
LRED314 ASIG5V:2397 ASIG5V:2399 4.19932e-13
LRED315 ASIG5V:2397 ASIG5V:2453 4.19932e-13
LRED316 ASIG5V:2399 ASIG5V:2451 4.19932e-13
LRED317 ASIG5V:2401 ASIG5V:2455 6.29898e-13
LRED318 ASIG5V:2405 ASIG5V:2407 4.19932e-13
LRED319 ASIG5V:2405 ASIG5V:2457 4.19932e-13
LRED320 ASIG5V:2407 ASIG5V:2455 2.09966e-13
LRED321 ASIG5V:2409 ASIG5V:2459 4.19932e-13
LRED322 ASIG5V:2413 ASIG5V:2415 4.19932e-13
LRED323 ASIG5V:2413 ASIG5V:2461 4.19932e-13
LRED324 ASIG5V:2415 ASIG5V:2459 4.19932e-13
LRED325 ASIG5V:2417 ASIG5V:2419 4.19932e-13
LRED326 ASIG5V:2417 ASIG5V:2463 4.19932e-13
LRED327 ASIG5V:2419 ASIG5V:2461 4.19932e-13
LRED328 ASIG5V:2421 ASIG5V:2423 4.19932e-13
LRED329 ASIG5V:2421 ASIG5V:2465 4.19932e-13
LRED330 ASIG5V:2425 ASIG5V:2427 2.09966e-13
LRED331 ASIG5V:2425 ASIG5V:2467 6.29898e-13
LRED332 ASIG5V:2427 ASIG5V:2465 4.19932e-13
LRED333 ASIG5V:2429 ASIG5V:2431 4.19932e-13
LRED334 ASIG5V:2429 ASIG5V:2469 4.24131e-13
LRED335 ASIG5V:2433 ASIG5V:2435 4.24131e-13
LRED336 ASIG5V:2433 ASIG5V:2471 4.24131e-13
LRED337 ASIG5V:2435 ASIG5V:2469 4.24131e-13
LRED338 ASIG5V:2437 ASIG5V:2439 4.24131e-13
LRED339 ASIG5V:2437 ASIG5V:2473 4.24131e-13
LRED340 ASIG5V:2441 ASIG5V:2443 4.24131e-13
LRED341 ASIG5V:2443 ASIG5V:2473 4.24131e-13
LRED342 ASIG5V:2449 ASIG5V:2477 4.19932e-13
LRED343 ASIG5V:2453 ASIG5V:2479 4.19932e-13
LRED344 ASIG5V:2457 ASIG5V:2481 4.19932e-13
LRED345 ASIG5V:2475 X46/X29/D0:neg 4.19932e-13
LRED346 ASIG5V:2489 ASIG5V:416 4.24131e-13
LRED347 ASIG5V:2493 ASIG5V:2495 6.32611e-13
LRED348 ASIG5V:2495 ASIG5V:2559 6.32611e-13
LRED349 ASIG5V:2497 ASIG5V:2499 6.32611e-13
LRED350 ASIG5V:2497 ASIG5V:2565 6.32611e-13
LRED351 ASIG5V:2499 ASIG5V:2561 6.32611e-13
LRED352 ASIG5V:2501 ASIG5V:2567 6.32611e-13
LRED353 ASIG5V:2505 ASIG5V:2507 6.32611e-13
LRED354 ASIG5V:2505 ASIG5V:2569 6.32611e-13
LRED355 ASIG5V:2507 ASIG5V:2567 6.32611e-13
LRED356 ASIG5V:2509 ASIG5V:2571 9.48916e-13
LRED357 ASIG5V:2513 ASIG5V:2515 6.32611e-13
LRED358 ASIG5V:2513 ASIG5V:2573 6.32611e-13
LRED359 ASIG5V:2515 ASIG5V:2571 3.16305e-13
LRED360 ASIG5V:2517 ASIG5V:2575 6.32611e-13
LRED361 ASIG5V:2521 ASIG5V:2523 6.32611e-13
LRED362 ASIG5V:2521 ASIG5V:2577 6.32611e-13
LRED363 ASIG5V:2523 ASIG5V:2575 6.32611e-13
LRED364 ASIG5V:2525 ASIG5V:2527 6.32611e-13
LRED365 ASIG5V:2525 ASIG5V:2579 6.32611e-13
LRED366 ASIG5V:2527 ASIG5V:2577 6.32611e-13
LRED367 ASIG5V:2529 ASIG5V:2531 6.32611e-13
LRED368 ASIG5V:2529 ASIG5V:2581 6.32611e-13
LRED369 ASIG5V:2533 ASIG5V:2535 3.16305e-13
LRED370 ASIG5V:2533 ASIG5V:2583 9.48916e-13
LRED371 ASIG5V:2535 ASIG5V:2581 6.32611e-13
LRED372 ASIG5V:2537 ASIG5V:2539 6.32611e-13
LRED373 ASIG5V:2537 ASIG5V:2585 6.38937e-13
LRED374 ASIG5V:2541 ASIG5V:2543 6.38937e-13
LRED375 ASIG5V:2541 ASIG5V:2587 6.38937e-13
LRED376 ASIG5V:2543 ASIG5V:2585 6.38937e-13
LRED377 ASIG5V:2545 ASIG5V:2547 6.38937e-13
LRED378 ASIG5V:2545 ASIG5V:2589 6.38937e-13
LRED379 ASIG5V:2549 ASIG5V:2551 6.38937e-13
LRED380 ASIG5V:2551 ASIG5V:2589 6.38937e-13
LRED381 ASIG5V:2553 ASIG5V:453 6.38937e-13
LRED382 ASIG5V:2555 ASIG5V:453 6.38937e-13
LRED383 ASIG5V:2557 X46/X30/D0:pos 6.32611e-13
LRED384 ASIG5V:2565 ASIG5V:2591 6.32611e-13
LRED385 ASIG5V:2569 ASIG5V:2593 6.32611e-13
LRED386 ASIG5V:2573 ASIG5V:2595 6.32611e-13
LRED387 ASIG5V:2605 ASIG5V:2607 7.1462e-13
LRED388 ASIG5V:2607 ASIG5V:2671 7.1462e-13
LRED389 ASIG5V:2609 ASIG5V:2611 7.1462e-13
LRED390 ASIG5V:2609 ASIG5V:2677 7.1462e-13
LRED391 ASIG5V:2611 ASIG5V:2673 7.1462e-13
LRED392 ASIG5V:2613 ASIG5V:2679 7.1462e-13
LRED393 ASIG5V:2617 ASIG5V:2619 7.1462e-13
LRED394 ASIG5V:2617 ASIG5V:2681 7.1462e-13
LRED395 ASIG5V:2619 ASIG5V:2679 7.1462e-13
LRED396 ASIG5V:2621 ASIG5V:2683 1.07193e-12
LRED397 ASIG5V:2625 ASIG5V:2627 7.1462e-13
LRED398 ASIG5V:2625 ASIG5V:2685 7.1462e-13
LRED399 ASIG5V:2627 ASIG5V:2683 3.5731e-13
LRED400 ASIG5V:2629 ASIG5V:2687 7.1462e-13
LRED401 ASIG5V:2633 ASIG5V:2635 7.1462e-13
LRED402 ASIG5V:2633 ASIG5V:2689 7.1462e-13
LRED403 ASIG5V:2635 ASIG5V:2687 7.1462e-13
LRED404 ASIG5V:2637 ASIG5V:2639 7.1462e-13
LRED405 ASIG5V:2637 ASIG5V:2691 7.1462e-13
LRED406 ASIG5V:2639 ASIG5V:2689 7.1462e-13
LRED407 ASIG5V:2641 ASIG5V:2643 7.1462e-13
LRED408 ASIG5V:2641 ASIG5V:2693 7.1462e-13
LRED409 ASIG5V:2645 ASIG5V:2647 3.5731e-13
LRED410 ASIG5V:2645 ASIG5V:2695 1.07193e-12
LRED411 ASIG5V:2647 ASIG5V:2693 7.1462e-13
LRED412 ASIG5V:2649 ASIG5V:2651 7.1462e-13
LRED413 ASIG5V:2649 ASIG5V:2697 7.21767e-13
LRED414 ASIG5V:2653 ASIG5V:2655 7.21767e-13
LRED415 ASIG5V:2653 ASIG5V:2699 7.21767e-13
LRED416 ASIG5V:2655 ASIG5V:2697 7.21767e-13
LRED417 ASIG5V:2657 ASIG5V:2659 7.21767e-13
LRED418 ASIG5V:2657 ASIG5V:2701 7.21767e-13
LRED419 ASIG5V:2661 ASIG5V:2663 7.21767e-13
LRED420 ASIG5V:2663 ASIG5V:2701 7.21767e-13
LRED421 ASIG5V:2665 ASIG5V:558 7.21767e-13
LRED422 ASIG5V:2667 ASIG5V:558 7.21767e-13
LRED423 ASIG5V:2669 X46/X31/D0:pos 7.1462e-13
LRED424 ASIG5V:2677 ASIG5V:2703 7.1462e-13
LRED425 ASIG5V:2681 ASIG5V:2705 7.1462e-13
LRED426 ASIG5V:2685 ASIG5V:2707 7.1462e-13
LRED427 ASIG5V:2717 ASIG5V:2719 7.07664e-13
LRED428 ASIG5V:2719 ASIG5V:2783 7.07664e-13
LRED429 ASIG5V:2721 ASIG5V:2723 7.07664e-13
LRED430 ASIG5V:2721 ASIG5V:2789 7.07664e-13
LRED431 ASIG5V:2723 ASIG5V:2785 7.07664e-13
LRED432 ASIG5V:2725 ASIG5V:2791 7.07664e-13
LRED433 ASIG5V:2729 ASIG5V:2731 7.07664e-13
LRED434 ASIG5V:2729 ASIG5V:2793 7.07664e-13
LRED435 ASIG5V:2731 ASIG5V:2791 7.07664e-13
LRED436 ASIG5V:2733 ASIG5V:2795 1.0615e-12
LRED437 ASIG5V:2737 ASIG5V:2739 7.07664e-13
LRED438 ASIG5V:2737 ASIG5V:2797 7.07664e-13
LRED439 ASIG5V:2739 ASIG5V:2795 3.53832e-13
LRED440 ASIG5V:2741 ASIG5V:2799 7.07664e-13
LRED441 ASIG5V:2745 ASIG5V:2747 7.07664e-13
LRED442 ASIG5V:2745 ASIG5V:2801 7.07664e-13
LRED443 ASIG5V:2747 ASIG5V:2799 7.07664e-13
LRED444 ASIG5V:2749 ASIG5V:2751 7.07664e-13
LRED445 ASIG5V:2749 ASIG5V:2803 7.07664e-13
LRED446 ASIG5V:2751 ASIG5V:2801 7.07664e-13
LRED447 ASIG5V:2753 ASIG5V:2755 7.07664e-13
LRED448 ASIG5V:2753 ASIG5V:2805 7.07664e-13
LRED449 ASIG5V:2757 ASIG5V:2759 3.53832e-13
LRED450 ASIG5V:2757 ASIG5V:2807 1.0615e-12
LRED451 ASIG5V:2759 ASIG5V:2805 7.07664e-13
LRED452 ASIG5V:2761 ASIG5V:2763 7.07664e-13
LRED453 ASIG5V:2761 ASIG5V:2809 7.14741e-13
LRED454 ASIG5V:2765 ASIG5V:2767 7.14741e-13
LRED455 ASIG5V:2765 ASIG5V:2811 7.14741e-13
LRED456 ASIG5V:2767 ASIG5V:2809 7.14741e-13
LRED457 ASIG5V:2769 ASIG5V:2771 7.14741e-13
LRED458 ASIG5V:2769 ASIG5V:2813 7.14741e-13
LRED459 ASIG5V:2773 ASIG5V:2775 7.14741e-13
LRED460 ASIG5V:2775 ASIG5V:2813 7.14741e-13
LRED461 ASIG5V:2777 ASIG5V:663 7.14741e-13
LRED462 ASIG5V:2779 ASIG5V:663 7.14741e-13
LRED463 ASIG5V:2781 X46/X32/D0:pos 7.07664e-13
LRED464 ASIG5V:2789 ASIG5V:2815 7.07664e-13
LRED465 ASIG5V:2793 ASIG5V:2817 7.07664e-13
LRED466 ASIG5V:2797 ASIG5V:2819 7.07664e-13
LRED467 ASIG5V:2829 ASIG5V:2831 6.19642e-13
LRED468 ASIG5V:2831 ASIG5V:2895 6.19642e-13
LRED469 ASIG5V:2833 ASIG5V:2835 6.19642e-13
LRED470 ASIG5V:2833 ASIG5V:2901 6.19642e-13
LRED471 ASIG5V:2835 ASIG5V:2897 6.19642e-13
LRED472 ASIG5V:2837 ASIG5V:2903 6.19642e-13
LRED473 ASIG5V:2841 ASIG5V:2843 6.19642e-13
LRED474 ASIG5V:2841 ASIG5V:2905 6.19642e-13
LRED475 ASIG5V:2843 ASIG5V:2903 6.19642e-13
LRED476 ASIG5V:2845 ASIG5V:2907 9.29462e-13
LRED477 ASIG5V:2849 ASIG5V:2851 6.19642e-13
LRED478 ASIG5V:2849 ASIG5V:2909 6.19642e-13
LRED479 ASIG5V:2851 ASIG5V:2907 3.09821e-13
LRED480 ASIG5V:2853 ASIG5V:2911 6.19642e-13
LRED481 ASIG5V:2857 ASIG5V:2859 6.19642e-13
LRED482 ASIG5V:2857 ASIG5V:2913 6.19642e-13
LRED483 ASIG5V:2859 ASIG5V:2911 6.19642e-13
LRED484 ASIG5V:2861 ASIG5V:2863 6.19642e-13
LRED485 ASIG5V:2861 ASIG5V:2915 6.19642e-13
LRED486 ASIG5V:2863 ASIG5V:2913 6.19642e-13
LRED487 ASIG5V:2865 ASIG5V:2867 6.19642e-13
LRED488 ASIG5V:2865 ASIG5V:2917 6.19642e-13
LRED489 ASIG5V:2869 ASIG5V:2871 3.09821e-13
LRED490 ASIG5V:2869 ASIG5V:2919 9.29462e-13
LRED491 ASIG5V:2871 ASIG5V:2917 6.19642e-13
LRED492 ASIG5V:2873 ASIG5V:2875 6.19642e-13
LRED493 ASIG5V:2873 ASIG5V:2921 6.25838e-13
LRED494 ASIG5V:2877 ASIG5V:2879 6.25838e-13
LRED495 ASIG5V:2877 ASIG5V:2923 6.25838e-13
LRED496 ASIG5V:2879 ASIG5V:2921 6.25838e-13
LRED497 ASIG5V:2881 ASIG5V:2883 6.25838e-13
LRED498 ASIG5V:2881 ASIG5V:2925 6.25838e-13
LRED499 ASIG5V:2885 ASIG5V:2887 6.25838e-13
LRED500 ASIG5V:2887 ASIG5V:2925 6.25838e-13
LRED501 ASIG5V:2889 ASIG5V:768 6.25838e-13
LRED502 ASIG5V:2891 ASIG5V:768 6.25838e-13
LRED503 ASIG5V:2893 X46/X33/D0:pos 6.19642e-13
LRED504 ASIG5V:2901 ASIG5V:2927 6.19642e-13
LRED505 ASIG5V:2905 ASIG5V:2929 6.19642e-13
LRED506 ASIG5V:2909 ASIG5V:2931 6.19642e-13
LRED507 ASIG5V:2957 R0:neg 4.38046e-12
LRED508 ASIG5V:2975 R1:neg 4.5083e-12
LRED509 ASIG5V:2993 R2:neg 4.86713e-12
LRED510 ASIG5V:3011 R3:neg 4.9324e-12
LRED511 ASIG5V:3029 R4:neg 4.85504e-12
LRED512 ASIG5V:3047 R5:neg 6.07088e-12
LRED513 ASIG5V:3065 R6:neg 4.81274e-12
LRED514 ASIG5V:3083 R7:neg 4.67374e-12
XR0 PAD:3766 R0:neg rm2 r_width=2.54e-06 r_length=2.76e-07
XR1 PAD:3766 R1:neg rm2 r_width=2.54e-06 r_length=2.76e-07
XR2 PAD:3766 R2:neg rm2 r_width=2.54e-06 r_length=2.76e-07
XR3 PAD:3766 R3:neg rm2 r_width=2.54e-06 r_length=2.76e-07
XR4 PAD:3766 R4:neg rm2 r_width=2.54e-06 r_length=2.76e-07
XR5 PAD:3766 R5:neg rm2 r_width=2.54e-06 r_length=2.76e-07
XR6 PAD:3766 R6:neg rm2 r_width=2.54e-06 r_length=2.76e-07
XR7 PAD:3766 R7:neg rm2 r_width=2.54e-06 r_length=2.76e-07
dX27/D0 DVSS X27/D0:neg diode_nd2ps_06v0 area=4e-11 pj=8.2e-05 M=1
dX28/D0 DVSS X28/D0:neg diode_nd2ps_06v0 area=4e-11 pj=8.2e-05 M=1
dX29/D0 DVSS X29/D0:neg diode_nd2ps_06v0 area=4e-11 pj=8.2e-05 M=1
dX30/D0 DVSS X30/D0:neg diode_nd2ps_06v0 area=4e-11 pj=8.2e-05 M=1
dX46/X26/D0 DVSS X46/X26/D0:neg diode_nd2ps_06v0 area=1.5e-10 pj=0.000106 M=1
dX46/X27/D0 DVSS X46/X27/D0:neg diode_nd2ps_06v0 area=1.5e-10 pj=0.000106 M=1
dX46/X28/D0 DVSS X46/X28/D0:neg diode_nd2ps_06v0 area=1.5e-10 pj=0.000106 M=1
dX46/X29/D0 DVSS X46/X29/D0:neg diode_nd2ps_06v0 area=1.5e-10 pj=0.000106 M=1
dX46/X30/D0 X46/X30/D0:pos X46/D1:neg diode_pd2nw_06v0 area=1.5e-10 pj=0.000106 M=1
dX46/X31/D0 X46/X31/D0:pos X46/D1:neg diode_pd2nw_06v0 area=1.5e-10 pj=0.000106 M=1
dX46/X32/D0 X46/X32/D0:pos X46/D1:neg diode_pd2nw_06v0 area=1.5e-10 pj=0.000106 M=1
dX46/X33/D0 X46/X33/D0:pos X46/D1:neg diode_pd2nw_06v0 area=1.5e-10 pj=0.000106 M=1
XX48/X1/X0/C0 X48/X1/X0/C0:pos DVSS cap_nmos_06v0 c_length=1.5e-05 c_width=1.5e-05
XX48/X1/X1/C0 X48/X1/X1/C0:pos DVSS cap_nmos_06v0 c_length=1.5e-05 c_width=1.5e-05
XX48/X2/X0/C0 X48/X2/X0/C0:pos DVSS cap_nmos_06v0 c_length=1.5e-05 c_width=1.5e-05
XX48/X2/X1/C0 X48/X2/X1/C0:pos DVSS cap_nmos_06v0 c_length=1.5e-05 c_width=1.5e-05
XX49/X0/X1/X0/C0 X49/X0/X1/X0/C0:pos DVSS cap_nmos_06v0 c_length=1.5e-05 c_width=1.5e-05
XX49/X0/X1/X1/C0 X49/X0/X1/X1/C0:pos DVSS cap_nmos_06v0 c_length=1.5e-05 c_width=1.5e-05
XX49/X0/X2/X0/C0 X49/X0/X2/X0/C0:pos DVSS cap_nmos_06v0 c_length=1.5e-05 c_width=1.5e-05
XX49/X0/X2/X1/C0 X49/X0/X2/X1/C0:pos DVSS cap_nmos_06v0 c_length=1.5e-05 c_width=1.5e-05
XX49/X1/X1/X0/C0 X49/X1/X1/X0/C0:pos DVSS cap_nmos_06v0 c_length=1.5e-05 c_width=1.5e-05
XX49/X1/X1/X1/C0 X49/X1/X1/X1/C0:pos DVSS cap_nmos_06v0 c_length=1.5e-05 c_width=1.5e-05
XX49/X1/X2/X0/C0 X49/X1/X2/X0/C0:pos DVSS cap_nmos_06v0 c_length=1.5e-05 c_width=1.5e-05
XX49/X1/X2/X1/C0 X49/X1/X2/X1/C0:pos DVSS cap_nmos_06v0 c_length=1.5e-05 c_width=1.5e-05
XX50/X0/X1/X0/C0 X50/X0/X1/X0/C0:pos DVSS cap_nmos_06v0 c_length=1.5e-05 c_width=1.5e-05
XX50/X0/X1/X1/C0 X50/X0/X1/X1/C0:pos DVSS cap_nmos_06v0 c_length=1.5e-05 c_width=1.5e-05
XX50/X0/X2/X0/C0 X50/X0/X2/X0/C0:pos DVSS cap_nmos_06v0 c_length=1.5e-05 c_width=1.5e-05
XX50/X0/X2/X1/C0 X50/X0/X2/X1/C0:pos DVSS cap_nmos_06v0 c_length=1.5e-05 c_width=1.5e-05
XX50/X1/X1/X0/C0 X50/X1/X1/X0/C0:pos DVSS cap_nmos_06v0 c_length=1.5e-05 c_width=1.5e-05
XX50/X1/X1/X1/C0 X50/X1/X1/X1/C0:pos DVSS cap_nmos_06v0 c_length=1.5e-05 c_width=1.5e-05
XX50/X1/X2/X0/C0 X50/X1/X2/X0/C0:pos DVSS cap_nmos_06v0 c_length=1.5e-05 c_width=1.5e-05
XX50/X1/X2/X1/C0 X50/X1/X2/X1/C0:pos DVSS cap_nmos_06v0 c_length=1.5e-05 c_width=1.5e-05
XX51/X0/X1/X0/C0 X51/X0/X1/X0/C0:pos DVSS cap_nmos_06v0 c_length=1.5e-05 c_width=1.5e-05
XX51/X0/X1/X1/C0 X51/X0/X1/X1/C0:pos DVSS cap_nmos_06v0 c_length=1.5e-05 c_width=1.5e-05
XX51/X0/X2/X0/C0 X51/X0/X2/X0/C0:pos DVSS cap_nmos_06v0 c_length=1.5e-05 c_width=1.5e-05
XX51/X0/X2/X1/C0 X51/X0/X2/X1/C0:pos DVSS cap_nmos_06v0 c_length=1.5e-05 c_width=1.5e-05
XX51/X1/X1/X0/C0 X51/X1/X1/X0/C0:pos DVSS cap_nmos_06v0 c_length=1.5e-05 c_width=1.5e-05
XX51/X1/X1/X1/C0 X51/X1/X1/X1/C0:pos DVSS cap_nmos_06v0 c_length=1.5e-05 c_width=1.5e-05
XX51/X1/X2/X0/C0 X51/X1/X2/X0/C0:pos DVSS cap_nmos_06v0 c_length=1.5e-05 c_width=1.5e-05
XX51/X1/X2/X1/C0 X51/X1/X2/X1/C0:pos DVSS cap_nmos_06v0 c_length=1.5e-05 c_width=1.5e-05
XX52/X0/X1/X0/C0 X52/X0/X1/X0/C0:pos DVSS cap_nmos_06v0 c_length=1.5e-05 c_width=1.5e-05
XX52/X0/X1/X1/C0 X52/X0/X1/X1/C0:pos DVSS cap_nmos_06v0 c_length=1.5e-05 c_width=1.5e-05
XX52/X0/X2/X0/C0 X52/X0/X2/X0/C0:pos DVSS cap_nmos_06v0 c_length=1.5e-05 c_width=1.5e-05
XX52/X0/X2/X1/C0 X52/X0/X2/X1/C0:pos DVSS cap_nmos_06v0 c_length=1.5e-05 c_width=1.5e-05
XX52/X1/X1/X0/C0 X52/X1/X1/X0/C0:pos DVSS cap_nmos_06v0 c_length=1.5e-05 c_width=1.5e-05
XX52/X1/X1/X1/C0 X52/X1/X1/X1/C0:pos DVSS cap_nmos_06v0 c_length=1.5e-05 c_width=1.5e-05
XX52/X1/X2/X0/C0 X52/X1/X2/X0/C0:pos DVSS cap_nmos_06v0 c_length=1.5e-05 c_width=1.5e-05
XX52/X1/X2/X1/C0 X52/X1/X2/X1/C0:pos DVSS cap_nmos_06v0 c_length=1.5e-05 c_width=1.5e-05
.ends gf180mcu_fd_io__asig_5p0_extracted
