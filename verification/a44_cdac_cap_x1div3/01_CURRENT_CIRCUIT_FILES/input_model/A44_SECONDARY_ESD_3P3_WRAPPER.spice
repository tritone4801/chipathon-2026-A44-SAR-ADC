* A44 frozen wrapper for the official Chipathon io_secondary_3p3 schematic.
* Wrapper pin order is intentionally independent of the Xschem symbol order.
* Source schematic SHA256:
*   55397f86b5f12f00022f74a4c65b6f8f943c9294a10576345514bd8cdba056c9
* The three device lines below are the 2026-08-24 Xschem-generated body.
* Official resistor bulk/body terminal is tied to VDD.

.subckt A44_SECONDARY_ESD_3P3 ASIG TO_GATE VDD VSS
XR1 TO_GATE ASIG VDD ppolyf_u r_width=16e-6 r_length=4e-6
D2 VSS TO_GATE diode_nd2ps_03v3 area='10u * 10u' pj='2*10u + 2*10u' m=4
D1 TO_GATE VDD diode_pd2nw_03v3 area='10u * 10u' pj='2*10u + 2*10u' m=4
.ends A44_SECONDARY_ESD_3P3
