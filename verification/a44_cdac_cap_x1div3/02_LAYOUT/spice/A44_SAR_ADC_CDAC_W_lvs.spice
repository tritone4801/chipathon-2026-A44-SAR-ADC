* NGSPICE file created from A44_CDAC_UNIT_W_R8_M6.ext - technology: gf180mcuD

.subckt A44_CDAC_UNIT_W_R8_M6 VIN CLKS VTOP DCTRL[7] DCTRL[6] DCTRL[5] DCTRL[4] DCTRL[3]
+ DCTRL[2] DCTRL[1] VREFP VDD GND VREFN
X0 VDD A44_TG8_SLICE_UDRV_W_R1_0/XTG_UDRV_W_R0/PCLK_ROW_W_R0/net5 A44_TG8_SLICE_UDRV_W_R1_0/XTG_UDRV_W_R0/P_CLK VDD pfet_03v3 ad=0.6552p pd=2.4u as=0.6552p ps=2.4u w=1.56u l=0.28u
X1 A44_TG8_SLICE_UDRV_W_R1_0/XTG_UDRV_W_R0/P_CLK A44_TG8_SLICE_UDRV_W_R1_0/XTG_UDRV_W_R0/PCLK_ROW_W_R0/net5 VDD VDD pfet_03v3 ad=0.6552p pd=2.4u as=0.6552p ps=2.4u w=1.56u l=0.28u
X2 VDD A44_TG8_SLICE_UDRV_W_R1_0/XTG_UDRV_W_R0/PCLK_ROW_W_R0/net5 A44_TG8_SLICE_UDRV_W_R1_0/XTG_UDRV_W_R0/P_CLK VDD pfet_03v3 ad=0.9269p pd=4.32u as=0.6552p ps=2.4u w=1.56u l=0.28u
X3 A44_TG8_SLICE_UDRV_W_R1_0/XTG_UDRV_W_R0/P_CLK A44_TG8_SLICE_UDRV_W_R1_0/XTG_UDRV_W_R0/PCLK_ROW_W_R0/net5 VDD VDD pfet_03v3 ad=0.6552p pd=2.4u as=0.6552p ps=2.4u w=1.56u l=0.28u
X4 A44_TG8_SLICE_UDRV_W_R1_0/XTG_UDRV_W_R0/P_CLK A44_TG8_SLICE_UDRV_W_R1_0/XTG_UDRV_W_R0/PCLK_ROW_W_R0/net5 VDD VDD pfet_03v3 ad=0.6552p pd=2.4u as=0.9269p ps=4.32u w=1.56u l=0.28u
X5 VDD A44_TG8_SLICE_UDRV_W_R1_0/XTG_UDRV_W_R0/PCLK_ROW_W_R0/net5 A44_TG8_SLICE_UDRV_W_R1_0/XTG_UDRV_W_R0/P_CLK VDD pfet_03v3 ad=0.6552p pd=2.4u as=0.6552p ps=2.4u w=1.56u l=0.28u
X6 VDD A44_TG8_SLICE_UDRV_W_R1_0/XTG_UDRV_W_R0/PCLK_ROW_W_R0/net5 A44_TG8_SLICE_UDRV_W_R1_0/XTG_UDRV_W_R0/P_CLK VDD pfet_03v3 ad=0.6552p pd=2.4u as=0.6552p ps=2.4u w=1.56u l=0.28u
X7 A44_TG8_SLICE_UDRV_W_R1_0/XTG_UDRV_W_R0/P_CLK A44_TG8_SLICE_UDRV_W_R1_0/XTG_UDRV_W_R0/PCLK_ROW_W_R0/net5 VDD VDD pfet_03v3 ad=0.6552p pd=2.4u as=0.6552p ps=2.4u w=1.56u l=0.28u
X8 A44_TG8_SLICE_UDRV_W_R1_0/XTG_UDRV_W_R0/P_CLK A44_TG8_SLICE_UDRV_W_R1_0/XTG_UDRV_W_R0/PCLK_ROW_W_R0/net5 GND GND nfet_03v3 ad=0.3276p pd=1.62u as=0.3276p ps=1.62u w=0.78u l=0.28u
X9 GND A44_TG8_SLICE_UDRV_W_R1_0/XTG_UDRV_W_R0/PCLK_ROW_W_R0/net5 A44_TG8_SLICE_UDRV_W_R1_0/XTG_UDRV_W_R0/P_CLK GND nfet_03v3 ad=0.4641p pd=2.76u as=0.3276p ps=1.62u w=0.78u l=0.28u
X10 A44_TG8_SLICE_UDRV_W_R1_0/XTG_UDRV_W_R0/P_CLK A44_TG8_SLICE_UDRV_W_R1_0/XTG_UDRV_W_R0/PCLK_ROW_W_R0/net5 GND GND nfet_03v3 ad=0.3276p pd=1.62u as=0.3276p ps=1.62u w=0.78u l=0.28u
X11 A44_TG8_SLICE_UDRV_W_R1_0/XTG_UDRV_W_R0/P_CLK A44_TG8_SLICE_UDRV_W_R1_0/XTG_UDRV_W_R0/PCLK_ROW_W_R0/net5 GND GND nfet_03v3 ad=0.3276p pd=1.62u as=0.4641p ps=2.76u w=0.78u l=0.28u
X12 GND A44_TG8_SLICE_UDRV_W_R1_0/XTG_UDRV_W_R0/PCLK_ROW_W_R0/net5 A44_TG8_SLICE_UDRV_W_R1_0/XTG_UDRV_W_R0/P_CLK GND nfet_03v3 ad=0.3276p pd=1.62u as=0.3276p ps=1.62u w=0.78u l=0.28u
X13 GND A44_TG8_SLICE_UDRV_W_R1_0/XTG_UDRV_W_R0/PCLK_ROW_W_R0/net5 A44_TG8_SLICE_UDRV_W_R1_0/XTG_UDRV_W_R0/P_CLK GND nfet_03v3 ad=0.3276p pd=1.62u as=0.3276p ps=1.62u w=0.78u l=0.28u
X14 A44_TG8_SLICE_UDRV_W_R1_0/XTG_UDRV_W_R0/P_CLK A44_TG8_SLICE_UDRV_W_R1_0/XTG_UDRV_W_R0/PCLK_ROW_W_R0/net5 GND GND nfet_03v3 ad=0.3276p pd=1.62u as=0.3276p ps=1.62u w=0.78u l=0.28u
X15 GND A44_TG8_SLICE_UDRV_W_R1_0/XTG_UDRV_W_R0/PCLK_ROW_W_R0/net5 A44_TG8_SLICE_UDRV_W_R1_0/XTG_UDRV_W_R0/P_CLK GND nfet_03v3 ad=0.3276p pd=1.62u as=0.3276p ps=1.62u w=0.78u l=0.28u
X16 A44_TG8_SLICE_UDRV_W_R1_0/XTG_UDRV_W_R0/PCLK_ROW_W_R0/net4 CLKS VDD VDD pfet_03v3 ad=0.6552p pd=2.4u as=0.6552p ps=2.4u w=1.56u l=0.28u
X17 VDD A44_TG8_SLICE_UDRV_W_R1_0/XTG_UDRV_W_R0/PCLK_ROW_W_R0/net4 A44_TG8_SLICE_UDRV_W_R1_0/XTG_UDRV_W_R0/PCLK_ROW_W_R0/net5 VDD pfet_03v3 ad=0.6552p pd=2.4u as=0.6552p ps=2.4u w=1.56u l=0.28u
X18 VDD CLKS A44_TG8_SLICE_UDRV_W_R1_0/XTG_UDRV_W_R0/PCLK_ROW_W_R0/net4 VDD pfet_03v3 ad=0.9269p pd=4.32u as=0.6552p ps=2.4u w=1.56u l=0.28u
X19 A44_TG8_SLICE_UDRV_W_R1_0/XTG_UDRV_W_R0/PCLK_ROW_W_R0/net5 A44_TG8_SLICE_UDRV_W_R1_0/XTG_UDRV_W_R0/PCLK_ROW_W_R0/net4 VDD VDD pfet_03v3 ad=0.6552p pd=2.4u as=0.6552p ps=2.4u w=1.56u l=0.28u
X20 A44_TG8_SLICE_UDRV_W_R1_0/XTG_UDRV_W_R0/PCLK_ROW_W_R0/net5 A44_TG8_SLICE_UDRV_W_R1_0/XTG_UDRV_W_R0/PCLK_ROW_W_R0/net4 VDD VDD pfet_03v3 ad=0.6552p pd=2.4u as=0.9269p ps=4.32u w=1.56u l=0.28u
X21 VDD A44_TG8_SLICE_UDRV_W_R1_0/XTG_UDRV_W_R0/PCLK_ROW_W_R0/net4 A44_TG8_SLICE_UDRV_W_R1_0/XTG_UDRV_W_R0/PCLK_ROW_W_R0/net5 VDD pfet_03v3 ad=0.6552p pd=2.4u as=0.6552p ps=2.4u w=1.56u l=0.28u
X22 GND A44_TG8_SLICE_UDRV_W_R1_0/XTG_UDRV_W_R0/PCLK_ROW_W_R0/net4 A44_TG8_SLICE_UDRV_W_R1_0/XTG_UDRV_W_R0/PCLK_ROW_W_R0/net5 GND nfet_03v3 ad=0.3276p pd=1.62u as=0.3276p ps=1.62u w=0.78u l=0.28u
X23 GND CLKS A44_TG8_SLICE_UDRV_W_R1_0/XTG_UDRV_W_R0/PCLK_ROW_W_R0/net4 GND nfet_03v3 ad=0.4641p pd=2.76u as=0.3276p ps=1.62u w=0.78u l=0.28u
X24 A44_TG8_SLICE_UDRV_W_R1_0/XTG_UDRV_W_R0/PCLK_ROW_W_R0/net5 A44_TG8_SLICE_UDRV_W_R1_0/XTG_UDRV_W_R0/PCLK_ROW_W_R0/net4 GND GND nfet_03v3 ad=0.3276p pd=1.62u as=0.3276p ps=1.62u w=0.78u l=0.28u
X25 A44_TG8_SLICE_UDRV_W_R1_0/XTG_UDRV_W_R0/PCLK_ROW_W_R0/net5 A44_TG8_SLICE_UDRV_W_R1_0/XTG_UDRV_W_R0/PCLK_ROW_W_R0/net4 GND GND nfet_03v3 ad=0.3276p pd=1.62u as=0.4641p ps=2.76u w=0.78u l=0.28u
X26 GND A44_TG8_SLICE_UDRV_W_R1_0/XTG_UDRV_W_R0/PCLK_ROW_W_R0/net4 A44_TG8_SLICE_UDRV_W_R1_0/XTG_UDRV_W_R0/PCLK_ROW_W_R0/net5 GND nfet_03v3 ad=0.3276p pd=1.62u as=0.3276p ps=1.62u w=0.78u l=0.28u
X27 A44_TG8_SLICE_UDRV_W_R1_0/XTG_UDRV_W_R0/PCLK_ROW_W_R0/net4 CLKS GND GND nfet_03v3 ad=0.3276p pd=1.62u as=0.3276p ps=1.62u w=0.78u l=0.28u
X28 A44_TG8_SLICE_UDRV_W_R1_0/XTG_UDRV_W_R0/NCLK_ROW_W_R0/net3 A44_TG8_SLICE_UDRV_W_R1_0/XTG_UDRV_W_R0/NCLK_ROW_W_R0/net2 VDD VDD pfet_03v3 ad=0.6552p pd=2.4u as=0.6552p ps=2.4u w=1.56u l=0.28u
X29 VDD A44_TG8_SLICE_UDRV_W_R1_0/XTG_UDRV_W_R0/NCLK_ROW_W_R0/net3 A44_TG8_SLICE_UDRV_W_R1_0/XTG_UDRV_W_R0/N_CLK VDD pfet_03v3 ad=0.6552p pd=2.4u as=0.6552p ps=2.4u w=1.56u l=0.28u
X30 A44_TG8_SLICE_UDRV_W_R1_0/XTG_UDRV_W_R0/NCLK_ROW_W_R0/net3 A44_TG8_SLICE_UDRV_W_R1_0/XTG_UDRV_W_R0/NCLK_ROW_W_R0/net2 VDD VDD pfet_03v3 ad=0.6552p pd=2.4u as=0.6552p ps=2.4u w=1.56u l=0.28u
X31 A44_TG8_SLICE_UDRV_W_R1_0/XTG_UDRV_W_R0/N_CLK A44_TG8_SLICE_UDRV_W_R1_0/XTG_UDRV_W_R0/NCLK_ROW_W_R0/net3 VDD VDD pfet_03v3 ad=0.6552p pd=2.4u as=0.9269p ps=4.32u w=1.56u l=0.28u
X32 VDD A44_TG8_SLICE_UDRV_W_R1_0/XTG_UDRV_W_R0/NCLK_ROW_W_R0/net2 A44_TG8_SLICE_UDRV_W_R1_0/XTG_UDRV_W_R0/NCLK_ROW_W_R0/net3 VDD pfet_03v3 ad=0.6552p pd=2.4u as=0.6552p ps=2.4u w=1.56u l=0.28u
X33 VDD A44_TG8_SLICE_UDRV_W_R1_0/XTG_UDRV_W_R0/NCLK_ROW_W_R0/net3 A44_TG8_SLICE_UDRV_W_R1_0/XTG_UDRV_W_R0/N_CLK VDD pfet_03v3 ad=0.6552p pd=2.4u as=0.6552p ps=2.4u w=1.56u l=0.28u
X34 VDD A44_TG8_SLICE_UDRV_W_R1_0/XTG_UDRV_W_R0/NCLK_ROW_W_R0/net2 A44_TG8_SLICE_UDRV_W_R1_0/XTG_UDRV_W_R0/NCLK_ROW_W_R0/net3 VDD pfet_03v3 ad=0.9269p pd=4.32u as=0.6552p ps=2.4u w=1.56u l=0.28u
X35 A44_TG8_SLICE_UDRV_W_R1_0/XTG_UDRV_W_R0/N_CLK A44_TG8_SLICE_UDRV_W_R1_0/XTG_UDRV_W_R0/NCLK_ROW_W_R0/net3 VDD VDD pfet_03v3 ad=0.6552p pd=2.4u as=0.6552p ps=2.4u w=1.56u l=0.28u
X36 A44_TG8_SLICE_UDRV_W_R1_0/XTG_UDRV_W_R0/N_CLK A44_TG8_SLICE_UDRV_W_R1_0/XTG_UDRV_W_R0/NCLK_ROW_W_R0/net3 VDD VDD pfet_03v3 ad=0.6552p pd=2.4u as=0.6552p ps=2.4u w=1.56u l=0.28u
X37 VDD A44_TG8_SLICE_UDRV_W_R1_0/XTG_UDRV_W_R0/NCLK_ROW_W_R0/net3 A44_TG8_SLICE_UDRV_W_R1_0/XTG_UDRV_W_R0/N_CLK VDD pfet_03v3 ad=0.6552p pd=2.4u as=0.6552p ps=2.4u w=1.56u l=0.28u
X38 A44_TG8_SLICE_UDRV_W_R1_0/XTG_UDRV_W_R0/N_CLK A44_TG8_SLICE_UDRV_W_R1_0/XTG_UDRV_W_R0/NCLK_ROW_W_R0/net3 GND GND nfet_03v3 ad=0.3276p pd=1.62u as=0.3276p ps=1.62u w=0.78u l=0.28u
X39 GND A44_TG8_SLICE_UDRV_W_R1_0/XTG_UDRV_W_R0/NCLK_ROW_W_R0/net3 A44_TG8_SLICE_UDRV_W_R1_0/XTG_UDRV_W_R0/N_CLK GND nfet_03v3 ad=0.3276p pd=1.62u as=0.3276p ps=1.62u w=0.78u l=0.28u
X40 GND A44_TG8_SLICE_UDRV_W_R1_0/XTG_UDRV_W_R0/NCLK_ROW_W_R0/net2 A44_TG8_SLICE_UDRV_W_R1_0/XTG_UDRV_W_R0/NCLK_ROW_W_R0/net3 GND nfet_03v3 ad=0.3276p pd=1.62u as=0.3276p ps=1.62u w=0.78u l=0.28u
X41 A44_TG8_SLICE_UDRV_W_R1_0/XTG_UDRV_W_R0/N_CLK A44_TG8_SLICE_UDRV_W_R1_0/XTG_UDRV_W_R0/NCLK_ROW_W_R0/net3 GND GND nfet_03v3 ad=0.3276p pd=1.62u as=0.4641p ps=2.76u w=0.78u l=0.28u
X42 GND A44_TG8_SLICE_UDRV_W_R1_0/XTG_UDRV_W_R0/NCLK_ROW_W_R0/net3 A44_TG8_SLICE_UDRV_W_R1_0/XTG_UDRV_W_R0/N_CLK GND nfet_03v3 ad=0.3276p pd=1.62u as=0.3276p ps=1.62u w=0.78u l=0.28u
X43 GND A44_TG8_SLICE_UDRV_W_R1_0/XTG_UDRV_W_R0/NCLK_ROW_W_R0/net2 A44_TG8_SLICE_UDRV_W_R1_0/XTG_UDRV_W_R0/NCLK_ROW_W_R0/net3 GND nfet_03v3 ad=0.4641p pd=2.76u as=0.3276p ps=1.62u w=0.78u l=0.28u
X44 A44_TG8_SLICE_UDRV_W_R1_0/XTG_UDRV_W_R0/NCLK_ROW_W_R0/net3 A44_TG8_SLICE_UDRV_W_R1_0/XTG_UDRV_W_R0/NCLK_ROW_W_R0/net2 GND GND nfet_03v3 ad=0.3276p pd=1.62u as=0.3276p ps=1.62u w=0.78u l=0.28u
X45 GND A44_TG8_SLICE_UDRV_W_R1_0/XTG_UDRV_W_R0/NCLK_ROW_W_R0/net3 A44_TG8_SLICE_UDRV_W_R1_0/XTG_UDRV_W_R0/N_CLK GND nfet_03v3 ad=0.3276p pd=1.62u as=0.3276p ps=1.62u w=0.78u l=0.28u
X46 A44_TG8_SLICE_UDRV_W_R1_0/XTG_UDRV_W_R0/N_CLK A44_TG8_SLICE_UDRV_W_R1_0/XTG_UDRV_W_R0/NCLK_ROW_W_R0/net3 GND GND nfet_03v3 ad=0.3276p pd=1.62u as=0.3276p ps=1.62u w=0.78u l=0.28u
X47 A44_TG8_SLICE_UDRV_W_R1_0/XTG_UDRV_W_R0/NCLK_ROW_W_R0/net3 A44_TG8_SLICE_UDRV_W_R1_0/XTG_UDRV_W_R0/NCLK_ROW_W_R0/net2 GND GND nfet_03v3 ad=0.3276p pd=1.62u as=0.3276p ps=1.62u w=0.78u l=0.28u
X48 A44_TG8_SLICE_UDRV_W_R1_0/XTG_UDRV_W_R0/NCLK_ROW_W_R0/net2 A44_TG8_SLICE_UDRV_W_R1_0/XTG_UDRV_W_R0/NCLK_ROW_W_R0/net1 VDD VDD pfet_03v3 ad=0.6552p pd=2.4u as=0.6552p ps=2.4u w=1.56u l=0.28u
X49 VDD A44_TG8_SLICE_UDRV_W_R1_0/XTG_UDRV_W_R0/NCLK_ROW_W_R0/net1 A44_TG8_SLICE_UDRV_W_R1_0/XTG_UDRV_W_R0/NCLK_ROW_W_R0/net2 VDD pfet_03v3 ad=0.6552p pd=2.4u as=0.6552p ps=2.4u w=1.56u l=0.28u
X50 VDD CLKS A44_TG8_SLICE_UDRV_W_R1_0/XTG_UDRV_W_R0/NCLK_ROW_W_R0/net1 VDD pfet_03v3 ad=0.9269p pd=4.32u as=0.6552p ps=2.4u w=1.56u l=0.28u
X51 A44_TG8_SLICE_UDRV_W_R1_0/XTG_UDRV_W_R0/NCLK_ROW_W_R0/net1 CLKS VDD VDD pfet_03v3 ad=0.6552p pd=2.4u as=0.6552p ps=2.4u w=1.56u l=0.28u
X52 VDD A44_TG8_SLICE_UDRV_W_R1_0/XTG_UDRV_W_R0/NCLK_ROW_W_R0/net1 A44_TG8_SLICE_UDRV_W_R1_0/XTG_UDRV_W_R0/NCLK_ROW_W_R0/net2 VDD pfet_03v3 ad=0.6552p pd=2.4u as=0.9269p ps=4.32u w=1.56u l=0.28u
X53 GND A44_TG8_SLICE_UDRV_W_R1_0/XTG_UDRV_W_R0/NCLK_ROW_W_R0/net1 A44_TG8_SLICE_UDRV_W_R1_0/XTG_UDRV_W_R0/NCLK_ROW_W_R0/net2 GND nfet_03v3 ad=0.3276p pd=1.62u as=0.4641p ps=2.76u w=0.78u l=0.28u
X54 GND CLKS A44_TG8_SLICE_UDRV_W_R1_0/XTG_UDRV_W_R0/NCLK_ROW_W_R0/net1 GND nfet_03v3 ad=0.4641p pd=2.76u as=0.3276p ps=1.62u w=0.78u l=0.28u
X55 A44_TG8_SLICE_UDRV_W_R1_0/XTG_UDRV_W_R0/NCLK_ROW_W_R0/net2 A44_TG8_SLICE_UDRV_W_R1_0/XTG_UDRV_W_R0/NCLK_ROW_W_R0/net1 GND GND nfet_03v3 ad=0.3276p pd=1.62u as=0.3276p ps=1.62u w=0.78u l=0.28u
X56 A44_TG8_SLICE_UDRV_W_R1_0/XTG_UDRV_W_R0/NCLK_ROW_W_R0/net1 CLKS GND GND nfet_03v3 ad=0.3276p pd=1.62u as=0.3276p ps=1.62u w=0.78u l=0.28u
X57 GND A44_TG8_SLICE_UDRV_W_R1_0/XTG_UDRV_W_R0/NCLK_ROW_W_R0/net1 A44_TG8_SLICE_UDRV_W_R1_0/XTG_UDRV_W_R0/NCLK_ROW_W_R0/net2 GND nfet_03v3 ad=0.3276p pd=1.62u as=0.3276p ps=1.62u w=0.78u l=0.28u
X58 VTOP A44_TG8_SLICE_UDRV_W_R1_0/XTG_UDRV_W_R0/P_CLK VIN VDD pfet_03v3 ad=3.69235p pd=13.64u as=3.69235p ps=13.64u w=6.22u l=0.28u
X59 VTOP A44_TG8_SLICE_UDRV_W_R1_0/XTG_UDRV_W_R0/P_CLK VIN VDD pfet_03v3 ad=3.69235p pd=13.64u as=3.69235p ps=13.64u w=6.22u l=0.28u
X60 VTOP A44_TG8_SLICE_UDRV_W_R1_0/XTG_UDRV_W_R0/P_CLK VIN VDD pfet_03v3 ad=3.69235p pd=13.64u as=3.69235p ps=13.64u w=6.22u l=0.28u
X61 VTOP A44_TG8_SLICE_UDRV_W_R1_0/XTG_UDRV_W_R0/P_CLK VIN VDD pfet_03v3 ad=3.69235p pd=13.64u as=3.69235p ps=13.64u w=6.22u l=0.28u
X62 VTOP A44_TG8_SLICE_UDRV_W_R1_0/XTG_UDRV_W_R0/N_CLK VIN GND nfet_03v3 ad=1.8465p pd=7.42u as=1.8465p ps=7.42u w=3.11u l=0.28u
X63 VTOP A44_TG8_SLICE_UDRV_W_R1_0/XTG_UDRV_W_R0/N_CLK VIN GND nfet_03v3 ad=1.8465p pd=7.42u as=1.8465p ps=7.42u w=3.11u l=0.28u
X64 VTOP A44_TG8_SLICE_UDRV_W_R1_0/XTG_UDRV_W_R0/N_CLK VIN GND nfet_03v3 ad=1.8465p pd=7.42u as=1.8465p ps=7.42u w=3.11u l=0.28u
X65 VTOP A44_TG8_SLICE_UDRV_W_R1_0/XTG_UDRV_W_R0/N_CLK VIN GND nfet_03v3 ad=1.8465p pd=7.42u as=1.8465p ps=7.42u w=3.11u l=0.28u
X66 VTOP A44_TG8_SLICE_UDRV_W_R1_0/XTG_UDRV_W_R0/P_CLK VIN VDD pfet_03v3 ad=29.5388p pd=0.10912m as=29.5388p ps=0.10912m w=6.22u l=0.28u
X67 VTOP A44_TG8_SLICE_UDRV_W_R1_0/XTG_UDRV_W_R0/P_CLK VIN VDD pfet_03v3 ad=0 pd=0 as=0 ps=0 w=6.22u l=0.28u
X68 VTOP A44_TG8_SLICE_UDRV_W_R1_0/XTG_UDRV_W_R0/P_CLK VIN VDD pfet_03v3 ad=0 pd=0 as=0 ps=0 w=6.22u l=0.28u
X69 VTOP A44_TG8_SLICE_UDRV_W_R1_0/XTG_UDRV_W_R0/P_CLK VIN VDD pfet_03v3 ad=0 pd=0 as=0 ps=0 w=6.22u l=0.28u
X70 VTOP A44_TG8_SLICE_UDRV_W_R1_0/XTG_UDRV_W_R0/N_CLK VIN GND nfet_03v3 ad=14.772p pd=59.36u as=14.772p ps=59.36u w=3.11u l=0.28u
X71 VTOP A44_TG8_SLICE_UDRV_W_R1_0/XTG_UDRV_W_R0/N_CLK VIN GND nfet_03v3 ad=0 pd=0 as=0 ps=0 w=3.11u l=0.28u
X72 VTOP A44_TG8_SLICE_UDRV_W_R1_0/XTG_UDRV_W_R0/N_CLK VIN GND nfet_03v3 ad=0 pd=0 as=0 ps=0 w=3.11u l=0.28u
X73 VTOP A44_TG8_SLICE_UDRV_W_R1_0/XTG_UDRV_W_R0/N_CLK VIN GND nfet_03v3 ad=0 pd=0 as=0 ps=0 w=3.11u l=0.28u
X74 VREFP A44_DCTRL_STRIP_W_R2_0/CTRL_OUT[7] A44_CDAC_CAP_BANK_ASSEMBLY_R8_M6_0/A44_CAP_CORE128_M6_R1_0/CAP_BOTTOM_048 VDD pfet_03v3 ad=0.9269p pd=4.32u as=0.9269p ps=4.32u w=1.56u l=0.28u
X75 VREFP A44_DCTRL_STRIP_W_R2_0/CTRL_OUT[7] A44_CDAC_CAP_BANK_ASSEMBLY_R8_M6_0/A44_CAP_CORE128_M6_R1_0/CAP_BOTTOM_048 VDD pfet_03v3 ad=0.9269p pd=4.32u as=0.9269p ps=4.32u w=1.56u l=0.28u
X76 VREFP A44_DCTRL_STRIP_W_R2_0/CTRL_OUT[7] A44_CDAC_CAP_BANK_ASSEMBLY_R8_M6_0/A44_CAP_CORE128_M6_R1_0/CAP_BOTTOM_048 VDD pfet_03v3 ad=0.9269p pd=4.32u as=0.9269p ps=4.32u w=1.56u l=0.28u
X77 VREFP A44_DCTRL_STRIP_W_R2_0/CTRL_OUT[7] A44_CDAC_CAP_BANK_ASSEMBLY_R8_M6_0/A44_CAP_CORE128_M6_R1_0/CAP_BOTTOM_048 VDD pfet_03v3 ad=0.9269p pd=4.32u as=0.9269p ps=4.32u w=1.56u l=0.28u
X78 VREFP A44_DCTRL_STRIP_W_R2_0/CTRL_OUT[7] A44_CDAC_CAP_BANK_ASSEMBLY_R8_M6_0/A44_CAP_CORE128_M6_R1_0/CAP_BOTTOM_048 VDD pfet_03v3 ad=0.9269p pd=4.32u as=0.9269p ps=4.32u w=1.56u l=0.28u
X79 VREFP A44_DCTRL_STRIP_W_R2_0/CTRL_OUT[7] A44_CDAC_CAP_BANK_ASSEMBLY_R8_M6_0/A44_CAP_CORE128_M6_R1_0/CAP_BOTTOM_048 VDD pfet_03v3 ad=0.9269p pd=4.32u as=0.9269p ps=4.32u w=1.56u l=0.28u
X80 VREFP A44_DCTRL_STRIP_W_R2_0/CTRL_OUT[7] A44_CDAC_CAP_BANK_ASSEMBLY_R8_M6_0/A44_CAP_CORE128_M6_R1_0/CAP_BOTTOM_048 VDD pfet_03v3 ad=0.9269p pd=4.32u as=0.9269p ps=4.32u w=1.56u l=0.28u
X81 VREFP A44_DCTRL_STRIP_W_R2_0/CTRL_OUT[7] A44_CDAC_CAP_BANK_ASSEMBLY_R8_M6_0/A44_CAP_CORE128_M6_R1_0/CAP_BOTTOM_048 VDD pfet_03v3 ad=0.9269p pd=4.32u as=0.9269p ps=4.32u w=1.56u l=0.28u
X82 VREFP A44_DCTRL_STRIP_W_R2_0/CTRL_OUT[7] A44_CDAC_CAP_BANK_ASSEMBLY_R8_M6_0/A44_CAP_CORE128_M6_R1_0/CAP_BOTTOM_048 VDD pfet_03v3 ad=0.9269p pd=4.32u as=0.9269p ps=4.32u w=1.56u l=0.28u
X83 VREFP A44_DCTRL_STRIP_W_R2_0/CTRL_OUT[7] A44_CDAC_CAP_BANK_ASSEMBLY_R8_M6_0/A44_CAP_CORE128_M6_R1_0/CAP_BOTTOM_048 VDD pfet_03v3 ad=2.11889n pd=9.87552m as=16.6842p ps=77.76u w=1.56u l=0.28u
X84 VREFP A44_DCTRL_STRIP_W_R2_0/CTRL_OUT[7] A44_CDAC_CAP_BANK_ASSEMBLY_R8_M6_0/A44_CAP_CORE128_M6_R1_0/CAP_BOTTOM_048 VDD pfet_03v3 ad=0 pd=0 as=0 ps=0 w=1.56u l=0.28u
X85 VREFP A44_DCTRL_STRIP_W_R2_0/CTRL_OUT[7] A44_CDAC_CAP_BANK_ASSEMBLY_R8_M6_0/A44_CAP_CORE128_M6_R1_0/CAP_BOTTOM_048 VDD pfet_03v3 ad=0 pd=0 as=0 ps=0 w=1.56u l=0.28u
X86 VREFP A44_DCTRL_STRIP_W_R2_0/CTRL_OUT[7] A44_CDAC_CAP_BANK_ASSEMBLY_R8_M6_0/A44_CAP_CORE128_M6_R1_0/CAP_BOTTOM_048 VDD pfet_03v3 ad=0 pd=0 as=0 ps=0 w=1.56u l=0.28u
X87 VREFP A44_DCTRL_STRIP_W_R2_0/CTRL_OUT[7] A44_CDAC_CAP_BANK_ASSEMBLY_R8_M6_0/A44_CAP_CORE128_M6_R1_0/CAP_BOTTOM_048 VDD pfet_03v3 ad=0 pd=0 as=0 ps=0 w=1.56u l=0.28u
X88 VREFP A44_DCTRL_STRIP_W_R2_0/CTRL_OUT[7] A44_CDAC_CAP_BANK_ASSEMBLY_R8_M6_0/A44_CAP_CORE128_M6_R1_0/CAP_BOTTOM_048 VDD pfet_03v3 ad=0 pd=0 as=0 ps=0 w=1.56u l=0.28u
X89 VREFP A44_DCTRL_STRIP_W_R2_0/CTRL_OUT[7] A44_CDAC_CAP_BANK_ASSEMBLY_R8_M6_0/A44_CAP_CORE128_M6_R1_0/CAP_BOTTOM_048 VDD pfet_03v3 ad=0 pd=0 as=0 ps=0 w=1.56u l=0.28u
X90 VREFP A44_DCTRL_STRIP_W_R2_0/CTRL_OUT[7] A44_CDAC_CAP_BANK_ASSEMBLY_R8_M6_0/A44_CAP_CORE128_M6_R1_0/CAP_BOTTOM_048 VDD pfet_03v3 ad=0 pd=0 as=0 ps=0 w=1.56u l=0.28u
X91 VREFP A44_DCTRL_STRIP_W_R2_0/CTRL_OUT[7] A44_CDAC_CAP_BANK_ASSEMBLY_R8_M6_0/A44_CAP_CORE128_M6_R1_0/CAP_BOTTOM_048 VDD pfet_03v3 ad=0 pd=0 as=0 ps=0 w=1.56u l=0.28u
X92 VREFN A44_DCTRL_STRIP_W_R2_0/CTRL_OUT[7] A44_CDAC_CAP_BANK_ASSEMBLY_R8_M6_0/A44_CAP_CORE128_M6_R1_0/CAP_BOTTOM_048 GND nfet_03v3 ad=0.9269p pd=4.32u as=0.9269p ps=4.32u w=1.56u l=0.28u
X93 VREFN A44_DCTRL_STRIP_W_R2_0/CTRL_OUT[7] A44_CDAC_CAP_BANK_ASSEMBLY_R8_M6_0/A44_CAP_CORE128_M6_R1_0/CAP_BOTTOM_048 GND nfet_03v3 ad=0.9269p pd=4.32u as=0.9269p ps=4.32u w=1.56u l=0.28u
X94 VREFN A44_DCTRL_STRIP_W_R2_0/CTRL_OUT[7] A44_CDAC_CAP_BANK_ASSEMBLY_R8_M6_0/A44_CAP_CORE128_M6_R1_0/CAP_BOTTOM_048 GND nfet_03v3 ad=0.9269p pd=4.32u as=0.9269p ps=4.32u w=1.56u l=0.28u
X95 VREFN A44_DCTRL_STRIP_W_R2_0/CTRL_OUT[7] A44_CDAC_CAP_BANK_ASSEMBLY_R8_M6_0/A44_CAP_CORE128_M6_R1_0/CAP_BOTTOM_048 GND nfet_03v3 ad=0.9269p pd=4.32u as=0.9269p ps=4.32u w=1.56u l=0.28u
X96 VREFN A44_DCTRL_STRIP_W_R2_0/CTRL_OUT[7] A44_CDAC_CAP_BANK_ASSEMBLY_R8_M6_0/A44_CAP_CORE128_M6_R1_0/CAP_BOTTOM_048 GND nfet_03v3 ad=0.9269p pd=4.32u as=0.9269p ps=4.32u w=1.56u l=0.28u
X97 VREFN A44_DCTRL_STRIP_W_R2_0/CTRL_OUT[7] A44_CDAC_CAP_BANK_ASSEMBLY_R8_M6_0/A44_CAP_CORE128_M6_R1_0/CAP_BOTTOM_048 GND nfet_03v3 ad=0.9269p pd=4.32u as=0.9269p ps=4.32u w=1.56u l=0.28u
X98 VREFN A44_DCTRL_STRIP_W_R2_0/CTRL_OUT[7] A44_CDAC_CAP_BANK_ASSEMBLY_R8_M6_0/A44_CAP_CORE128_M6_R1_0/CAP_BOTTOM_048 GND nfet_03v3 ad=0.9269p pd=4.32u as=0.9269p ps=4.32u w=1.56u l=0.28u
X99 VREFN A44_DCTRL_STRIP_W_R2_0/CTRL_OUT[7] A44_CDAC_CAP_BANK_ASSEMBLY_R8_M6_0/A44_CAP_CORE128_M6_R1_0/CAP_BOTTOM_048 GND nfet_03v3 ad=0.9269p pd=4.32u as=0.9269p ps=4.32u w=1.56u l=0.28u
X100 VREFN A44_DCTRL_STRIP_W_R2_0/CTRL_OUT[7] A44_CDAC_CAP_BANK_ASSEMBLY_R8_M6_0/A44_CAP_CORE128_M6_R1_0/CAP_BOTTOM_048 GND nfet_03v3 ad=0.9269p pd=4.32u as=0.9269p ps=4.32u w=1.56u l=0.28u
X101 VREFN A44_DCTRL_STRIP_W_R2_0/CTRL_OUT[7] A44_CDAC_CAP_BANK_ASSEMBLY_R8_M6_0/A44_CAP_CORE128_M6_R1_0/CAP_BOTTOM_048 GND nfet_03v3 ad=2.11889n pd=9.87552m as=16.6842p ps=77.76u w=1.56u l=0.28u
X102 VREFN A44_DCTRL_STRIP_W_R2_0/CTRL_OUT[7] A44_CDAC_CAP_BANK_ASSEMBLY_R8_M6_0/A44_CAP_CORE128_M6_R1_0/CAP_BOTTOM_048 GND nfet_03v3 ad=0 pd=0 as=0 ps=0 w=1.56u l=0.28u
X103 VREFN A44_DCTRL_STRIP_W_R2_0/CTRL_OUT[7] A44_CDAC_CAP_BANK_ASSEMBLY_R8_M6_0/A44_CAP_CORE128_M6_R1_0/CAP_BOTTOM_048 GND nfet_03v3 ad=0 pd=0 as=0 ps=0 w=1.56u l=0.28u
X104 VREFN A44_DCTRL_STRIP_W_R2_0/CTRL_OUT[7] A44_CDAC_CAP_BANK_ASSEMBLY_R8_M6_0/A44_CAP_CORE128_M6_R1_0/CAP_BOTTOM_048 GND nfet_03v3 ad=0 pd=0 as=0 ps=0 w=1.56u l=0.28u
X105 VREFN A44_DCTRL_STRIP_W_R2_0/CTRL_OUT[7] A44_CDAC_CAP_BANK_ASSEMBLY_R8_M6_0/A44_CAP_CORE128_M6_R1_0/CAP_BOTTOM_048 GND nfet_03v3 ad=0 pd=0 as=0 ps=0 w=1.56u l=0.28u
X106 VREFN A44_DCTRL_STRIP_W_R2_0/CTRL_OUT[7] A44_CDAC_CAP_BANK_ASSEMBLY_R8_M6_0/A44_CAP_CORE128_M6_R1_0/CAP_BOTTOM_048 GND nfet_03v3 ad=0 pd=0 as=0 ps=0 w=1.56u l=0.28u
X107 VREFN A44_DCTRL_STRIP_W_R2_0/CTRL_OUT[7] A44_CDAC_CAP_BANK_ASSEMBLY_R8_M6_0/A44_CAP_CORE128_M6_R1_0/CAP_BOTTOM_048 GND nfet_03v3 ad=0 pd=0 as=0 ps=0 w=1.56u l=0.28u
X108 VREFN A44_DCTRL_STRIP_W_R2_0/CTRL_OUT[7] A44_CDAC_CAP_BANK_ASSEMBLY_R8_M6_0/A44_CAP_CORE128_M6_R1_0/CAP_BOTTOM_048 GND nfet_03v3 ad=0 pd=0 as=0 ps=0 w=1.56u l=0.28u
X109 VREFN A44_DCTRL_STRIP_W_R2_0/CTRL_OUT[7] A44_CDAC_CAP_BANK_ASSEMBLY_R8_M6_0/A44_CAP_CORE128_M6_R1_0/CAP_BOTTOM_048 GND nfet_03v3 ad=0 pd=0 as=0 ps=0 w=1.56u l=0.28u
X110 VREFP A44_DCTRL_STRIP_W_R2_0/CTRL_OUT[5] A44_CDAC_CAP_BANK_ASSEMBLY_R8_M6_0/A44_CAP_CORE128_M6_R1_0/CAP_BOTTOM_032 VDD pfet_03v3 ad=0 pd=0 as=16.6842p ps=77.76u w=1.56u l=0.28u
X111 VREFP A44_DCTRL_STRIP_W_R2_0/CTRL_OUT[5] A44_CDAC_CAP_BANK_ASSEMBLY_R8_M6_0/A44_CAP_CORE128_M6_R1_0/CAP_BOTTOM_032 VDD pfet_03v3 ad=0 pd=0 as=0 ps=0 w=1.56u l=0.28u
X112 VREFP A44_DCTRL_STRIP_W_R2_0/CTRL_OUT[5] A44_CDAC_CAP_BANK_ASSEMBLY_R8_M6_0/A44_CAP_CORE128_M6_R1_0/CAP_BOTTOM_032 VDD pfet_03v3 ad=0 pd=0 as=0 ps=0 w=1.56u l=0.28u
X113 VREFP A44_DCTRL_STRIP_W_R2_0/CTRL_OUT[5] A44_CDAC_CAP_BANK_ASSEMBLY_R8_M6_0/A44_CAP_CORE128_M6_R1_0/CAP_BOTTOM_032 VDD pfet_03v3 ad=0 pd=0 as=0 ps=0 w=1.56u l=0.28u
X114 VREFP A44_DCTRL_STRIP_W_R2_0/CTRL_OUT[5] A44_CDAC_CAP_BANK_ASSEMBLY_R8_M6_0/A44_CAP_CORE128_M6_R1_0/CAP_BOTTOM_032 VDD pfet_03v3 ad=0 pd=0 as=0 ps=0 w=1.56u l=0.28u
X115 VREFP A44_DCTRL_STRIP_W_R2_0/CTRL_OUT[5] A44_CDAC_CAP_BANK_ASSEMBLY_R8_M6_0/A44_CAP_CORE128_M6_R1_0/CAP_BOTTOM_032 VDD pfet_03v3 ad=0 pd=0 as=0 ps=0 w=1.56u l=0.28u
X116 VREFP A44_DCTRL_STRIP_W_R2_0/CTRL_OUT[5] A44_CDAC_CAP_BANK_ASSEMBLY_R8_M6_0/A44_CAP_CORE128_M6_R1_0/CAP_BOTTOM_032 VDD pfet_03v3 ad=0 pd=0 as=0 ps=0 w=1.56u l=0.28u
X117 VREFP A44_DCTRL_STRIP_W_R2_0/CTRL_OUT[5] A44_CDAC_CAP_BANK_ASSEMBLY_R8_M6_0/A44_CAP_CORE128_M6_R1_0/CAP_BOTTOM_032 VDD pfet_03v3 ad=0 pd=0 as=0 ps=0 w=1.56u l=0.28u
X118 VREFP A44_DCTRL_STRIP_W_R2_0/CTRL_OUT[5] A44_CDAC_CAP_BANK_ASSEMBLY_R8_M6_0/A44_CAP_CORE128_M6_R1_0/CAP_BOTTOM_032 VDD pfet_03v3 ad=0 pd=0 as=0 ps=0 w=1.56u l=0.28u
X119 VREFP A44_DCTRL_STRIP_W_R2_0/CTRL_OUT[5] A44_CDAC_CAP_BANK_ASSEMBLY_R8_M6_0/A44_CAP_CORE128_M6_R1_0/CAP_BOTTOM_032 VDD pfet_03v3 ad=0 pd=0 as=0 ps=0 w=1.56u l=0.28u
X120 VREFP A44_DCTRL_STRIP_W_R2_0/CTRL_OUT[5] A44_CDAC_CAP_BANK_ASSEMBLY_R8_M6_0/A44_CAP_CORE128_M6_R1_0/CAP_BOTTOM_032 VDD pfet_03v3 ad=0 pd=0 as=0 ps=0 w=1.56u l=0.28u
X121 VREFP A44_DCTRL_STRIP_W_R2_0/CTRL_OUT[5] A44_CDAC_CAP_BANK_ASSEMBLY_R8_M6_0/A44_CAP_CORE128_M6_R1_0/CAP_BOTTOM_032 VDD pfet_03v3 ad=0 pd=0 as=0 ps=0 w=1.56u l=0.28u
X122 VREFP A44_DCTRL_STRIP_W_R2_0/CTRL_OUT[5] A44_CDAC_CAP_BANK_ASSEMBLY_R8_M6_0/A44_CAP_CORE128_M6_R1_0/CAP_BOTTOM_032 VDD pfet_03v3 ad=0 pd=0 as=0 ps=0 w=1.56u l=0.28u
X123 VREFP A44_DCTRL_STRIP_W_R2_0/CTRL_OUT[5] A44_CDAC_CAP_BANK_ASSEMBLY_R8_M6_0/A44_CAP_CORE128_M6_R1_0/CAP_BOTTOM_032 VDD pfet_03v3 ad=0 pd=0 as=0 ps=0 w=1.56u l=0.28u
X124 VREFP A44_DCTRL_STRIP_W_R2_0/CTRL_OUT[5] A44_CDAC_CAP_BANK_ASSEMBLY_R8_M6_0/A44_CAP_CORE128_M6_R1_0/CAP_BOTTOM_032 VDD pfet_03v3 ad=0 pd=0 as=0 ps=0 w=1.56u l=0.28u
X125 VREFP A44_DCTRL_STRIP_W_R2_0/CTRL_OUT[5] A44_CDAC_CAP_BANK_ASSEMBLY_R8_M6_0/A44_CAP_CORE128_M6_R1_0/CAP_BOTTOM_032 VDD pfet_03v3 ad=0 pd=0 as=0 ps=0 w=1.56u l=0.28u
X126 VREFP A44_DCTRL_STRIP_W_R2_0/CTRL_OUT[5] A44_CDAC_CAP_BANK_ASSEMBLY_R8_M6_0/A44_CAP_CORE128_M6_R1_0/CAP_BOTTOM_032 VDD pfet_03v3 ad=0 pd=0 as=0 ps=0 w=1.56u l=0.28u
X127 VREFP A44_DCTRL_STRIP_W_R2_0/CTRL_OUT[5] A44_CDAC_CAP_BANK_ASSEMBLY_R8_M6_0/A44_CAP_CORE128_M6_R1_0/CAP_BOTTOM_032 VDD pfet_03v3 ad=0 pd=0 as=0 ps=0 w=1.56u l=0.28u
X128 VREFN A44_DCTRL_STRIP_W_R2_0/CTRL_OUT[5] A44_CDAC_CAP_BANK_ASSEMBLY_R8_M6_0/A44_CAP_CORE128_M6_R1_0/CAP_BOTTOM_032 GND nfet_03v3 ad=0 pd=0 as=16.6842p ps=77.76u w=1.56u l=0.28u
X129 VREFN A44_DCTRL_STRIP_W_R2_0/CTRL_OUT[5] A44_CDAC_CAP_BANK_ASSEMBLY_R8_M6_0/A44_CAP_CORE128_M6_R1_0/CAP_BOTTOM_032 GND nfet_03v3 ad=0 pd=0 as=0 ps=0 w=1.56u l=0.28u
X130 VREFN A44_DCTRL_STRIP_W_R2_0/CTRL_OUT[5] A44_CDAC_CAP_BANK_ASSEMBLY_R8_M6_0/A44_CAP_CORE128_M6_R1_0/CAP_BOTTOM_032 GND nfet_03v3 ad=0 pd=0 as=0 ps=0 w=1.56u l=0.28u
X131 VREFN A44_DCTRL_STRIP_W_R2_0/CTRL_OUT[5] A44_CDAC_CAP_BANK_ASSEMBLY_R8_M6_0/A44_CAP_CORE128_M6_R1_0/CAP_BOTTOM_032 GND nfet_03v3 ad=0 pd=0 as=0 ps=0 w=1.56u l=0.28u
X132 VREFN A44_DCTRL_STRIP_W_R2_0/CTRL_OUT[5] A44_CDAC_CAP_BANK_ASSEMBLY_R8_M6_0/A44_CAP_CORE128_M6_R1_0/CAP_BOTTOM_032 GND nfet_03v3 ad=0 pd=0 as=0 ps=0 w=1.56u l=0.28u
X133 VREFN A44_DCTRL_STRIP_W_R2_0/CTRL_OUT[5] A44_CDAC_CAP_BANK_ASSEMBLY_R8_M6_0/A44_CAP_CORE128_M6_R1_0/CAP_BOTTOM_032 GND nfet_03v3 ad=0 pd=0 as=0 ps=0 w=1.56u l=0.28u
X134 VREFN A44_DCTRL_STRIP_W_R2_0/CTRL_OUT[5] A44_CDAC_CAP_BANK_ASSEMBLY_R8_M6_0/A44_CAP_CORE128_M6_R1_0/CAP_BOTTOM_032 GND nfet_03v3 ad=0 pd=0 as=0 ps=0 w=1.56u l=0.28u
X135 VREFN A44_DCTRL_STRIP_W_R2_0/CTRL_OUT[5] A44_CDAC_CAP_BANK_ASSEMBLY_R8_M6_0/A44_CAP_CORE128_M6_R1_0/CAP_BOTTOM_032 GND nfet_03v3 ad=0 pd=0 as=0 ps=0 w=1.56u l=0.28u
X136 VREFN A44_DCTRL_STRIP_W_R2_0/CTRL_OUT[5] A44_CDAC_CAP_BANK_ASSEMBLY_R8_M6_0/A44_CAP_CORE128_M6_R1_0/CAP_BOTTOM_032 GND nfet_03v3 ad=0 pd=0 as=0 ps=0 w=1.56u l=0.28u
X137 VREFN A44_DCTRL_STRIP_W_R2_0/CTRL_OUT[5] A44_CDAC_CAP_BANK_ASSEMBLY_R8_M6_0/A44_CAP_CORE128_M6_R1_0/CAP_BOTTOM_032 GND nfet_03v3 ad=0 pd=0 as=0 ps=0 w=1.56u l=0.28u
X138 VREFN A44_DCTRL_STRIP_W_R2_0/CTRL_OUT[5] A44_CDAC_CAP_BANK_ASSEMBLY_R8_M6_0/A44_CAP_CORE128_M6_R1_0/CAP_BOTTOM_032 GND nfet_03v3 ad=0 pd=0 as=0 ps=0 w=1.56u l=0.28u
X139 VREFN A44_DCTRL_STRIP_W_R2_0/CTRL_OUT[5] A44_CDAC_CAP_BANK_ASSEMBLY_R8_M6_0/A44_CAP_CORE128_M6_R1_0/CAP_BOTTOM_032 GND nfet_03v3 ad=0 pd=0 as=0 ps=0 w=1.56u l=0.28u
X140 VREFN A44_DCTRL_STRIP_W_R2_0/CTRL_OUT[5] A44_CDAC_CAP_BANK_ASSEMBLY_R8_M6_0/A44_CAP_CORE128_M6_R1_0/CAP_BOTTOM_032 GND nfet_03v3 ad=0 pd=0 as=0 ps=0 w=1.56u l=0.28u
X141 VREFN A44_DCTRL_STRIP_W_R2_0/CTRL_OUT[5] A44_CDAC_CAP_BANK_ASSEMBLY_R8_M6_0/A44_CAP_CORE128_M6_R1_0/CAP_BOTTOM_032 GND nfet_03v3 ad=0 pd=0 as=0 ps=0 w=1.56u l=0.28u
X142 VREFN A44_DCTRL_STRIP_W_R2_0/CTRL_OUT[5] A44_CDAC_CAP_BANK_ASSEMBLY_R8_M6_0/A44_CAP_CORE128_M6_R1_0/CAP_BOTTOM_032 GND nfet_03v3 ad=0 pd=0 as=0 ps=0 w=1.56u l=0.28u
X143 VREFN A44_DCTRL_STRIP_W_R2_0/CTRL_OUT[5] A44_CDAC_CAP_BANK_ASSEMBLY_R8_M6_0/A44_CAP_CORE128_M6_R1_0/CAP_BOTTOM_032 GND nfet_03v3 ad=0 pd=0 as=0 ps=0 w=1.56u l=0.28u
X144 VREFN A44_DCTRL_STRIP_W_R2_0/CTRL_OUT[5] A44_CDAC_CAP_BANK_ASSEMBLY_R8_M6_0/A44_CAP_CORE128_M6_R1_0/CAP_BOTTOM_032 GND nfet_03v3 ad=0 pd=0 as=0 ps=0 w=1.56u l=0.28u
X145 VREFN A44_DCTRL_STRIP_W_R2_0/CTRL_OUT[5] A44_CDAC_CAP_BANK_ASSEMBLY_R8_M6_0/A44_CAP_CORE128_M6_R1_0/CAP_BOTTOM_032 GND nfet_03v3 ad=0 pd=0 as=0 ps=0 w=1.56u l=0.28u
X146 VREFP A44_DCTRL_STRIP_W_R2_0/CTRL_OUT[7] A44_CDAC_CAP_BANK_ASSEMBLY_R8_M6_0/A44_CAP_CORE128_M6_R1_0/CAP_BOTTOM_019 VDD pfet_03v3 ad=0 pd=0 as=16.6842p ps=77.76u w=1.56u l=0.28u
X147 VREFP A44_DCTRL_STRIP_W_R2_0/CTRL_OUT[7] A44_CDAC_CAP_BANK_ASSEMBLY_R8_M6_0/A44_CAP_CORE128_M6_R1_0/CAP_BOTTOM_019 VDD pfet_03v3 ad=0 pd=0 as=0 ps=0 w=1.56u l=0.28u
X148 VREFP A44_DCTRL_STRIP_W_R2_0/CTRL_OUT[7] A44_CDAC_CAP_BANK_ASSEMBLY_R8_M6_0/A44_CAP_CORE128_M6_R1_0/CAP_BOTTOM_019 VDD pfet_03v3 ad=0 pd=0 as=0 ps=0 w=1.56u l=0.28u
X149 VREFP A44_DCTRL_STRIP_W_R2_0/CTRL_OUT[7] A44_CDAC_CAP_BANK_ASSEMBLY_R8_M6_0/A44_CAP_CORE128_M6_R1_0/CAP_BOTTOM_019 VDD pfet_03v3 ad=0 pd=0 as=0 ps=0 w=1.56u l=0.28u
X150 VREFP A44_DCTRL_STRIP_W_R2_0/CTRL_OUT[7] A44_CDAC_CAP_BANK_ASSEMBLY_R8_M6_0/A44_CAP_CORE128_M6_R1_0/CAP_BOTTOM_019 VDD pfet_03v3 ad=0 pd=0 as=0 ps=0 w=1.56u l=0.28u
X151 VREFP A44_DCTRL_STRIP_W_R2_0/CTRL_OUT[7] A44_CDAC_CAP_BANK_ASSEMBLY_R8_M6_0/A44_CAP_CORE128_M6_R1_0/CAP_BOTTOM_019 VDD pfet_03v3 ad=0 pd=0 as=0 ps=0 w=1.56u l=0.28u
X152 VREFP A44_DCTRL_STRIP_W_R2_0/CTRL_OUT[7] A44_CDAC_CAP_BANK_ASSEMBLY_R8_M6_0/A44_CAP_CORE128_M6_R1_0/CAP_BOTTOM_019 VDD pfet_03v3 ad=0 pd=0 as=0 ps=0 w=1.56u l=0.28u
X153 VREFP A44_DCTRL_STRIP_W_R2_0/CTRL_OUT[7] A44_CDAC_CAP_BANK_ASSEMBLY_R8_M6_0/A44_CAP_CORE128_M6_R1_0/CAP_BOTTOM_019 VDD pfet_03v3 ad=0 pd=0 as=0 ps=0 w=1.56u l=0.28u
X154 VREFP A44_DCTRL_STRIP_W_R2_0/CTRL_OUT[7] A44_CDAC_CAP_BANK_ASSEMBLY_R8_M6_0/A44_CAP_CORE128_M6_R1_0/CAP_BOTTOM_019 VDD pfet_03v3 ad=0 pd=0 as=0 ps=0 w=1.56u l=0.28u
X155 VREFP A44_DCTRL_STRIP_W_R2_0/CTRL_OUT[7] A44_CDAC_CAP_BANK_ASSEMBLY_R8_M6_0/A44_CAP_CORE128_M6_R1_0/CAP_BOTTOM_019 VDD pfet_03v3 ad=0 pd=0 as=0 ps=0 w=1.56u l=0.28u
X156 VREFP A44_DCTRL_STRIP_W_R2_0/CTRL_OUT[7] A44_CDAC_CAP_BANK_ASSEMBLY_R8_M6_0/A44_CAP_CORE128_M6_R1_0/CAP_BOTTOM_019 VDD pfet_03v3 ad=0 pd=0 as=0 ps=0 w=1.56u l=0.28u
X157 VREFP A44_DCTRL_STRIP_W_R2_0/CTRL_OUT[7] A44_CDAC_CAP_BANK_ASSEMBLY_R8_M6_0/A44_CAP_CORE128_M6_R1_0/CAP_BOTTOM_019 VDD pfet_03v3 ad=0 pd=0 as=0 ps=0 w=1.56u l=0.28u
X158 VREFP A44_DCTRL_STRIP_W_R2_0/CTRL_OUT[7] A44_CDAC_CAP_BANK_ASSEMBLY_R8_M6_0/A44_CAP_CORE128_M6_R1_0/CAP_BOTTOM_019 VDD pfet_03v3 ad=0 pd=0 as=0 ps=0 w=1.56u l=0.28u
X159 VREFP A44_DCTRL_STRIP_W_R2_0/CTRL_OUT[7] A44_CDAC_CAP_BANK_ASSEMBLY_R8_M6_0/A44_CAP_CORE128_M6_R1_0/CAP_BOTTOM_019 VDD pfet_03v3 ad=0 pd=0 as=0 ps=0 w=1.56u l=0.28u
X160 VREFP A44_DCTRL_STRIP_W_R2_0/CTRL_OUT[7] A44_CDAC_CAP_BANK_ASSEMBLY_R8_M6_0/A44_CAP_CORE128_M6_R1_0/CAP_BOTTOM_019 VDD pfet_03v3 ad=0 pd=0 as=0 ps=0 w=1.56u l=0.28u
X161 VREFP A44_DCTRL_STRIP_W_R2_0/CTRL_OUT[7] A44_CDAC_CAP_BANK_ASSEMBLY_R8_M6_0/A44_CAP_CORE128_M6_R1_0/CAP_BOTTOM_019 VDD pfet_03v3 ad=0 pd=0 as=0 ps=0 w=1.56u l=0.28u
X162 VREFP A44_DCTRL_STRIP_W_R2_0/CTRL_OUT[7] A44_CDAC_CAP_BANK_ASSEMBLY_R8_M6_0/A44_CAP_CORE128_M6_R1_0/CAP_BOTTOM_019 VDD pfet_03v3 ad=0 pd=0 as=0 ps=0 w=1.56u l=0.28u
X163 VREFP A44_DCTRL_STRIP_W_R2_0/CTRL_OUT[7] A44_CDAC_CAP_BANK_ASSEMBLY_R8_M6_0/A44_CAP_CORE128_M6_R1_0/CAP_BOTTOM_019 VDD pfet_03v3 ad=0 pd=0 as=0 ps=0 w=1.56u l=0.28u
X164 VREFN A44_DCTRL_STRIP_W_R2_0/CTRL_OUT[7] A44_CDAC_CAP_BANK_ASSEMBLY_R8_M6_0/A44_CAP_CORE128_M6_R1_0/CAP_BOTTOM_019 GND nfet_03v3 ad=0 pd=0 as=16.6842p ps=77.76u w=1.56u l=0.28u
X165 VREFN A44_DCTRL_STRIP_W_R2_0/CTRL_OUT[7] A44_CDAC_CAP_BANK_ASSEMBLY_R8_M6_0/A44_CAP_CORE128_M6_R1_0/CAP_BOTTOM_019 GND nfet_03v3 ad=0 pd=0 as=0 ps=0 w=1.56u l=0.28u
X166 VREFN A44_DCTRL_STRIP_W_R2_0/CTRL_OUT[7] A44_CDAC_CAP_BANK_ASSEMBLY_R8_M6_0/A44_CAP_CORE128_M6_R1_0/CAP_BOTTOM_019 GND nfet_03v3 ad=0 pd=0 as=0 ps=0 w=1.56u l=0.28u
X167 VREFN A44_DCTRL_STRIP_W_R2_0/CTRL_OUT[7] A44_CDAC_CAP_BANK_ASSEMBLY_R8_M6_0/A44_CAP_CORE128_M6_R1_0/CAP_BOTTOM_019 GND nfet_03v3 ad=0 pd=0 as=0 ps=0 w=1.56u l=0.28u
X168 VREFN A44_DCTRL_STRIP_W_R2_0/CTRL_OUT[7] A44_CDAC_CAP_BANK_ASSEMBLY_R8_M6_0/A44_CAP_CORE128_M6_R1_0/CAP_BOTTOM_019 GND nfet_03v3 ad=0 pd=0 as=0 ps=0 w=1.56u l=0.28u
X169 VREFN A44_DCTRL_STRIP_W_R2_0/CTRL_OUT[7] A44_CDAC_CAP_BANK_ASSEMBLY_R8_M6_0/A44_CAP_CORE128_M6_R1_0/CAP_BOTTOM_019 GND nfet_03v3 ad=0 pd=0 as=0 ps=0 w=1.56u l=0.28u
X170 VREFN A44_DCTRL_STRIP_W_R2_0/CTRL_OUT[7] A44_CDAC_CAP_BANK_ASSEMBLY_R8_M6_0/A44_CAP_CORE128_M6_R1_0/CAP_BOTTOM_019 GND nfet_03v3 ad=0 pd=0 as=0 ps=0 w=1.56u l=0.28u
X171 VREFN A44_DCTRL_STRIP_W_R2_0/CTRL_OUT[7] A44_CDAC_CAP_BANK_ASSEMBLY_R8_M6_0/A44_CAP_CORE128_M6_R1_0/CAP_BOTTOM_019 GND nfet_03v3 ad=0 pd=0 as=0 ps=0 w=1.56u l=0.28u
X172 VREFN A44_DCTRL_STRIP_W_R2_0/CTRL_OUT[7] A44_CDAC_CAP_BANK_ASSEMBLY_R8_M6_0/A44_CAP_CORE128_M6_R1_0/CAP_BOTTOM_019 GND nfet_03v3 ad=0 pd=0 as=0 ps=0 w=1.56u l=0.28u
X173 VREFN A44_DCTRL_STRIP_W_R2_0/CTRL_OUT[7] A44_CDAC_CAP_BANK_ASSEMBLY_R8_M6_0/A44_CAP_CORE128_M6_R1_0/CAP_BOTTOM_019 GND nfet_03v3 ad=0 pd=0 as=0 ps=0 w=1.56u l=0.28u
X174 VREFN A44_DCTRL_STRIP_W_R2_0/CTRL_OUT[7] A44_CDAC_CAP_BANK_ASSEMBLY_R8_M6_0/A44_CAP_CORE128_M6_R1_0/CAP_BOTTOM_019 GND nfet_03v3 ad=0 pd=0 as=0 ps=0 w=1.56u l=0.28u
X175 VREFN A44_DCTRL_STRIP_W_R2_0/CTRL_OUT[7] A44_CDAC_CAP_BANK_ASSEMBLY_R8_M6_0/A44_CAP_CORE128_M6_R1_0/CAP_BOTTOM_019 GND nfet_03v3 ad=0 pd=0 as=0 ps=0 w=1.56u l=0.28u
X176 VREFN A44_DCTRL_STRIP_W_R2_0/CTRL_OUT[7] A44_CDAC_CAP_BANK_ASSEMBLY_R8_M6_0/A44_CAP_CORE128_M6_R1_0/CAP_BOTTOM_019 GND nfet_03v3 ad=0 pd=0 as=0 ps=0 w=1.56u l=0.28u
X177 VREFN A44_DCTRL_STRIP_W_R2_0/CTRL_OUT[7] A44_CDAC_CAP_BANK_ASSEMBLY_R8_M6_0/A44_CAP_CORE128_M6_R1_0/CAP_BOTTOM_019 GND nfet_03v3 ad=0 pd=0 as=0 ps=0 w=1.56u l=0.28u
X178 VREFN A44_DCTRL_STRIP_W_R2_0/CTRL_OUT[7] A44_CDAC_CAP_BANK_ASSEMBLY_R8_M6_0/A44_CAP_CORE128_M6_R1_0/CAP_BOTTOM_019 GND nfet_03v3 ad=0 pd=0 as=0 ps=0 w=1.56u l=0.28u
X179 VREFN A44_DCTRL_STRIP_W_R2_0/CTRL_OUT[7] A44_CDAC_CAP_BANK_ASSEMBLY_R8_M6_0/A44_CAP_CORE128_M6_R1_0/CAP_BOTTOM_019 GND nfet_03v3 ad=0 pd=0 as=0 ps=0 w=1.56u l=0.28u
X180 VREFN A44_DCTRL_STRIP_W_R2_0/CTRL_OUT[7] A44_CDAC_CAP_BANK_ASSEMBLY_R8_M6_0/A44_CAP_CORE128_M6_R1_0/CAP_BOTTOM_019 GND nfet_03v3 ad=0 pd=0 as=0 ps=0 w=1.56u l=0.28u
X181 VREFN A44_DCTRL_STRIP_W_R2_0/CTRL_OUT[7] A44_CDAC_CAP_BANK_ASSEMBLY_R8_M6_0/A44_CAP_CORE128_M6_R1_0/CAP_BOTTOM_019 GND nfet_03v3 ad=0 pd=0 as=0 ps=0 w=1.56u l=0.28u
X182 VREFP A44_DCTRL_STRIP_W_R2_0/CTRL_OUT[6] A44_CDAC_CAP_BANK_ASSEMBLY_R8_M6_0/A44_CAP_CORE128_M6_R1_0/CAP_BOTTOM_003 VDD pfet_03v3 ad=0 pd=0 as=16.6842p ps=77.76u w=1.56u l=0.28u
X183 VREFP A44_DCTRL_STRIP_W_R2_0/CTRL_OUT[6] A44_CDAC_CAP_BANK_ASSEMBLY_R8_M6_0/A44_CAP_CORE128_M6_R1_0/CAP_BOTTOM_003 VDD pfet_03v3 ad=0 pd=0 as=0 ps=0 w=1.56u l=0.28u
X184 VREFP A44_DCTRL_STRIP_W_R2_0/CTRL_OUT[6] A44_CDAC_CAP_BANK_ASSEMBLY_R8_M6_0/A44_CAP_CORE128_M6_R1_0/CAP_BOTTOM_003 VDD pfet_03v3 ad=0 pd=0 as=0 ps=0 w=1.56u l=0.28u
X185 VREFP A44_DCTRL_STRIP_W_R2_0/CTRL_OUT[6] A44_CDAC_CAP_BANK_ASSEMBLY_R8_M6_0/A44_CAP_CORE128_M6_R1_0/CAP_BOTTOM_003 VDD pfet_03v3 ad=0 pd=0 as=0 ps=0 w=1.56u l=0.28u
X186 VREFP A44_DCTRL_STRIP_W_R2_0/CTRL_OUT[6] A44_CDAC_CAP_BANK_ASSEMBLY_R8_M6_0/A44_CAP_CORE128_M6_R1_0/CAP_BOTTOM_003 VDD pfet_03v3 ad=0 pd=0 as=0 ps=0 w=1.56u l=0.28u
X187 VREFP A44_DCTRL_STRIP_W_R2_0/CTRL_OUT[6] A44_CDAC_CAP_BANK_ASSEMBLY_R8_M6_0/A44_CAP_CORE128_M6_R1_0/CAP_BOTTOM_003 VDD pfet_03v3 ad=0 pd=0 as=0 ps=0 w=1.56u l=0.28u
X188 VREFP A44_DCTRL_STRIP_W_R2_0/CTRL_OUT[6] A44_CDAC_CAP_BANK_ASSEMBLY_R8_M6_0/A44_CAP_CORE128_M6_R1_0/CAP_BOTTOM_003 VDD pfet_03v3 ad=0 pd=0 as=0 ps=0 w=1.56u l=0.28u
X189 VREFP A44_DCTRL_STRIP_W_R2_0/CTRL_OUT[6] A44_CDAC_CAP_BANK_ASSEMBLY_R8_M6_0/A44_CAP_CORE128_M6_R1_0/CAP_BOTTOM_003 VDD pfet_03v3 ad=0 pd=0 as=0 ps=0 w=1.56u l=0.28u
X190 VREFP A44_DCTRL_STRIP_W_R2_0/CTRL_OUT[6] A44_CDAC_CAP_BANK_ASSEMBLY_R8_M6_0/A44_CAP_CORE128_M6_R1_0/CAP_BOTTOM_003 VDD pfet_03v3 ad=0 pd=0 as=0 ps=0 w=1.56u l=0.28u
X191 VREFP A44_DCTRL_STRIP_W_R2_0/CTRL_OUT[6] A44_CDAC_CAP_BANK_ASSEMBLY_R8_M6_0/A44_CAP_CORE128_M6_R1_0/CAP_BOTTOM_003 VDD pfet_03v3 ad=0 pd=0 as=0 ps=0 w=1.56u l=0.28u
X192 VREFP A44_DCTRL_STRIP_W_R2_0/CTRL_OUT[6] A44_CDAC_CAP_BANK_ASSEMBLY_R8_M6_0/A44_CAP_CORE128_M6_R1_0/CAP_BOTTOM_003 VDD pfet_03v3 ad=0 pd=0 as=0 ps=0 w=1.56u l=0.28u
X193 VREFP A44_DCTRL_STRIP_W_R2_0/CTRL_OUT[6] A44_CDAC_CAP_BANK_ASSEMBLY_R8_M6_0/A44_CAP_CORE128_M6_R1_0/CAP_BOTTOM_003 VDD pfet_03v3 ad=0 pd=0 as=0 ps=0 w=1.56u l=0.28u
X194 VREFP A44_DCTRL_STRIP_W_R2_0/CTRL_OUT[6] A44_CDAC_CAP_BANK_ASSEMBLY_R8_M6_0/A44_CAP_CORE128_M6_R1_0/CAP_BOTTOM_003 VDD pfet_03v3 ad=0 pd=0 as=0 ps=0 w=1.56u l=0.28u
X195 VREFP A44_DCTRL_STRIP_W_R2_0/CTRL_OUT[6] A44_CDAC_CAP_BANK_ASSEMBLY_R8_M6_0/A44_CAP_CORE128_M6_R1_0/CAP_BOTTOM_003 VDD pfet_03v3 ad=0 pd=0 as=0 ps=0 w=1.56u l=0.28u
X196 VREFP A44_DCTRL_STRIP_W_R2_0/CTRL_OUT[6] A44_CDAC_CAP_BANK_ASSEMBLY_R8_M6_0/A44_CAP_CORE128_M6_R1_0/CAP_BOTTOM_003 VDD pfet_03v3 ad=0 pd=0 as=0 ps=0 w=1.56u l=0.28u
X197 VREFP A44_DCTRL_STRIP_W_R2_0/CTRL_OUT[6] A44_CDAC_CAP_BANK_ASSEMBLY_R8_M6_0/A44_CAP_CORE128_M6_R1_0/CAP_BOTTOM_003 VDD pfet_03v3 ad=0 pd=0 as=0 ps=0 w=1.56u l=0.28u
X198 VREFP A44_DCTRL_STRIP_W_R2_0/CTRL_OUT[6] A44_CDAC_CAP_BANK_ASSEMBLY_R8_M6_0/A44_CAP_CORE128_M6_R1_0/CAP_BOTTOM_003 VDD pfet_03v3 ad=0 pd=0 as=0 ps=0 w=1.56u l=0.28u
X199 VREFP A44_DCTRL_STRIP_W_R2_0/CTRL_OUT[6] A44_CDAC_CAP_BANK_ASSEMBLY_R8_M6_0/A44_CAP_CORE128_M6_R1_0/CAP_BOTTOM_003 VDD pfet_03v3 ad=0 pd=0 as=0 ps=0 w=1.56u l=0.28u
X200 VREFN A44_DCTRL_STRIP_W_R2_0/CTRL_OUT[6] A44_CDAC_CAP_BANK_ASSEMBLY_R8_M6_0/A44_CAP_CORE128_M6_R1_0/CAP_BOTTOM_003 GND nfet_03v3 ad=0 pd=0 as=16.6842p ps=77.76u w=1.56u l=0.28u
X201 VREFN A44_DCTRL_STRIP_W_R2_0/CTRL_OUT[6] A44_CDAC_CAP_BANK_ASSEMBLY_R8_M6_0/A44_CAP_CORE128_M6_R1_0/CAP_BOTTOM_003 GND nfet_03v3 ad=0 pd=0 as=0 ps=0 w=1.56u l=0.28u
X202 VREFN A44_DCTRL_STRIP_W_R2_0/CTRL_OUT[6] A44_CDAC_CAP_BANK_ASSEMBLY_R8_M6_0/A44_CAP_CORE128_M6_R1_0/CAP_BOTTOM_003 GND nfet_03v3 ad=0 pd=0 as=0 ps=0 w=1.56u l=0.28u
X203 VREFN A44_DCTRL_STRIP_W_R2_0/CTRL_OUT[6] A44_CDAC_CAP_BANK_ASSEMBLY_R8_M6_0/A44_CAP_CORE128_M6_R1_0/CAP_BOTTOM_003 GND nfet_03v3 ad=0 pd=0 as=0 ps=0 w=1.56u l=0.28u
X204 VREFN A44_DCTRL_STRIP_W_R2_0/CTRL_OUT[6] A44_CDAC_CAP_BANK_ASSEMBLY_R8_M6_0/A44_CAP_CORE128_M6_R1_0/CAP_BOTTOM_003 GND nfet_03v3 ad=0 pd=0 as=0 ps=0 w=1.56u l=0.28u
X205 VREFN A44_DCTRL_STRIP_W_R2_0/CTRL_OUT[6] A44_CDAC_CAP_BANK_ASSEMBLY_R8_M6_0/A44_CAP_CORE128_M6_R1_0/CAP_BOTTOM_003 GND nfet_03v3 ad=0 pd=0 as=0 ps=0 w=1.56u l=0.28u
X206 VREFN A44_DCTRL_STRIP_W_R2_0/CTRL_OUT[6] A44_CDAC_CAP_BANK_ASSEMBLY_R8_M6_0/A44_CAP_CORE128_M6_R1_0/CAP_BOTTOM_003 GND nfet_03v3 ad=0 pd=0 as=0 ps=0 w=1.56u l=0.28u
X207 VREFN A44_DCTRL_STRIP_W_R2_0/CTRL_OUT[6] A44_CDAC_CAP_BANK_ASSEMBLY_R8_M6_0/A44_CAP_CORE128_M6_R1_0/CAP_BOTTOM_003 GND nfet_03v3 ad=0 pd=0 as=0 ps=0 w=1.56u l=0.28u
X208 VREFN A44_DCTRL_STRIP_W_R2_0/CTRL_OUT[6] A44_CDAC_CAP_BANK_ASSEMBLY_R8_M6_0/A44_CAP_CORE128_M6_R1_0/CAP_BOTTOM_003 GND nfet_03v3 ad=0 pd=0 as=0 ps=0 w=1.56u l=0.28u
X209 VREFN A44_DCTRL_STRIP_W_R2_0/CTRL_OUT[6] A44_CDAC_CAP_BANK_ASSEMBLY_R8_M6_0/A44_CAP_CORE128_M6_R1_0/CAP_BOTTOM_003 GND nfet_03v3 ad=0 pd=0 as=0 ps=0 w=1.56u l=0.28u
X210 VREFN A44_DCTRL_STRIP_W_R2_0/CTRL_OUT[6] A44_CDAC_CAP_BANK_ASSEMBLY_R8_M6_0/A44_CAP_CORE128_M6_R1_0/CAP_BOTTOM_003 GND nfet_03v3 ad=0 pd=0 as=0 ps=0 w=1.56u l=0.28u
X211 VREFN A44_DCTRL_STRIP_W_R2_0/CTRL_OUT[6] A44_CDAC_CAP_BANK_ASSEMBLY_R8_M6_0/A44_CAP_CORE128_M6_R1_0/CAP_BOTTOM_003 GND nfet_03v3 ad=0 pd=0 as=0 ps=0 w=1.56u l=0.28u
X212 VREFN A44_DCTRL_STRIP_W_R2_0/CTRL_OUT[6] A44_CDAC_CAP_BANK_ASSEMBLY_R8_M6_0/A44_CAP_CORE128_M6_R1_0/CAP_BOTTOM_003 GND nfet_03v3 ad=0 pd=0 as=0 ps=0 w=1.56u l=0.28u
X213 VREFN A44_DCTRL_STRIP_W_R2_0/CTRL_OUT[6] A44_CDAC_CAP_BANK_ASSEMBLY_R8_M6_0/A44_CAP_CORE128_M6_R1_0/CAP_BOTTOM_003 GND nfet_03v3 ad=0 pd=0 as=0 ps=0 w=1.56u l=0.28u
X214 VREFN A44_DCTRL_STRIP_W_R2_0/CTRL_OUT[6] A44_CDAC_CAP_BANK_ASSEMBLY_R8_M6_0/A44_CAP_CORE128_M6_R1_0/CAP_BOTTOM_003 GND nfet_03v3 ad=0 pd=0 as=0 ps=0 w=1.56u l=0.28u
X215 VREFN A44_DCTRL_STRIP_W_R2_0/CTRL_OUT[6] A44_CDAC_CAP_BANK_ASSEMBLY_R8_M6_0/A44_CAP_CORE128_M6_R1_0/CAP_BOTTOM_003 GND nfet_03v3 ad=0 pd=0 as=0 ps=0 w=1.56u l=0.28u
X216 VREFN A44_DCTRL_STRIP_W_R2_0/CTRL_OUT[6] A44_CDAC_CAP_BANK_ASSEMBLY_R8_M6_0/A44_CAP_CORE128_M6_R1_0/CAP_BOTTOM_003 GND nfet_03v3 ad=0 pd=0 as=0 ps=0 w=1.56u l=0.28u
X217 VREFN A44_DCTRL_STRIP_W_R2_0/CTRL_OUT[6] A44_CDAC_CAP_BANK_ASSEMBLY_R8_M6_0/A44_CAP_CORE128_M6_R1_0/CAP_BOTTOM_003 GND nfet_03v3 ad=0 pd=0 as=0 ps=0 w=1.56u l=0.28u
X218 VREFP A44_DCTRL_STRIP_W_R2_0/CTRL_OUT[6] A44_CDAC_CAP_BANK_ASSEMBLY_R8_M6_0/A44_CAP_CORE128_M6_R1_0/CAP_BOTTOM_053 VDD pfet_03v3 ad=0 pd=0 as=16.6842p ps=77.76u w=1.56u l=0.28u
X219 VREFP A44_DCTRL_STRIP_W_R2_0/CTRL_OUT[6] A44_CDAC_CAP_BANK_ASSEMBLY_R8_M6_0/A44_CAP_CORE128_M6_R1_0/CAP_BOTTOM_053 VDD pfet_03v3 ad=0 pd=0 as=0 ps=0 w=1.56u l=0.28u
X220 VREFP A44_DCTRL_STRIP_W_R2_0/CTRL_OUT[6] A44_CDAC_CAP_BANK_ASSEMBLY_R8_M6_0/A44_CAP_CORE128_M6_R1_0/CAP_BOTTOM_053 VDD pfet_03v3 ad=0 pd=0 as=0 ps=0 w=1.56u l=0.28u
X221 VREFP A44_DCTRL_STRIP_W_R2_0/CTRL_OUT[6] A44_CDAC_CAP_BANK_ASSEMBLY_R8_M6_0/A44_CAP_CORE128_M6_R1_0/CAP_BOTTOM_053 VDD pfet_03v3 ad=0 pd=0 as=0 ps=0 w=1.56u l=0.28u
X222 VREFP A44_DCTRL_STRIP_W_R2_0/CTRL_OUT[6] A44_CDAC_CAP_BANK_ASSEMBLY_R8_M6_0/A44_CAP_CORE128_M6_R1_0/CAP_BOTTOM_053 VDD pfet_03v3 ad=0 pd=0 as=0 ps=0 w=1.56u l=0.28u
X223 VREFP A44_DCTRL_STRIP_W_R2_0/CTRL_OUT[6] A44_CDAC_CAP_BANK_ASSEMBLY_R8_M6_0/A44_CAP_CORE128_M6_R1_0/CAP_BOTTOM_053 VDD pfet_03v3 ad=0 pd=0 as=0 ps=0 w=1.56u l=0.28u
X224 VREFP A44_DCTRL_STRIP_W_R2_0/CTRL_OUT[6] A44_CDAC_CAP_BANK_ASSEMBLY_R8_M6_0/A44_CAP_CORE128_M6_R1_0/CAP_BOTTOM_053 VDD pfet_03v3 ad=0 pd=0 as=0 ps=0 w=1.56u l=0.28u
X225 VREFP A44_DCTRL_STRIP_W_R2_0/CTRL_OUT[6] A44_CDAC_CAP_BANK_ASSEMBLY_R8_M6_0/A44_CAP_CORE128_M6_R1_0/CAP_BOTTOM_053 VDD pfet_03v3 ad=0 pd=0 as=0 ps=0 w=1.56u l=0.28u
X226 VREFP A44_DCTRL_STRIP_W_R2_0/CTRL_OUT[6] A44_CDAC_CAP_BANK_ASSEMBLY_R8_M6_0/A44_CAP_CORE128_M6_R1_0/CAP_BOTTOM_053 VDD pfet_03v3 ad=0 pd=0 as=0 ps=0 w=1.56u l=0.28u
X227 VREFP A44_DCTRL_STRIP_W_R2_0/CTRL_OUT[6] A44_CDAC_CAP_BANK_ASSEMBLY_R8_M6_0/A44_CAP_CORE128_M6_R1_0/CAP_BOTTOM_053 VDD pfet_03v3 ad=0 pd=0 as=0 ps=0 w=1.56u l=0.28u
X228 VREFP A44_DCTRL_STRIP_W_R2_0/CTRL_OUT[6] A44_CDAC_CAP_BANK_ASSEMBLY_R8_M6_0/A44_CAP_CORE128_M6_R1_0/CAP_BOTTOM_053 VDD pfet_03v3 ad=0 pd=0 as=0 ps=0 w=1.56u l=0.28u
X229 VREFP A44_DCTRL_STRIP_W_R2_0/CTRL_OUT[6] A44_CDAC_CAP_BANK_ASSEMBLY_R8_M6_0/A44_CAP_CORE128_M6_R1_0/CAP_BOTTOM_053 VDD pfet_03v3 ad=0 pd=0 as=0 ps=0 w=1.56u l=0.28u
X230 VREFP A44_DCTRL_STRIP_W_R2_0/CTRL_OUT[6] A44_CDAC_CAP_BANK_ASSEMBLY_R8_M6_0/A44_CAP_CORE128_M6_R1_0/CAP_BOTTOM_053 VDD pfet_03v3 ad=0 pd=0 as=0 ps=0 w=1.56u l=0.28u
X231 VREFP A44_DCTRL_STRIP_W_R2_0/CTRL_OUT[6] A44_CDAC_CAP_BANK_ASSEMBLY_R8_M6_0/A44_CAP_CORE128_M6_R1_0/CAP_BOTTOM_053 VDD pfet_03v3 ad=0 pd=0 as=0 ps=0 w=1.56u l=0.28u
X232 VREFP A44_DCTRL_STRIP_W_R2_0/CTRL_OUT[6] A44_CDAC_CAP_BANK_ASSEMBLY_R8_M6_0/A44_CAP_CORE128_M6_R1_0/CAP_BOTTOM_053 VDD pfet_03v3 ad=0 pd=0 as=0 ps=0 w=1.56u l=0.28u
X233 VREFP A44_DCTRL_STRIP_W_R2_0/CTRL_OUT[6] A44_CDAC_CAP_BANK_ASSEMBLY_R8_M6_0/A44_CAP_CORE128_M6_R1_0/CAP_BOTTOM_053 VDD pfet_03v3 ad=0 pd=0 as=0 ps=0 w=1.56u l=0.28u
X234 VREFP A44_DCTRL_STRIP_W_R2_0/CTRL_OUT[6] A44_CDAC_CAP_BANK_ASSEMBLY_R8_M6_0/A44_CAP_CORE128_M6_R1_0/CAP_BOTTOM_053 VDD pfet_03v3 ad=0 pd=0 as=0 ps=0 w=1.56u l=0.28u
X235 VREFP A44_DCTRL_STRIP_W_R2_0/CTRL_OUT[6] A44_CDAC_CAP_BANK_ASSEMBLY_R8_M6_0/A44_CAP_CORE128_M6_R1_0/CAP_BOTTOM_053 VDD pfet_03v3 ad=0 pd=0 as=0 ps=0 w=1.56u l=0.28u
X236 VREFN A44_DCTRL_STRIP_W_R2_0/CTRL_OUT[6] A44_CDAC_CAP_BANK_ASSEMBLY_R8_M6_0/A44_CAP_CORE128_M6_R1_0/CAP_BOTTOM_053 GND nfet_03v3 ad=0 pd=0 as=16.6842p ps=77.76u w=1.56u l=0.28u
X237 VREFN A44_DCTRL_STRIP_W_R2_0/CTRL_OUT[6] A44_CDAC_CAP_BANK_ASSEMBLY_R8_M6_0/A44_CAP_CORE128_M6_R1_0/CAP_BOTTOM_053 GND nfet_03v3 ad=0 pd=0 as=0 ps=0 w=1.56u l=0.28u
X238 VREFN A44_DCTRL_STRIP_W_R2_0/CTRL_OUT[6] A44_CDAC_CAP_BANK_ASSEMBLY_R8_M6_0/A44_CAP_CORE128_M6_R1_0/CAP_BOTTOM_053 GND nfet_03v3 ad=0 pd=0 as=0 ps=0 w=1.56u l=0.28u
X239 VREFN A44_DCTRL_STRIP_W_R2_0/CTRL_OUT[6] A44_CDAC_CAP_BANK_ASSEMBLY_R8_M6_0/A44_CAP_CORE128_M6_R1_0/CAP_BOTTOM_053 GND nfet_03v3 ad=0 pd=0 as=0 ps=0 w=1.56u l=0.28u
X240 VREFN A44_DCTRL_STRIP_W_R2_0/CTRL_OUT[6] A44_CDAC_CAP_BANK_ASSEMBLY_R8_M6_0/A44_CAP_CORE128_M6_R1_0/CAP_BOTTOM_053 GND nfet_03v3 ad=0 pd=0 as=0 ps=0 w=1.56u l=0.28u
X241 VREFN A44_DCTRL_STRIP_W_R2_0/CTRL_OUT[6] A44_CDAC_CAP_BANK_ASSEMBLY_R8_M6_0/A44_CAP_CORE128_M6_R1_0/CAP_BOTTOM_053 GND nfet_03v3 ad=0 pd=0 as=0 ps=0 w=1.56u l=0.28u
X242 VREFN A44_DCTRL_STRIP_W_R2_0/CTRL_OUT[6] A44_CDAC_CAP_BANK_ASSEMBLY_R8_M6_0/A44_CAP_CORE128_M6_R1_0/CAP_BOTTOM_053 GND nfet_03v3 ad=0 pd=0 as=0 ps=0 w=1.56u l=0.28u
X243 VREFN A44_DCTRL_STRIP_W_R2_0/CTRL_OUT[6] A44_CDAC_CAP_BANK_ASSEMBLY_R8_M6_0/A44_CAP_CORE128_M6_R1_0/CAP_BOTTOM_053 GND nfet_03v3 ad=0 pd=0 as=0 ps=0 w=1.56u l=0.28u
X244 VREFN A44_DCTRL_STRIP_W_R2_0/CTRL_OUT[6] A44_CDAC_CAP_BANK_ASSEMBLY_R8_M6_0/A44_CAP_CORE128_M6_R1_0/CAP_BOTTOM_053 GND nfet_03v3 ad=0 pd=0 as=0 ps=0 w=1.56u l=0.28u
X245 VREFN A44_DCTRL_STRIP_W_R2_0/CTRL_OUT[6] A44_CDAC_CAP_BANK_ASSEMBLY_R8_M6_0/A44_CAP_CORE128_M6_R1_0/CAP_BOTTOM_053 GND nfet_03v3 ad=0 pd=0 as=0 ps=0 w=1.56u l=0.28u
X246 VREFN A44_DCTRL_STRIP_W_R2_0/CTRL_OUT[6] A44_CDAC_CAP_BANK_ASSEMBLY_R8_M6_0/A44_CAP_CORE128_M6_R1_0/CAP_BOTTOM_053 GND nfet_03v3 ad=0 pd=0 as=0 ps=0 w=1.56u l=0.28u
X247 VREFN A44_DCTRL_STRIP_W_R2_0/CTRL_OUT[6] A44_CDAC_CAP_BANK_ASSEMBLY_R8_M6_0/A44_CAP_CORE128_M6_R1_0/CAP_BOTTOM_053 GND nfet_03v3 ad=0 pd=0 as=0 ps=0 w=1.56u l=0.28u
X248 VREFN A44_DCTRL_STRIP_W_R2_0/CTRL_OUT[6] A44_CDAC_CAP_BANK_ASSEMBLY_R8_M6_0/A44_CAP_CORE128_M6_R1_0/CAP_BOTTOM_053 GND nfet_03v3 ad=0 pd=0 as=0 ps=0 w=1.56u l=0.28u
X249 VREFN A44_DCTRL_STRIP_W_R2_0/CTRL_OUT[6] A44_CDAC_CAP_BANK_ASSEMBLY_R8_M6_0/A44_CAP_CORE128_M6_R1_0/CAP_BOTTOM_053 GND nfet_03v3 ad=0 pd=0 as=0 ps=0 w=1.56u l=0.28u
X250 VREFN A44_DCTRL_STRIP_W_R2_0/CTRL_OUT[6] A44_CDAC_CAP_BANK_ASSEMBLY_R8_M6_0/A44_CAP_CORE128_M6_R1_0/CAP_BOTTOM_053 GND nfet_03v3 ad=0 pd=0 as=0 ps=0 w=1.56u l=0.28u
X251 VREFN A44_DCTRL_STRIP_W_R2_0/CTRL_OUT[6] A44_CDAC_CAP_BANK_ASSEMBLY_R8_M6_0/A44_CAP_CORE128_M6_R1_0/CAP_BOTTOM_053 GND nfet_03v3 ad=0 pd=0 as=0 ps=0 w=1.56u l=0.28u
X252 VREFN A44_DCTRL_STRIP_W_R2_0/CTRL_OUT[6] A44_CDAC_CAP_BANK_ASSEMBLY_R8_M6_0/A44_CAP_CORE128_M6_R1_0/CAP_BOTTOM_053 GND nfet_03v3 ad=0 pd=0 as=0 ps=0 w=1.56u l=0.28u
X253 VREFN A44_DCTRL_STRIP_W_R2_0/CTRL_OUT[6] A44_CDAC_CAP_BANK_ASSEMBLY_R8_M6_0/A44_CAP_CORE128_M6_R1_0/CAP_BOTTOM_053 GND nfet_03v3 ad=0 pd=0 as=0 ps=0 w=1.56u l=0.28u
X254 VREFP A44_DCTRL_STRIP_W_R2_0/CTRL_OUT[6] A44_CDAC_CAP_BANK_ASSEMBLY_R8_M6_0/A44_CAP_CORE128_M6_R1_0/CAP_BOTTOM_016 VDD pfet_03v3 ad=0 pd=0 as=16.6842p ps=77.76u w=1.56u l=0.28u
X255 VREFP A44_DCTRL_STRIP_W_R2_0/CTRL_OUT[6] A44_CDAC_CAP_BANK_ASSEMBLY_R8_M6_0/A44_CAP_CORE128_M6_R1_0/CAP_BOTTOM_016 VDD pfet_03v3 ad=0 pd=0 as=0 ps=0 w=1.56u l=0.28u
X256 VREFP A44_DCTRL_STRIP_W_R2_0/CTRL_OUT[6] A44_CDAC_CAP_BANK_ASSEMBLY_R8_M6_0/A44_CAP_CORE128_M6_R1_0/CAP_BOTTOM_016 VDD pfet_03v3 ad=0 pd=0 as=0 ps=0 w=1.56u l=0.28u
X257 VREFP A44_DCTRL_STRIP_W_R2_0/CTRL_OUT[6] A44_CDAC_CAP_BANK_ASSEMBLY_R8_M6_0/A44_CAP_CORE128_M6_R1_0/CAP_BOTTOM_016 VDD pfet_03v3 ad=0 pd=0 as=0 ps=0 w=1.56u l=0.28u
X258 VREFP A44_DCTRL_STRIP_W_R2_0/CTRL_OUT[6] A44_CDAC_CAP_BANK_ASSEMBLY_R8_M6_0/A44_CAP_CORE128_M6_R1_0/CAP_BOTTOM_016 VDD pfet_03v3 ad=0 pd=0 as=0 ps=0 w=1.56u l=0.28u
X259 VREFP A44_DCTRL_STRIP_W_R2_0/CTRL_OUT[6] A44_CDAC_CAP_BANK_ASSEMBLY_R8_M6_0/A44_CAP_CORE128_M6_R1_0/CAP_BOTTOM_016 VDD pfet_03v3 ad=0 pd=0 as=0 ps=0 w=1.56u l=0.28u
X260 VREFP A44_DCTRL_STRIP_W_R2_0/CTRL_OUT[6] A44_CDAC_CAP_BANK_ASSEMBLY_R8_M6_0/A44_CAP_CORE128_M6_R1_0/CAP_BOTTOM_016 VDD pfet_03v3 ad=0 pd=0 as=0 ps=0 w=1.56u l=0.28u
X261 VREFP A44_DCTRL_STRIP_W_R2_0/CTRL_OUT[6] A44_CDAC_CAP_BANK_ASSEMBLY_R8_M6_0/A44_CAP_CORE128_M6_R1_0/CAP_BOTTOM_016 VDD pfet_03v3 ad=0 pd=0 as=0 ps=0 w=1.56u l=0.28u
X262 VREFP A44_DCTRL_STRIP_W_R2_0/CTRL_OUT[6] A44_CDAC_CAP_BANK_ASSEMBLY_R8_M6_0/A44_CAP_CORE128_M6_R1_0/CAP_BOTTOM_016 VDD pfet_03v3 ad=0 pd=0 as=0 ps=0 w=1.56u l=0.28u
X263 VREFP A44_DCTRL_STRIP_W_R2_0/CTRL_OUT[6] A44_CDAC_CAP_BANK_ASSEMBLY_R8_M6_0/A44_CAP_CORE128_M6_R1_0/CAP_BOTTOM_016 VDD pfet_03v3 ad=0 pd=0 as=0 ps=0 w=1.56u l=0.28u
X264 VREFP A44_DCTRL_STRIP_W_R2_0/CTRL_OUT[6] A44_CDAC_CAP_BANK_ASSEMBLY_R8_M6_0/A44_CAP_CORE128_M6_R1_0/CAP_BOTTOM_016 VDD pfet_03v3 ad=0 pd=0 as=0 ps=0 w=1.56u l=0.28u
X265 VREFP A44_DCTRL_STRIP_W_R2_0/CTRL_OUT[6] A44_CDAC_CAP_BANK_ASSEMBLY_R8_M6_0/A44_CAP_CORE128_M6_R1_0/CAP_BOTTOM_016 VDD pfet_03v3 ad=0 pd=0 as=0 ps=0 w=1.56u l=0.28u
X266 VREFP A44_DCTRL_STRIP_W_R2_0/CTRL_OUT[6] A44_CDAC_CAP_BANK_ASSEMBLY_R8_M6_0/A44_CAP_CORE128_M6_R1_0/CAP_BOTTOM_016 VDD pfet_03v3 ad=0 pd=0 as=0 ps=0 w=1.56u l=0.28u
X267 VREFP A44_DCTRL_STRIP_W_R2_0/CTRL_OUT[6] A44_CDAC_CAP_BANK_ASSEMBLY_R8_M6_0/A44_CAP_CORE128_M6_R1_0/CAP_BOTTOM_016 VDD pfet_03v3 ad=0 pd=0 as=0 ps=0 w=1.56u l=0.28u
X268 VREFP A44_DCTRL_STRIP_W_R2_0/CTRL_OUT[6] A44_CDAC_CAP_BANK_ASSEMBLY_R8_M6_0/A44_CAP_CORE128_M6_R1_0/CAP_BOTTOM_016 VDD pfet_03v3 ad=0 pd=0 as=0 ps=0 w=1.56u l=0.28u
X269 VREFP A44_DCTRL_STRIP_W_R2_0/CTRL_OUT[6] A44_CDAC_CAP_BANK_ASSEMBLY_R8_M6_0/A44_CAP_CORE128_M6_R1_0/CAP_BOTTOM_016 VDD pfet_03v3 ad=0 pd=0 as=0 ps=0 w=1.56u l=0.28u
X270 VREFP A44_DCTRL_STRIP_W_R2_0/CTRL_OUT[6] A44_CDAC_CAP_BANK_ASSEMBLY_R8_M6_0/A44_CAP_CORE128_M6_R1_0/CAP_BOTTOM_016 VDD pfet_03v3 ad=0 pd=0 as=0 ps=0 w=1.56u l=0.28u
X271 VREFP A44_DCTRL_STRIP_W_R2_0/CTRL_OUT[6] A44_CDAC_CAP_BANK_ASSEMBLY_R8_M6_0/A44_CAP_CORE128_M6_R1_0/CAP_BOTTOM_016 VDD pfet_03v3 ad=0 pd=0 as=0 ps=0 w=1.56u l=0.28u
X272 VREFN A44_DCTRL_STRIP_W_R2_0/CTRL_OUT[6] A44_CDAC_CAP_BANK_ASSEMBLY_R8_M6_0/A44_CAP_CORE128_M6_R1_0/CAP_BOTTOM_016 GND nfet_03v3 ad=0 pd=0 as=16.6842p ps=77.76u w=1.56u l=0.28u
X273 VREFN A44_DCTRL_STRIP_W_R2_0/CTRL_OUT[6] A44_CDAC_CAP_BANK_ASSEMBLY_R8_M6_0/A44_CAP_CORE128_M6_R1_0/CAP_BOTTOM_016 GND nfet_03v3 ad=0 pd=0 as=0 ps=0 w=1.56u l=0.28u
X274 VREFN A44_DCTRL_STRIP_W_R2_0/CTRL_OUT[6] A44_CDAC_CAP_BANK_ASSEMBLY_R8_M6_0/A44_CAP_CORE128_M6_R1_0/CAP_BOTTOM_016 GND nfet_03v3 ad=0 pd=0 as=0 ps=0 w=1.56u l=0.28u
X275 VREFN A44_DCTRL_STRIP_W_R2_0/CTRL_OUT[6] A44_CDAC_CAP_BANK_ASSEMBLY_R8_M6_0/A44_CAP_CORE128_M6_R1_0/CAP_BOTTOM_016 GND nfet_03v3 ad=0 pd=0 as=0 ps=0 w=1.56u l=0.28u
X276 VREFN A44_DCTRL_STRIP_W_R2_0/CTRL_OUT[6] A44_CDAC_CAP_BANK_ASSEMBLY_R8_M6_0/A44_CAP_CORE128_M6_R1_0/CAP_BOTTOM_016 GND nfet_03v3 ad=0 pd=0 as=0 ps=0 w=1.56u l=0.28u
X277 VREFN A44_DCTRL_STRIP_W_R2_0/CTRL_OUT[6] A44_CDAC_CAP_BANK_ASSEMBLY_R8_M6_0/A44_CAP_CORE128_M6_R1_0/CAP_BOTTOM_016 GND nfet_03v3 ad=0 pd=0 as=0 ps=0 w=1.56u l=0.28u
X278 VREFN A44_DCTRL_STRIP_W_R2_0/CTRL_OUT[6] A44_CDAC_CAP_BANK_ASSEMBLY_R8_M6_0/A44_CAP_CORE128_M6_R1_0/CAP_BOTTOM_016 GND nfet_03v3 ad=0 pd=0 as=0 ps=0 w=1.56u l=0.28u
X279 VREFN A44_DCTRL_STRIP_W_R2_0/CTRL_OUT[6] A44_CDAC_CAP_BANK_ASSEMBLY_R8_M6_0/A44_CAP_CORE128_M6_R1_0/CAP_BOTTOM_016 GND nfet_03v3 ad=0 pd=0 as=0 ps=0 w=1.56u l=0.28u
X280 VREFN A44_DCTRL_STRIP_W_R2_0/CTRL_OUT[6] A44_CDAC_CAP_BANK_ASSEMBLY_R8_M6_0/A44_CAP_CORE128_M6_R1_0/CAP_BOTTOM_016 GND nfet_03v3 ad=0 pd=0 as=0 ps=0 w=1.56u l=0.28u
X281 VREFN A44_DCTRL_STRIP_W_R2_0/CTRL_OUT[6] A44_CDAC_CAP_BANK_ASSEMBLY_R8_M6_0/A44_CAP_CORE128_M6_R1_0/CAP_BOTTOM_016 GND nfet_03v3 ad=0 pd=0 as=0 ps=0 w=1.56u l=0.28u
X282 VREFN A44_DCTRL_STRIP_W_R2_0/CTRL_OUT[6] A44_CDAC_CAP_BANK_ASSEMBLY_R8_M6_0/A44_CAP_CORE128_M6_R1_0/CAP_BOTTOM_016 GND nfet_03v3 ad=0 pd=0 as=0 ps=0 w=1.56u l=0.28u
X283 VREFN A44_DCTRL_STRIP_W_R2_0/CTRL_OUT[6] A44_CDAC_CAP_BANK_ASSEMBLY_R8_M6_0/A44_CAP_CORE128_M6_R1_0/CAP_BOTTOM_016 GND nfet_03v3 ad=0 pd=0 as=0 ps=0 w=1.56u l=0.28u
X284 VREFN A44_DCTRL_STRIP_W_R2_0/CTRL_OUT[6] A44_CDAC_CAP_BANK_ASSEMBLY_R8_M6_0/A44_CAP_CORE128_M6_R1_0/CAP_BOTTOM_016 GND nfet_03v3 ad=0 pd=0 as=0 ps=0 w=1.56u l=0.28u
X285 VREFN A44_DCTRL_STRIP_W_R2_0/CTRL_OUT[6] A44_CDAC_CAP_BANK_ASSEMBLY_R8_M6_0/A44_CAP_CORE128_M6_R1_0/CAP_BOTTOM_016 GND nfet_03v3 ad=0 pd=0 as=0 ps=0 w=1.56u l=0.28u
X286 VREFN A44_DCTRL_STRIP_W_R2_0/CTRL_OUT[6] A44_CDAC_CAP_BANK_ASSEMBLY_R8_M6_0/A44_CAP_CORE128_M6_R1_0/CAP_BOTTOM_016 GND nfet_03v3 ad=0 pd=0 as=0 ps=0 w=1.56u l=0.28u
X287 VREFN A44_DCTRL_STRIP_W_R2_0/CTRL_OUT[6] A44_CDAC_CAP_BANK_ASSEMBLY_R8_M6_0/A44_CAP_CORE128_M6_R1_0/CAP_BOTTOM_016 GND nfet_03v3 ad=0 pd=0 as=0 ps=0 w=1.56u l=0.28u
X288 VREFN A44_DCTRL_STRIP_W_R2_0/CTRL_OUT[6] A44_CDAC_CAP_BANK_ASSEMBLY_R8_M6_0/A44_CAP_CORE128_M6_R1_0/CAP_BOTTOM_016 GND nfet_03v3 ad=0 pd=0 as=0 ps=0 w=1.56u l=0.28u
X289 VREFN A44_DCTRL_STRIP_W_R2_0/CTRL_OUT[6] A44_CDAC_CAP_BANK_ASSEMBLY_R8_M6_0/A44_CAP_CORE128_M6_R1_0/CAP_BOTTOM_016 GND nfet_03v3 ad=0 pd=0 as=0 ps=0 w=1.56u l=0.28u
X290 VREFP A44_DCTRL_STRIP_W_R2_0/CTRL_OUT[7] A44_CDAC_CAP_BANK_ASSEMBLY_R8_M6_0/A44_CAP_CORE128_M6_R1_0/CAP_BOTTOM_037 VDD pfet_03v3 ad=0 pd=0 as=16.6842p ps=77.76u w=1.56u l=0.28u
X291 VREFP A44_DCTRL_STRIP_W_R2_0/CTRL_OUT[7] A44_CDAC_CAP_BANK_ASSEMBLY_R8_M6_0/A44_CAP_CORE128_M6_R1_0/CAP_BOTTOM_037 VDD pfet_03v3 ad=0 pd=0 as=0 ps=0 w=1.56u l=0.28u
X292 VREFP A44_DCTRL_STRIP_W_R2_0/CTRL_OUT[7] A44_CDAC_CAP_BANK_ASSEMBLY_R8_M6_0/A44_CAP_CORE128_M6_R1_0/CAP_BOTTOM_037 VDD pfet_03v3 ad=0 pd=0 as=0 ps=0 w=1.56u l=0.28u
X293 VREFP A44_DCTRL_STRIP_W_R2_0/CTRL_OUT[7] A44_CDAC_CAP_BANK_ASSEMBLY_R8_M6_0/A44_CAP_CORE128_M6_R1_0/CAP_BOTTOM_037 VDD pfet_03v3 ad=0 pd=0 as=0 ps=0 w=1.56u l=0.28u
X294 VREFP A44_DCTRL_STRIP_W_R2_0/CTRL_OUT[7] A44_CDAC_CAP_BANK_ASSEMBLY_R8_M6_0/A44_CAP_CORE128_M6_R1_0/CAP_BOTTOM_037 VDD pfet_03v3 ad=0 pd=0 as=0 ps=0 w=1.56u l=0.28u
X295 VREFP A44_DCTRL_STRIP_W_R2_0/CTRL_OUT[7] A44_CDAC_CAP_BANK_ASSEMBLY_R8_M6_0/A44_CAP_CORE128_M6_R1_0/CAP_BOTTOM_037 VDD pfet_03v3 ad=0 pd=0 as=0 ps=0 w=1.56u l=0.28u
X296 VREFP A44_DCTRL_STRIP_W_R2_0/CTRL_OUT[7] A44_CDAC_CAP_BANK_ASSEMBLY_R8_M6_0/A44_CAP_CORE128_M6_R1_0/CAP_BOTTOM_037 VDD pfet_03v3 ad=0 pd=0 as=0 ps=0 w=1.56u l=0.28u
X297 VREFP A44_DCTRL_STRIP_W_R2_0/CTRL_OUT[7] A44_CDAC_CAP_BANK_ASSEMBLY_R8_M6_0/A44_CAP_CORE128_M6_R1_0/CAP_BOTTOM_037 VDD pfet_03v3 ad=0 pd=0 as=0 ps=0 w=1.56u l=0.28u
X298 VREFP A44_DCTRL_STRIP_W_R2_0/CTRL_OUT[7] A44_CDAC_CAP_BANK_ASSEMBLY_R8_M6_0/A44_CAP_CORE128_M6_R1_0/CAP_BOTTOM_037 VDD pfet_03v3 ad=0 pd=0 as=0 ps=0 w=1.56u l=0.28u
X299 VREFP A44_DCTRL_STRIP_W_R2_0/CTRL_OUT[7] A44_CDAC_CAP_BANK_ASSEMBLY_R8_M6_0/A44_CAP_CORE128_M6_R1_0/CAP_BOTTOM_037 VDD pfet_03v3 ad=0 pd=0 as=0 ps=0 w=1.56u l=0.28u
X300 VREFP A44_DCTRL_STRIP_W_R2_0/CTRL_OUT[7] A44_CDAC_CAP_BANK_ASSEMBLY_R8_M6_0/A44_CAP_CORE128_M6_R1_0/CAP_BOTTOM_037 VDD pfet_03v3 ad=0 pd=0 as=0 ps=0 w=1.56u l=0.28u
X301 VREFP A44_DCTRL_STRIP_W_R2_0/CTRL_OUT[7] A44_CDAC_CAP_BANK_ASSEMBLY_R8_M6_0/A44_CAP_CORE128_M6_R1_0/CAP_BOTTOM_037 VDD pfet_03v3 ad=0 pd=0 as=0 ps=0 w=1.56u l=0.28u
X302 VREFP A44_DCTRL_STRIP_W_R2_0/CTRL_OUT[7] A44_CDAC_CAP_BANK_ASSEMBLY_R8_M6_0/A44_CAP_CORE128_M6_R1_0/CAP_BOTTOM_037 VDD pfet_03v3 ad=0 pd=0 as=0 ps=0 w=1.56u l=0.28u
X303 VREFP A44_DCTRL_STRIP_W_R2_0/CTRL_OUT[7] A44_CDAC_CAP_BANK_ASSEMBLY_R8_M6_0/A44_CAP_CORE128_M6_R1_0/CAP_BOTTOM_037 VDD pfet_03v3 ad=0 pd=0 as=0 ps=0 w=1.56u l=0.28u
X304 VREFP A44_DCTRL_STRIP_W_R2_0/CTRL_OUT[7] A44_CDAC_CAP_BANK_ASSEMBLY_R8_M6_0/A44_CAP_CORE128_M6_R1_0/CAP_BOTTOM_037 VDD pfet_03v3 ad=0 pd=0 as=0 ps=0 w=1.56u l=0.28u
X305 VREFP A44_DCTRL_STRIP_W_R2_0/CTRL_OUT[7] A44_CDAC_CAP_BANK_ASSEMBLY_R8_M6_0/A44_CAP_CORE128_M6_R1_0/CAP_BOTTOM_037 VDD pfet_03v3 ad=0 pd=0 as=0 ps=0 w=1.56u l=0.28u
X306 VREFP A44_DCTRL_STRIP_W_R2_0/CTRL_OUT[7] A44_CDAC_CAP_BANK_ASSEMBLY_R8_M6_0/A44_CAP_CORE128_M6_R1_0/CAP_BOTTOM_037 VDD pfet_03v3 ad=0 pd=0 as=0 ps=0 w=1.56u l=0.28u
X307 VREFP A44_DCTRL_STRIP_W_R2_0/CTRL_OUT[7] A44_CDAC_CAP_BANK_ASSEMBLY_R8_M6_0/A44_CAP_CORE128_M6_R1_0/CAP_BOTTOM_037 VDD pfet_03v3 ad=0 pd=0 as=0 ps=0 w=1.56u l=0.28u
X308 VREFN A44_DCTRL_STRIP_W_R2_0/CTRL_OUT[7] A44_CDAC_CAP_BANK_ASSEMBLY_R8_M6_0/A44_CAP_CORE128_M6_R1_0/CAP_BOTTOM_037 GND nfet_03v3 ad=0 pd=0 as=16.6842p ps=77.76u w=1.56u l=0.28u
X309 VREFN A44_DCTRL_STRIP_W_R2_0/CTRL_OUT[7] A44_CDAC_CAP_BANK_ASSEMBLY_R8_M6_0/A44_CAP_CORE128_M6_R1_0/CAP_BOTTOM_037 GND nfet_03v3 ad=0 pd=0 as=0 ps=0 w=1.56u l=0.28u
X310 VREFN A44_DCTRL_STRIP_W_R2_0/CTRL_OUT[7] A44_CDAC_CAP_BANK_ASSEMBLY_R8_M6_0/A44_CAP_CORE128_M6_R1_0/CAP_BOTTOM_037 GND nfet_03v3 ad=0 pd=0 as=0 ps=0 w=1.56u l=0.28u
X311 VREFN A44_DCTRL_STRIP_W_R2_0/CTRL_OUT[7] A44_CDAC_CAP_BANK_ASSEMBLY_R8_M6_0/A44_CAP_CORE128_M6_R1_0/CAP_BOTTOM_037 GND nfet_03v3 ad=0 pd=0 as=0 ps=0 w=1.56u l=0.28u
X312 VREFN A44_DCTRL_STRIP_W_R2_0/CTRL_OUT[7] A44_CDAC_CAP_BANK_ASSEMBLY_R8_M6_0/A44_CAP_CORE128_M6_R1_0/CAP_BOTTOM_037 GND nfet_03v3 ad=0 pd=0 as=0 ps=0 w=1.56u l=0.28u
X313 VREFN A44_DCTRL_STRIP_W_R2_0/CTRL_OUT[7] A44_CDAC_CAP_BANK_ASSEMBLY_R8_M6_0/A44_CAP_CORE128_M6_R1_0/CAP_BOTTOM_037 GND nfet_03v3 ad=0 pd=0 as=0 ps=0 w=1.56u l=0.28u
X314 VREFN A44_DCTRL_STRIP_W_R2_0/CTRL_OUT[7] A44_CDAC_CAP_BANK_ASSEMBLY_R8_M6_0/A44_CAP_CORE128_M6_R1_0/CAP_BOTTOM_037 GND nfet_03v3 ad=0 pd=0 as=0 ps=0 w=1.56u l=0.28u
X315 VREFN A44_DCTRL_STRIP_W_R2_0/CTRL_OUT[7] A44_CDAC_CAP_BANK_ASSEMBLY_R8_M6_0/A44_CAP_CORE128_M6_R1_0/CAP_BOTTOM_037 GND nfet_03v3 ad=0 pd=0 as=0 ps=0 w=1.56u l=0.28u
X316 VREFN A44_DCTRL_STRIP_W_R2_0/CTRL_OUT[7] A44_CDAC_CAP_BANK_ASSEMBLY_R8_M6_0/A44_CAP_CORE128_M6_R1_0/CAP_BOTTOM_037 GND nfet_03v3 ad=0 pd=0 as=0 ps=0 w=1.56u l=0.28u
X317 VREFN A44_DCTRL_STRIP_W_R2_0/CTRL_OUT[7] A44_CDAC_CAP_BANK_ASSEMBLY_R8_M6_0/A44_CAP_CORE128_M6_R1_0/CAP_BOTTOM_037 GND nfet_03v3 ad=0 pd=0 as=0 ps=0 w=1.56u l=0.28u
X318 VREFN A44_DCTRL_STRIP_W_R2_0/CTRL_OUT[7] A44_CDAC_CAP_BANK_ASSEMBLY_R8_M6_0/A44_CAP_CORE128_M6_R1_0/CAP_BOTTOM_037 GND nfet_03v3 ad=0 pd=0 as=0 ps=0 w=1.56u l=0.28u
X319 VREFN A44_DCTRL_STRIP_W_R2_0/CTRL_OUT[7] A44_CDAC_CAP_BANK_ASSEMBLY_R8_M6_0/A44_CAP_CORE128_M6_R1_0/CAP_BOTTOM_037 GND nfet_03v3 ad=0 pd=0 as=0 ps=0 w=1.56u l=0.28u
X320 VREFN A44_DCTRL_STRIP_W_R2_0/CTRL_OUT[7] A44_CDAC_CAP_BANK_ASSEMBLY_R8_M6_0/A44_CAP_CORE128_M6_R1_0/CAP_BOTTOM_037 GND nfet_03v3 ad=0 pd=0 as=0 ps=0 w=1.56u l=0.28u
X321 VREFN A44_DCTRL_STRIP_W_R2_0/CTRL_OUT[7] A44_CDAC_CAP_BANK_ASSEMBLY_R8_M6_0/A44_CAP_CORE128_M6_R1_0/CAP_BOTTOM_037 GND nfet_03v3 ad=0 pd=0 as=0 ps=0 w=1.56u l=0.28u
X322 VREFN A44_DCTRL_STRIP_W_R2_0/CTRL_OUT[7] A44_CDAC_CAP_BANK_ASSEMBLY_R8_M6_0/A44_CAP_CORE128_M6_R1_0/CAP_BOTTOM_037 GND nfet_03v3 ad=0 pd=0 as=0 ps=0 w=1.56u l=0.28u
X323 VREFN A44_DCTRL_STRIP_W_R2_0/CTRL_OUT[7] A44_CDAC_CAP_BANK_ASSEMBLY_R8_M6_0/A44_CAP_CORE128_M6_R1_0/CAP_BOTTOM_037 GND nfet_03v3 ad=0 pd=0 as=0 ps=0 w=1.56u l=0.28u
X324 VREFN A44_DCTRL_STRIP_W_R2_0/CTRL_OUT[7] A44_CDAC_CAP_BANK_ASSEMBLY_R8_M6_0/A44_CAP_CORE128_M6_R1_0/CAP_BOTTOM_037 GND nfet_03v3 ad=0 pd=0 as=0 ps=0 w=1.56u l=0.28u
X325 VREFN A44_DCTRL_STRIP_W_R2_0/CTRL_OUT[7] A44_CDAC_CAP_BANK_ASSEMBLY_R8_M6_0/A44_CAP_CORE128_M6_R1_0/CAP_BOTTOM_037 GND nfet_03v3 ad=0 pd=0 as=0 ps=0 w=1.56u l=0.28u
X326 VREFP A44_DCTRL_STRIP_W_R2_0/CTRL_OUT[7] A44_CDAC_CAP_BANK_ASSEMBLY_R8_M6_0/A44_CAP_CORE128_M6_R1_0/CAP_BOTTOM_000 VDD pfet_03v3 ad=0 pd=0 as=16.6842p ps=77.76u w=1.56u l=0.28u
X327 VREFP A44_DCTRL_STRIP_W_R2_0/CTRL_OUT[7] A44_CDAC_CAP_BANK_ASSEMBLY_R8_M6_0/A44_CAP_CORE128_M6_R1_0/CAP_BOTTOM_000 VDD pfet_03v3 ad=0 pd=0 as=0 ps=0 w=1.56u l=0.28u
X328 VREFP A44_DCTRL_STRIP_W_R2_0/CTRL_OUT[7] A44_CDAC_CAP_BANK_ASSEMBLY_R8_M6_0/A44_CAP_CORE128_M6_R1_0/CAP_BOTTOM_000 VDD pfet_03v3 ad=0 pd=0 as=0 ps=0 w=1.56u l=0.28u
X329 VREFP A44_DCTRL_STRIP_W_R2_0/CTRL_OUT[7] A44_CDAC_CAP_BANK_ASSEMBLY_R8_M6_0/A44_CAP_CORE128_M6_R1_0/CAP_BOTTOM_000 VDD pfet_03v3 ad=0 pd=0 as=0 ps=0 w=1.56u l=0.28u
X330 VREFP A44_DCTRL_STRIP_W_R2_0/CTRL_OUT[7] A44_CDAC_CAP_BANK_ASSEMBLY_R8_M6_0/A44_CAP_CORE128_M6_R1_0/CAP_BOTTOM_000 VDD pfet_03v3 ad=0 pd=0 as=0 ps=0 w=1.56u l=0.28u
X331 VREFP A44_DCTRL_STRIP_W_R2_0/CTRL_OUT[7] A44_CDAC_CAP_BANK_ASSEMBLY_R8_M6_0/A44_CAP_CORE128_M6_R1_0/CAP_BOTTOM_000 VDD pfet_03v3 ad=0 pd=0 as=0 ps=0 w=1.56u l=0.28u
X332 VREFP A44_DCTRL_STRIP_W_R2_0/CTRL_OUT[7] A44_CDAC_CAP_BANK_ASSEMBLY_R8_M6_0/A44_CAP_CORE128_M6_R1_0/CAP_BOTTOM_000 VDD pfet_03v3 ad=0 pd=0 as=0 ps=0 w=1.56u l=0.28u
X333 VREFP A44_DCTRL_STRIP_W_R2_0/CTRL_OUT[7] A44_CDAC_CAP_BANK_ASSEMBLY_R8_M6_0/A44_CAP_CORE128_M6_R1_0/CAP_BOTTOM_000 VDD pfet_03v3 ad=0 pd=0 as=0 ps=0 w=1.56u l=0.28u
X334 VREFP A44_DCTRL_STRIP_W_R2_0/CTRL_OUT[7] A44_CDAC_CAP_BANK_ASSEMBLY_R8_M6_0/A44_CAP_CORE128_M6_R1_0/CAP_BOTTOM_000 VDD pfet_03v3 ad=0 pd=0 as=0 ps=0 w=1.56u l=0.28u
X335 VREFP A44_DCTRL_STRIP_W_R2_0/CTRL_OUT[7] A44_CDAC_CAP_BANK_ASSEMBLY_R8_M6_0/A44_CAP_CORE128_M6_R1_0/CAP_BOTTOM_000 VDD pfet_03v3 ad=0 pd=0 as=0 ps=0 w=1.56u l=0.28u
X336 VREFP A44_DCTRL_STRIP_W_R2_0/CTRL_OUT[7] A44_CDAC_CAP_BANK_ASSEMBLY_R8_M6_0/A44_CAP_CORE128_M6_R1_0/CAP_BOTTOM_000 VDD pfet_03v3 ad=0 pd=0 as=0 ps=0 w=1.56u l=0.28u
X337 VREFP A44_DCTRL_STRIP_W_R2_0/CTRL_OUT[7] A44_CDAC_CAP_BANK_ASSEMBLY_R8_M6_0/A44_CAP_CORE128_M6_R1_0/CAP_BOTTOM_000 VDD pfet_03v3 ad=0 pd=0 as=0 ps=0 w=1.56u l=0.28u
X338 VREFP A44_DCTRL_STRIP_W_R2_0/CTRL_OUT[7] A44_CDAC_CAP_BANK_ASSEMBLY_R8_M6_0/A44_CAP_CORE128_M6_R1_0/CAP_BOTTOM_000 VDD pfet_03v3 ad=0 pd=0 as=0 ps=0 w=1.56u l=0.28u
X339 VREFP A44_DCTRL_STRIP_W_R2_0/CTRL_OUT[7] A44_CDAC_CAP_BANK_ASSEMBLY_R8_M6_0/A44_CAP_CORE128_M6_R1_0/CAP_BOTTOM_000 VDD pfet_03v3 ad=0 pd=0 as=0 ps=0 w=1.56u l=0.28u
X340 VREFP A44_DCTRL_STRIP_W_R2_0/CTRL_OUT[7] A44_CDAC_CAP_BANK_ASSEMBLY_R8_M6_0/A44_CAP_CORE128_M6_R1_0/CAP_BOTTOM_000 VDD pfet_03v3 ad=0 pd=0 as=0 ps=0 w=1.56u l=0.28u
X341 VREFP A44_DCTRL_STRIP_W_R2_0/CTRL_OUT[7] A44_CDAC_CAP_BANK_ASSEMBLY_R8_M6_0/A44_CAP_CORE128_M6_R1_0/CAP_BOTTOM_000 VDD pfet_03v3 ad=0 pd=0 as=0 ps=0 w=1.56u l=0.28u
X342 VREFP A44_DCTRL_STRIP_W_R2_0/CTRL_OUT[7] A44_CDAC_CAP_BANK_ASSEMBLY_R8_M6_0/A44_CAP_CORE128_M6_R1_0/CAP_BOTTOM_000 VDD pfet_03v3 ad=0 pd=0 as=0 ps=0 w=1.56u l=0.28u
X343 VREFP A44_DCTRL_STRIP_W_R2_0/CTRL_OUT[7] A44_CDAC_CAP_BANK_ASSEMBLY_R8_M6_0/A44_CAP_CORE128_M6_R1_0/CAP_BOTTOM_000 VDD pfet_03v3 ad=0 pd=0 as=0 ps=0 w=1.56u l=0.28u
X344 VREFN A44_DCTRL_STRIP_W_R2_0/CTRL_OUT[7] A44_CDAC_CAP_BANK_ASSEMBLY_R8_M6_0/A44_CAP_CORE128_M6_R1_0/CAP_BOTTOM_000 GND nfet_03v3 ad=0 pd=0 as=16.6842p ps=77.76u w=1.56u l=0.28u
X345 VREFN A44_DCTRL_STRIP_W_R2_0/CTRL_OUT[7] A44_CDAC_CAP_BANK_ASSEMBLY_R8_M6_0/A44_CAP_CORE128_M6_R1_0/CAP_BOTTOM_000 GND nfet_03v3 ad=0 pd=0 as=0 ps=0 w=1.56u l=0.28u
X346 VREFN A44_DCTRL_STRIP_W_R2_0/CTRL_OUT[7] A44_CDAC_CAP_BANK_ASSEMBLY_R8_M6_0/A44_CAP_CORE128_M6_R1_0/CAP_BOTTOM_000 GND nfet_03v3 ad=0 pd=0 as=0 ps=0 w=1.56u l=0.28u
X347 VREFN A44_DCTRL_STRIP_W_R2_0/CTRL_OUT[7] A44_CDAC_CAP_BANK_ASSEMBLY_R8_M6_0/A44_CAP_CORE128_M6_R1_0/CAP_BOTTOM_000 GND nfet_03v3 ad=0 pd=0 as=0 ps=0 w=1.56u l=0.28u
X348 VREFN A44_DCTRL_STRIP_W_R2_0/CTRL_OUT[7] A44_CDAC_CAP_BANK_ASSEMBLY_R8_M6_0/A44_CAP_CORE128_M6_R1_0/CAP_BOTTOM_000 GND nfet_03v3 ad=0 pd=0 as=0 ps=0 w=1.56u l=0.28u
X349 VREFN A44_DCTRL_STRIP_W_R2_0/CTRL_OUT[7] A44_CDAC_CAP_BANK_ASSEMBLY_R8_M6_0/A44_CAP_CORE128_M6_R1_0/CAP_BOTTOM_000 GND nfet_03v3 ad=0 pd=0 as=0 ps=0 w=1.56u l=0.28u
X350 VREFN A44_DCTRL_STRIP_W_R2_0/CTRL_OUT[7] A44_CDAC_CAP_BANK_ASSEMBLY_R8_M6_0/A44_CAP_CORE128_M6_R1_0/CAP_BOTTOM_000 GND nfet_03v3 ad=0 pd=0 as=0 ps=0 w=1.56u l=0.28u
X351 VREFN A44_DCTRL_STRIP_W_R2_0/CTRL_OUT[7] A44_CDAC_CAP_BANK_ASSEMBLY_R8_M6_0/A44_CAP_CORE128_M6_R1_0/CAP_BOTTOM_000 GND nfet_03v3 ad=0 pd=0 as=0 ps=0 w=1.56u l=0.28u
X352 VREFN A44_DCTRL_STRIP_W_R2_0/CTRL_OUT[7] A44_CDAC_CAP_BANK_ASSEMBLY_R8_M6_0/A44_CAP_CORE128_M6_R1_0/CAP_BOTTOM_000 GND nfet_03v3 ad=0 pd=0 as=0 ps=0 w=1.56u l=0.28u
X353 VREFN A44_DCTRL_STRIP_W_R2_0/CTRL_OUT[7] A44_CDAC_CAP_BANK_ASSEMBLY_R8_M6_0/A44_CAP_CORE128_M6_R1_0/CAP_BOTTOM_000 GND nfet_03v3 ad=0 pd=0 as=0 ps=0 w=1.56u l=0.28u
X354 VREFN A44_DCTRL_STRIP_W_R2_0/CTRL_OUT[7] A44_CDAC_CAP_BANK_ASSEMBLY_R8_M6_0/A44_CAP_CORE128_M6_R1_0/CAP_BOTTOM_000 GND nfet_03v3 ad=0 pd=0 as=0 ps=0 w=1.56u l=0.28u
X355 VREFN A44_DCTRL_STRIP_W_R2_0/CTRL_OUT[7] A44_CDAC_CAP_BANK_ASSEMBLY_R8_M6_0/A44_CAP_CORE128_M6_R1_0/CAP_BOTTOM_000 GND nfet_03v3 ad=0 pd=0 as=0 ps=0 w=1.56u l=0.28u
X356 VREFN A44_DCTRL_STRIP_W_R2_0/CTRL_OUT[7] A44_CDAC_CAP_BANK_ASSEMBLY_R8_M6_0/A44_CAP_CORE128_M6_R1_0/CAP_BOTTOM_000 GND nfet_03v3 ad=0 pd=0 as=0 ps=0 w=1.56u l=0.28u
X357 VREFN A44_DCTRL_STRIP_W_R2_0/CTRL_OUT[7] A44_CDAC_CAP_BANK_ASSEMBLY_R8_M6_0/A44_CAP_CORE128_M6_R1_0/CAP_BOTTOM_000 GND nfet_03v3 ad=0 pd=0 as=0 ps=0 w=1.56u l=0.28u
X358 VREFN A44_DCTRL_STRIP_W_R2_0/CTRL_OUT[7] A44_CDAC_CAP_BANK_ASSEMBLY_R8_M6_0/A44_CAP_CORE128_M6_R1_0/CAP_BOTTOM_000 GND nfet_03v3 ad=0 pd=0 as=0 ps=0 w=1.56u l=0.28u
X359 VREFN A44_DCTRL_STRIP_W_R2_0/CTRL_OUT[7] A44_CDAC_CAP_BANK_ASSEMBLY_R8_M6_0/A44_CAP_CORE128_M6_R1_0/CAP_BOTTOM_000 GND nfet_03v3 ad=0 pd=0 as=0 ps=0 w=1.56u l=0.28u
X360 VREFN A44_DCTRL_STRIP_W_R2_0/CTRL_OUT[7] A44_CDAC_CAP_BANK_ASSEMBLY_R8_M6_0/A44_CAP_CORE128_M6_R1_0/CAP_BOTTOM_000 GND nfet_03v3 ad=0 pd=0 as=0 ps=0 w=1.56u l=0.28u
X361 VREFN A44_DCTRL_STRIP_W_R2_0/CTRL_OUT[7] A44_CDAC_CAP_BANK_ASSEMBLY_R8_M6_0/A44_CAP_CORE128_M6_R1_0/CAP_BOTTOM_000 GND nfet_03v3 ad=0 pd=0 as=0 ps=0 w=1.56u l=0.28u
X362 VREFP A44_DCTRL_STRIP_W_R2_0/CTRL_OUT[5] A44_CDAC_CAP_BANK_ASSEMBLY_R8_M6_0/A44_CAP_CORE128_M6_R1_0/CAP_BOTTOM_063 VDD pfet_03v3 ad=0 pd=0 as=16.6842p ps=77.76u w=1.56u l=0.28u
X363 VREFP A44_DCTRL_STRIP_W_R2_0/CTRL_OUT[5] A44_CDAC_CAP_BANK_ASSEMBLY_R8_M6_0/A44_CAP_CORE128_M6_R1_0/CAP_BOTTOM_063 VDD pfet_03v3 ad=0 pd=0 as=0 ps=0 w=1.56u l=0.28u
X364 VREFP A44_DCTRL_STRIP_W_R2_0/CTRL_OUT[5] A44_CDAC_CAP_BANK_ASSEMBLY_R8_M6_0/A44_CAP_CORE128_M6_R1_0/CAP_BOTTOM_063 VDD pfet_03v3 ad=0 pd=0 as=0 ps=0 w=1.56u l=0.28u
X365 VREFP A44_DCTRL_STRIP_W_R2_0/CTRL_OUT[5] A44_CDAC_CAP_BANK_ASSEMBLY_R8_M6_0/A44_CAP_CORE128_M6_R1_0/CAP_BOTTOM_063 VDD pfet_03v3 ad=0 pd=0 as=0 ps=0 w=1.56u l=0.28u
X366 VREFP A44_DCTRL_STRIP_W_R2_0/CTRL_OUT[5] A44_CDAC_CAP_BANK_ASSEMBLY_R8_M6_0/A44_CAP_CORE128_M6_R1_0/CAP_BOTTOM_063 VDD pfet_03v3 ad=0 pd=0 as=0 ps=0 w=1.56u l=0.28u
X367 VREFP A44_DCTRL_STRIP_W_R2_0/CTRL_OUT[5] A44_CDAC_CAP_BANK_ASSEMBLY_R8_M6_0/A44_CAP_CORE128_M6_R1_0/CAP_BOTTOM_063 VDD pfet_03v3 ad=0 pd=0 as=0 ps=0 w=1.56u l=0.28u
X368 VREFP A44_DCTRL_STRIP_W_R2_0/CTRL_OUT[5] A44_CDAC_CAP_BANK_ASSEMBLY_R8_M6_0/A44_CAP_CORE128_M6_R1_0/CAP_BOTTOM_063 VDD pfet_03v3 ad=0 pd=0 as=0 ps=0 w=1.56u l=0.28u
X369 VREFP A44_DCTRL_STRIP_W_R2_0/CTRL_OUT[5] A44_CDAC_CAP_BANK_ASSEMBLY_R8_M6_0/A44_CAP_CORE128_M6_R1_0/CAP_BOTTOM_063 VDD pfet_03v3 ad=0 pd=0 as=0 ps=0 w=1.56u l=0.28u
X370 VREFP A44_DCTRL_STRIP_W_R2_0/CTRL_OUT[5] A44_CDAC_CAP_BANK_ASSEMBLY_R8_M6_0/A44_CAP_CORE128_M6_R1_0/CAP_BOTTOM_063 VDD pfet_03v3 ad=0 pd=0 as=0 ps=0 w=1.56u l=0.28u
X371 VREFP A44_DCTRL_STRIP_W_R2_0/CTRL_OUT[5] A44_CDAC_CAP_BANK_ASSEMBLY_R8_M6_0/A44_CAP_CORE128_M6_R1_0/CAP_BOTTOM_063 VDD pfet_03v3 ad=0 pd=0 as=0 ps=0 w=1.56u l=0.28u
X372 VREFP A44_DCTRL_STRIP_W_R2_0/CTRL_OUT[5] A44_CDAC_CAP_BANK_ASSEMBLY_R8_M6_0/A44_CAP_CORE128_M6_R1_0/CAP_BOTTOM_063 VDD pfet_03v3 ad=0 pd=0 as=0 ps=0 w=1.56u l=0.28u
X373 VREFP A44_DCTRL_STRIP_W_R2_0/CTRL_OUT[5] A44_CDAC_CAP_BANK_ASSEMBLY_R8_M6_0/A44_CAP_CORE128_M6_R1_0/CAP_BOTTOM_063 VDD pfet_03v3 ad=0 pd=0 as=0 ps=0 w=1.56u l=0.28u
X374 VREFP A44_DCTRL_STRIP_W_R2_0/CTRL_OUT[5] A44_CDAC_CAP_BANK_ASSEMBLY_R8_M6_0/A44_CAP_CORE128_M6_R1_0/CAP_BOTTOM_063 VDD pfet_03v3 ad=0 pd=0 as=0 ps=0 w=1.56u l=0.28u
X375 VREFP A44_DCTRL_STRIP_W_R2_0/CTRL_OUT[5] A44_CDAC_CAP_BANK_ASSEMBLY_R8_M6_0/A44_CAP_CORE128_M6_R1_0/CAP_BOTTOM_063 VDD pfet_03v3 ad=0 pd=0 as=0 ps=0 w=1.56u l=0.28u
X376 VREFP A44_DCTRL_STRIP_W_R2_0/CTRL_OUT[5] A44_CDAC_CAP_BANK_ASSEMBLY_R8_M6_0/A44_CAP_CORE128_M6_R1_0/CAP_BOTTOM_063 VDD pfet_03v3 ad=0 pd=0 as=0 ps=0 w=1.56u l=0.28u
X377 VREFP A44_DCTRL_STRIP_W_R2_0/CTRL_OUT[5] A44_CDAC_CAP_BANK_ASSEMBLY_R8_M6_0/A44_CAP_CORE128_M6_R1_0/CAP_BOTTOM_063 VDD pfet_03v3 ad=0 pd=0 as=0 ps=0 w=1.56u l=0.28u
X378 VREFP A44_DCTRL_STRIP_W_R2_0/CTRL_OUT[5] A44_CDAC_CAP_BANK_ASSEMBLY_R8_M6_0/A44_CAP_CORE128_M6_R1_0/CAP_BOTTOM_063 VDD pfet_03v3 ad=0 pd=0 as=0 ps=0 w=1.56u l=0.28u
X379 VREFP A44_DCTRL_STRIP_W_R2_0/CTRL_OUT[5] A44_CDAC_CAP_BANK_ASSEMBLY_R8_M6_0/A44_CAP_CORE128_M6_R1_0/CAP_BOTTOM_063 VDD pfet_03v3 ad=0 pd=0 as=0 ps=0 w=1.56u l=0.28u
X380 VREFN A44_DCTRL_STRIP_W_R2_0/CTRL_OUT[5] A44_CDAC_CAP_BANK_ASSEMBLY_R8_M6_0/A44_CAP_CORE128_M6_R1_0/CAP_BOTTOM_063 GND nfet_03v3 ad=0 pd=0 as=16.6842p ps=77.76u w=1.56u l=0.28u
X381 VREFN A44_DCTRL_STRIP_W_R2_0/CTRL_OUT[5] A44_CDAC_CAP_BANK_ASSEMBLY_R8_M6_0/A44_CAP_CORE128_M6_R1_0/CAP_BOTTOM_063 GND nfet_03v3 ad=0 pd=0 as=0 ps=0 w=1.56u l=0.28u
X382 VREFN A44_DCTRL_STRIP_W_R2_0/CTRL_OUT[5] A44_CDAC_CAP_BANK_ASSEMBLY_R8_M6_0/A44_CAP_CORE128_M6_R1_0/CAP_BOTTOM_063 GND nfet_03v3 ad=0 pd=0 as=0 ps=0 w=1.56u l=0.28u
X383 VREFN A44_DCTRL_STRIP_W_R2_0/CTRL_OUT[5] A44_CDAC_CAP_BANK_ASSEMBLY_R8_M6_0/A44_CAP_CORE128_M6_R1_0/CAP_BOTTOM_063 GND nfet_03v3 ad=0 pd=0 as=0 ps=0 w=1.56u l=0.28u
X384 VREFN A44_DCTRL_STRIP_W_R2_0/CTRL_OUT[5] A44_CDAC_CAP_BANK_ASSEMBLY_R8_M6_0/A44_CAP_CORE128_M6_R1_0/CAP_BOTTOM_063 GND nfet_03v3 ad=0 pd=0 as=0 ps=0 w=1.56u l=0.28u
X385 VREFN A44_DCTRL_STRIP_W_R2_0/CTRL_OUT[5] A44_CDAC_CAP_BANK_ASSEMBLY_R8_M6_0/A44_CAP_CORE128_M6_R1_0/CAP_BOTTOM_063 GND nfet_03v3 ad=0 pd=0 as=0 ps=0 w=1.56u l=0.28u
X386 VREFN A44_DCTRL_STRIP_W_R2_0/CTRL_OUT[5] A44_CDAC_CAP_BANK_ASSEMBLY_R8_M6_0/A44_CAP_CORE128_M6_R1_0/CAP_BOTTOM_063 GND nfet_03v3 ad=0 pd=0 as=0 ps=0 w=1.56u l=0.28u
X387 VREFN A44_DCTRL_STRIP_W_R2_0/CTRL_OUT[5] A44_CDAC_CAP_BANK_ASSEMBLY_R8_M6_0/A44_CAP_CORE128_M6_R1_0/CAP_BOTTOM_063 GND nfet_03v3 ad=0 pd=0 as=0 ps=0 w=1.56u l=0.28u
X388 VREFN A44_DCTRL_STRIP_W_R2_0/CTRL_OUT[5] A44_CDAC_CAP_BANK_ASSEMBLY_R8_M6_0/A44_CAP_CORE128_M6_R1_0/CAP_BOTTOM_063 GND nfet_03v3 ad=0 pd=0 as=0 ps=0 w=1.56u l=0.28u
X389 VREFN A44_DCTRL_STRIP_W_R2_0/CTRL_OUT[5] A44_CDAC_CAP_BANK_ASSEMBLY_R8_M6_0/A44_CAP_CORE128_M6_R1_0/CAP_BOTTOM_063 GND nfet_03v3 ad=0 pd=0 as=0 ps=0 w=1.56u l=0.28u
X390 VREFN A44_DCTRL_STRIP_W_R2_0/CTRL_OUT[5] A44_CDAC_CAP_BANK_ASSEMBLY_R8_M6_0/A44_CAP_CORE128_M6_R1_0/CAP_BOTTOM_063 GND nfet_03v3 ad=0 pd=0 as=0 ps=0 w=1.56u l=0.28u
X391 VREFN A44_DCTRL_STRIP_W_R2_0/CTRL_OUT[5] A44_CDAC_CAP_BANK_ASSEMBLY_R8_M6_0/A44_CAP_CORE128_M6_R1_0/CAP_BOTTOM_063 GND nfet_03v3 ad=0 pd=0 as=0 ps=0 w=1.56u l=0.28u
X392 VREFN A44_DCTRL_STRIP_W_R2_0/CTRL_OUT[5] A44_CDAC_CAP_BANK_ASSEMBLY_R8_M6_0/A44_CAP_CORE128_M6_R1_0/CAP_BOTTOM_063 GND nfet_03v3 ad=0 pd=0 as=0 ps=0 w=1.56u l=0.28u
X393 VREFN A44_DCTRL_STRIP_W_R2_0/CTRL_OUT[5] A44_CDAC_CAP_BANK_ASSEMBLY_R8_M6_0/A44_CAP_CORE128_M6_R1_0/CAP_BOTTOM_063 GND nfet_03v3 ad=0 pd=0 as=0 ps=0 w=1.56u l=0.28u
X394 VREFN A44_DCTRL_STRIP_W_R2_0/CTRL_OUT[5] A44_CDAC_CAP_BANK_ASSEMBLY_R8_M6_0/A44_CAP_CORE128_M6_R1_0/CAP_BOTTOM_063 GND nfet_03v3 ad=0 pd=0 as=0 ps=0 w=1.56u l=0.28u
X395 VREFN A44_DCTRL_STRIP_W_R2_0/CTRL_OUT[5] A44_CDAC_CAP_BANK_ASSEMBLY_R8_M6_0/A44_CAP_CORE128_M6_R1_0/CAP_BOTTOM_063 GND nfet_03v3 ad=0 pd=0 as=0 ps=0 w=1.56u l=0.28u
X396 VREFN A44_DCTRL_STRIP_W_R2_0/CTRL_OUT[5] A44_CDAC_CAP_BANK_ASSEMBLY_R8_M6_0/A44_CAP_CORE128_M6_R1_0/CAP_BOTTOM_063 GND nfet_03v3 ad=0 pd=0 as=0 ps=0 w=1.56u l=0.28u
X397 VREFN A44_DCTRL_STRIP_W_R2_0/CTRL_OUT[5] A44_CDAC_CAP_BANK_ASSEMBLY_R8_M6_0/A44_CAP_CORE128_M6_R1_0/CAP_BOTTOM_063 GND nfet_03v3 ad=0 pd=0 as=0 ps=0 w=1.56u l=0.28u
X398 VREFP A44_DCTRL_STRIP_W_R2_0/CTRL_OUT[6] A44_CDAC_CAP_BANK_ASSEMBLY_R8_M6_0/A44_CAP_CORE128_M6_R1_0/CAP_BOTTOM_024 VDD pfet_03v3 ad=0 pd=0 as=16.6842p ps=77.76u w=1.56u l=0.28u
X399 VREFP A44_DCTRL_STRIP_W_R2_0/CTRL_OUT[6] A44_CDAC_CAP_BANK_ASSEMBLY_R8_M6_0/A44_CAP_CORE128_M6_R1_0/CAP_BOTTOM_024 VDD pfet_03v3 ad=0 pd=0 as=0 ps=0 w=1.56u l=0.28u
X400 VREFP A44_DCTRL_STRIP_W_R2_0/CTRL_OUT[6] A44_CDAC_CAP_BANK_ASSEMBLY_R8_M6_0/A44_CAP_CORE128_M6_R1_0/CAP_BOTTOM_024 VDD pfet_03v3 ad=0 pd=0 as=0 ps=0 w=1.56u l=0.28u
X401 VREFP A44_DCTRL_STRIP_W_R2_0/CTRL_OUT[6] A44_CDAC_CAP_BANK_ASSEMBLY_R8_M6_0/A44_CAP_CORE128_M6_R1_0/CAP_BOTTOM_024 VDD pfet_03v3 ad=0 pd=0 as=0 ps=0 w=1.56u l=0.28u
X402 VREFP A44_DCTRL_STRIP_W_R2_0/CTRL_OUT[6] A44_CDAC_CAP_BANK_ASSEMBLY_R8_M6_0/A44_CAP_CORE128_M6_R1_0/CAP_BOTTOM_024 VDD pfet_03v3 ad=0 pd=0 as=0 ps=0 w=1.56u l=0.28u
X403 VREFP A44_DCTRL_STRIP_W_R2_0/CTRL_OUT[6] A44_CDAC_CAP_BANK_ASSEMBLY_R8_M6_0/A44_CAP_CORE128_M6_R1_0/CAP_BOTTOM_024 VDD pfet_03v3 ad=0 pd=0 as=0 ps=0 w=1.56u l=0.28u
X404 VREFP A44_DCTRL_STRIP_W_R2_0/CTRL_OUT[6] A44_CDAC_CAP_BANK_ASSEMBLY_R8_M6_0/A44_CAP_CORE128_M6_R1_0/CAP_BOTTOM_024 VDD pfet_03v3 ad=0 pd=0 as=0 ps=0 w=1.56u l=0.28u
X405 VREFP A44_DCTRL_STRIP_W_R2_0/CTRL_OUT[6] A44_CDAC_CAP_BANK_ASSEMBLY_R8_M6_0/A44_CAP_CORE128_M6_R1_0/CAP_BOTTOM_024 VDD pfet_03v3 ad=0 pd=0 as=0 ps=0 w=1.56u l=0.28u
X406 VREFP A44_DCTRL_STRIP_W_R2_0/CTRL_OUT[6] A44_CDAC_CAP_BANK_ASSEMBLY_R8_M6_0/A44_CAP_CORE128_M6_R1_0/CAP_BOTTOM_024 VDD pfet_03v3 ad=0 pd=0 as=0 ps=0 w=1.56u l=0.28u
X407 VREFP A44_DCTRL_STRIP_W_R2_0/CTRL_OUT[6] A44_CDAC_CAP_BANK_ASSEMBLY_R8_M6_0/A44_CAP_CORE128_M6_R1_0/CAP_BOTTOM_024 VDD pfet_03v3 ad=0 pd=0 as=0 ps=0 w=1.56u l=0.28u
X408 VREFP A44_DCTRL_STRIP_W_R2_0/CTRL_OUT[6] A44_CDAC_CAP_BANK_ASSEMBLY_R8_M6_0/A44_CAP_CORE128_M6_R1_0/CAP_BOTTOM_024 VDD pfet_03v3 ad=0 pd=0 as=0 ps=0 w=1.56u l=0.28u
X409 VREFP A44_DCTRL_STRIP_W_R2_0/CTRL_OUT[6] A44_CDAC_CAP_BANK_ASSEMBLY_R8_M6_0/A44_CAP_CORE128_M6_R1_0/CAP_BOTTOM_024 VDD pfet_03v3 ad=0 pd=0 as=0 ps=0 w=1.56u l=0.28u
X410 VREFP A44_DCTRL_STRIP_W_R2_0/CTRL_OUT[6] A44_CDAC_CAP_BANK_ASSEMBLY_R8_M6_0/A44_CAP_CORE128_M6_R1_0/CAP_BOTTOM_024 VDD pfet_03v3 ad=0 pd=0 as=0 ps=0 w=1.56u l=0.28u
X411 VREFP A44_DCTRL_STRIP_W_R2_0/CTRL_OUT[6] A44_CDAC_CAP_BANK_ASSEMBLY_R8_M6_0/A44_CAP_CORE128_M6_R1_0/CAP_BOTTOM_024 VDD pfet_03v3 ad=0 pd=0 as=0 ps=0 w=1.56u l=0.28u
X412 VREFP A44_DCTRL_STRIP_W_R2_0/CTRL_OUT[6] A44_CDAC_CAP_BANK_ASSEMBLY_R8_M6_0/A44_CAP_CORE128_M6_R1_0/CAP_BOTTOM_024 VDD pfet_03v3 ad=0 pd=0 as=0 ps=0 w=1.56u l=0.28u
X413 VREFP A44_DCTRL_STRIP_W_R2_0/CTRL_OUT[6] A44_CDAC_CAP_BANK_ASSEMBLY_R8_M6_0/A44_CAP_CORE128_M6_R1_0/CAP_BOTTOM_024 VDD pfet_03v3 ad=0 pd=0 as=0 ps=0 w=1.56u l=0.28u
X414 VREFP A44_DCTRL_STRIP_W_R2_0/CTRL_OUT[6] A44_CDAC_CAP_BANK_ASSEMBLY_R8_M6_0/A44_CAP_CORE128_M6_R1_0/CAP_BOTTOM_024 VDD pfet_03v3 ad=0 pd=0 as=0 ps=0 w=1.56u l=0.28u
X415 VREFP A44_DCTRL_STRIP_W_R2_0/CTRL_OUT[6] A44_CDAC_CAP_BANK_ASSEMBLY_R8_M6_0/A44_CAP_CORE128_M6_R1_0/CAP_BOTTOM_024 VDD pfet_03v3 ad=0 pd=0 as=0 ps=0 w=1.56u l=0.28u
X416 VREFN A44_DCTRL_STRIP_W_R2_0/CTRL_OUT[6] A44_CDAC_CAP_BANK_ASSEMBLY_R8_M6_0/A44_CAP_CORE128_M6_R1_0/CAP_BOTTOM_024 GND nfet_03v3 ad=0 pd=0 as=16.6842p ps=77.76u w=1.56u l=0.28u
X417 VREFN A44_DCTRL_STRIP_W_R2_0/CTRL_OUT[6] A44_CDAC_CAP_BANK_ASSEMBLY_R8_M6_0/A44_CAP_CORE128_M6_R1_0/CAP_BOTTOM_024 GND nfet_03v3 ad=0 pd=0 as=0 ps=0 w=1.56u l=0.28u
X418 VREFN A44_DCTRL_STRIP_W_R2_0/CTRL_OUT[6] A44_CDAC_CAP_BANK_ASSEMBLY_R8_M6_0/A44_CAP_CORE128_M6_R1_0/CAP_BOTTOM_024 GND nfet_03v3 ad=0 pd=0 as=0 ps=0 w=1.56u l=0.28u
X419 VREFN A44_DCTRL_STRIP_W_R2_0/CTRL_OUT[6] A44_CDAC_CAP_BANK_ASSEMBLY_R8_M6_0/A44_CAP_CORE128_M6_R1_0/CAP_BOTTOM_024 GND nfet_03v3 ad=0 pd=0 as=0 ps=0 w=1.56u l=0.28u
X420 VREFN A44_DCTRL_STRIP_W_R2_0/CTRL_OUT[6] A44_CDAC_CAP_BANK_ASSEMBLY_R8_M6_0/A44_CAP_CORE128_M6_R1_0/CAP_BOTTOM_024 GND nfet_03v3 ad=0 pd=0 as=0 ps=0 w=1.56u l=0.28u
X421 VREFN A44_DCTRL_STRIP_W_R2_0/CTRL_OUT[6] A44_CDAC_CAP_BANK_ASSEMBLY_R8_M6_0/A44_CAP_CORE128_M6_R1_0/CAP_BOTTOM_024 GND nfet_03v3 ad=0 pd=0 as=0 ps=0 w=1.56u l=0.28u
X422 VREFN A44_DCTRL_STRIP_W_R2_0/CTRL_OUT[6] A44_CDAC_CAP_BANK_ASSEMBLY_R8_M6_0/A44_CAP_CORE128_M6_R1_0/CAP_BOTTOM_024 GND nfet_03v3 ad=0 pd=0 as=0 ps=0 w=1.56u l=0.28u
X423 VREFN A44_DCTRL_STRIP_W_R2_0/CTRL_OUT[6] A44_CDAC_CAP_BANK_ASSEMBLY_R8_M6_0/A44_CAP_CORE128_M6_R1_0/CAP_BOTTOM_024 GND nfet_03v3 ad=0 pd=0 as=0 ps=0 w=1.56u l=0.28u
X424 VREFN A44_DCTRL_STRIP_W_R2_0/CTRL_OUT[6] A44_CDAC_CAP_BANK_ASSEMBLY_R8_M6_0/A44_CAP_CORE128_M6_R1_0/CAP_BOTTOM_024 GND nfet_03v3 ad=0 pd=0 as=0 ps=0 w=1.56u l=0.28u
X425 VREFN A44_DCTRL_STRIP_W_R2_0/CTRL_OUT[6] A44_CDAC_CAP_BANK_ASSEMBLY_R8_M6_0/A44_CAP_CORE128_M6_R1_0/CAP_BOTTOM_024 GND nfet_03v3 ad=0 pd=0 as=0 ps=0 w=1.56u l=0.28u
X426 VREFN A44_DCTRL_STRIP_W_R2_0/CTRL_OUT[6] A44_CDAC_CAP_BANK_ASSEMBLY_R8_M6_0/A44_CAP_CORE128_M6_R1_0/CAP_BOTTOM_024 GND nfet_03v3 ad=0 pd=0 as=0 ps=0 w=1.56u l=0.28u
X427 VREFN A44_DCTRL_STRIP_W_R2_0/CTRL_OUT[6] A44_CDAC_CAP_BANK_ASSEMBLY_R8_M6_0/A44_CAP_CORE128_M6_R1_0/CAP_BOTTOM_024 GND nfet_03v3 ad=0 pd=0 as=0 ps=0 w=1.56u l=0.28u
X428 VREFN A44_DCTRL_STRIP_W_R2_0/CTRL_OUT[6] A44_CDAC_CAP_BANK_ASSEMBLY_R8_M6_0/A44_CAP_CORE128_M6_R1_0/CAP_BOTTOM_024 GND nfet_03v3 ad=0 pd=0 as=0 ps=0 w=1.56u l=0.28u
X429 VREFN A44_DCTRL_STRIP_W_R2_0/CTRL_OUT[6] A44_CDAC_CAP_BANK_ASSEMBLY_R8_M6_0/A44_CAP_CORE128_M6_R1_0/CAP_BOTTOM_024 GND nfet_03v3 ad=0 pd=0 as=0 ps=0 w=1.56u l=0.28u
X430 VREFN A44_DCTRL_STRIP_W_R2_0/CTRL_OUT[6] A44_CDAC_CAP_BANK_ASSEMBLY_R8_M6_0/A44_CAP_CORE128_M6_R1_0/CAP_BOTTOM_024 GND nfet_03v3 ad=0 pd=0 as=0 ps=0 w=1.56u l=0.28u
X431 VREFN A44_DCTRL_STRIP_W_R2_0/CTRL_OUT[6] A44_CDAC_CAP_BANK_ASSEMBLY_R8_M6_0/A44_CAP_CORE128_M6_R1_0/CAP_BOTTOM_024 GND nfet_03v3 ad=0 pd=0 as=0 ps=0 w=1.56u l=0.28u
X432 VREFN A44_DCTRL_STRIP_W_R2_0/CTRL_OUT[6] A44_CDAC_CAP_BANK_ASSEMBLY_R8_M6_0/A44_CAP_CORE128_M6_R1_0/CAP_BOTTOM_024 GND nfet_03v3 ad=0 pd=0 as=0 ps=0 w=1.56u l=0.28u
X433 VREFN A44_DCTRL_STRIP_W_R2_0/CTRL_OUT[6] A44_CDAC_CAP_BANK_ASSEMBLY_R8_M6_0/A44_CAP_CORE128_M6_R1_0/CAP_BOTTOM_024 GND nfet_03v3 ad=0 pd=0 as=0 ps=0 w=1.56u l=0.28u
X434 VREFP A44_DCTRL_STRIP_W_R2_0/CTRL_OUT[7] A44_CDAC_CAP_BANK_ASSEMBLY_R8_M6_0/A44_CAP_CORE128_M6_R1_0/CAP_BOTTOM_050 VDD pfet_03v3 ad=0 pd=0 as=16.6842p ps=77.76u w=1.56u l=0.28u
X435 VREFP A44_DCTRL_STRIP_W_R2_0/CTRL_OUT[7] A44_CDAC_CAP_BANK_ASSEMBLY_R8_M6_0/A44_CAP_CORE128_M6_R1_0/CAP_BOTTOM_050 VDD pfet_03v3 ad=0 pd=0 as=0 ps=0 w=1.56u l=0.28u
X436 VREFP A44_DCTRL_STRIP_W_R2_0/CTRL_OUT[7] A44_CDAC_CAP_BANK_ASSEMBLY_R8_M6_0/A44_CAP_CORE128_M6_R1_0/CAP_BOTTOM_050 VDD pfet_03v3 ad=0 pd=0 as=0 ps=0 w=1.56u l=0.28u
X437 VREFP A44_DCTRL_STRIP_W_R2_0/CTRL_OUT[7] A44_CDAC_CAP_BANK_ASSEMBLY_R8_M6_0/A44_CAP_CORE128_M6_R1_0/CAP_BOTTOM_050 VDD pfet_03v3 ad=0 pd=0 as=0 ps=0 w=1.56u l=0.28u
X438 VREFP A44_DCTRL_STRIP_W_R2_0/CTRL_OUT[7] A44_CDAC_CAP_BANK_ASSEMBLY_R8_M6_0/A44_CAP_CORE128_M6_R1_0/CAP_BOTTOM_050 VDD pfet_03v3 ad=0 pd=0 as=0 ps=0 w=1.56u l=0.28u
X439 VREFP A44_DCTRL_STRIP_W_R2_0/CTRL_OUT[7] A44_CDAC_CAP_BANK_ASSEMBLY_R8_M6_0/A44_CAP_CORE128_M6_R1_0/CAP_BOTTOM_050 VDD pfet_03v3 ad=0 pd=0 as=0 ps=0 w=1.56u l=0.28u
X440 VREFP A44_DCTRL_STRIP_W_R2_0/CTRL_OUT[7] A44_CDAC_CAP_BANK_ASSEMBLY_R8_M6_0/A44_CAP_CORE128_M6_R1_0/CAP_BOTTOM_050 VDD pfet_03v3 ad=0 pd=0 as=0 ps=0 w=1.56u l=0.28u
X441 VREFP A44_DCTRL_STRIP_W_R2_0/CTRL_OUT[7] A44_CDAC_CAP_BANK_ASSEMBLY_R8_M6_0/A44_CAP_CORE128_M6_R1_0/CAP_BOTTOM_050 VDD pfet_03v3 ad=0 pd=0 as=0 ps=0 w=1.56u l=0.28u
X442 VREFP A44_DCTRL_STRIP_W_R2_0/CTRL_OUT[7] A44_CDAC_CAP_BANK_ASSEMBLY_R8_M6_0/A44_CAP_CORE128_M6_R1_0/CAP_BOTTOM_050 VDD pfet_03v3 ad=0 pd=0 as=0 ps=0 w=1.56u l=0.28u
X443 VREFP A44_DCTRL_STRIP_W_R2_0/CTRL_OUT[7] A44_CDAC_CAP_BANK_ASSEMBLY_R8_M6_0/A44_CAP_CORE128_M6_R1_0/CAP_BOTTOM_050 VDD pfet_03v3 ad=0 pd=0 as=0 ps=0 w=1.56u l=0.28u
X444 VREFP A44_DCTRL_STRIP_W_R2_0/CTRL_OUT[7] A44_CDAC_CAP_BANK_ASSEMBLY_R8_M6_0/A44_CAP_CORE128_M6_R1_0/CAP_BOTTOM_050 VDD pfet_03v3 ad=0 pd=0 as=0 ps=0 w=1.56u l=0.28u
X445 VREFP A44_DCTRL_STRIP_W_R2_0/CTRL_OUT[7] A44_CDAC_CAP_BANK_ASSEMBLY_R8_M6_0/A44_CAP_CORE128_M6_R1_0/CAP_BOTTOM_050 VDD pfet_03v3 ad=0 pd=0 as=0 ps=0 w=1.56u l=0.28u
X446 VREFP A44_DCTRL_STRIP_W_R2_0/CTRL_OUT[7] A44_CDAC_CAP_BANK_ASSEMBLY_R8_M6_0/A44_CAP_CORE128_M6_R1_0/CAP_BOTTOM_050 VDD pfet_03v3 ad=0 pd=0 as=0 ps=0 w=1.56u l=0.28u
X447 VREFP A44_DCTRL_STRIP_W_R2_0/CTRL_OUT[7] A44_CDAC_CAP_BANK_ASSEMBLY_R8_M6_0/A44_CAP_CORE128_M6_R1_0/CAP_BOTTOM_050 VDD pfet_03v3 ad=0 pd=0 as=0 ps=0 w=1.56u l=0.28u
X448 VREFP A44_DCTRL_STRIP_W_R2_0/CTRL_OUT[7] A44_CDAC_CAP_BANK_ASSEMBLY_R8_M6_0/A44_CAP_CORE128_M6_R1_0/CAP_BOTTOM_050 VDD pfet_03v3 ad=0 pd=0 as=0 ps=0 w=1.56u l=0.28u
X449 VREFP A44_DCTRL_STRIP_W_R2_0/CTRL_OUT[7] A44_CDAC_CAP_BANK_ASSEMBLY_R8_M6_0/A44_CAP_CORE128_M6_R1_0/CAP_BOTTOM_050 VDD pfet_03v3 ad=0 pd=0 as=0 ps=0 w=1.56u l=0.28u
X450 VREFP A44_DCTRL_STRIP_W_R2_0/CTRL_OUT[7] A44_CDAC_CAP_BANK_ASSEMBLY_R8_M6_0/A44_CAP_CORE128_M6_R1_0/CAP_BOTTOM_050 VDD pfet_03v3 ad=0 pd=0 as=0 ps=0 w=1.56u l=0.28u
X451 VREFP A44_DCTRL_STRIP_W_R2_0/CTRL_OUT[7] A44_CDAC_CAP_BANK_ASSEMBLY_R8_M6_0/A44_CAP_CORE128_M6_R1_0/CAP_BOTTOM_050 VDD pfet_03v3 ad=0 pd=0 as=0 ps=0 w=1.56u l=0.28u
X452 VREFN A44_DCTRL_STRIP_W_R2_0/CTRL_OUT[7] A44_CDAC_CAP_BANK_ASSEMBLY_R8_M6_0/A44_CAP_CORE128_M6_R1_0/CAP_BOTTOM_050 GND nfet_03v3 ad=0 pd=0 as=16.6842p ps=77.76u w=1.56u l=0.28u
X453 VREFN A44_DCTRL_STRIP_W_R2_0/CTRL_OUT[7] A44_CDAC_CAP_BANK_ASSEMBLY_R8_M6_0/A44_CAP_CORE128_M6_R1_0/CAP_BOTTOM_050 GND nfet_03v3 ad=0 pd=0 as=0 ps=0 w=1.56u l=0.28u
X454 VREFN A44_DCTRL_STRIP_W_R2_0/CTRL_OUT[7] A44_CDAC_CAP_BANK_ASSEMBLY_R8_M6_0/A44_CAP_CORE128_M6_R1_0/CAP_BOTTOM_050 GND nfet_03v3 ad=0 pd=0 as=0 ps=0 w=1.56u l=0.28u
X455 VREFN A44_DCTRL_STRIP_W_R2_0/CTRL_OUT[7] A44_CDAC_CAP_BANK_ASSEMBLY_R8_M6_0/A44_CAP_CORE128_M6_R1_0/CAP_BOTTOM_050 GND nfet_03v3 ad=0 pd=0 as=0 ps=0 w=1.56u l=0.28u
X456 VREFN A44_DCTRL_STRIP_W_R2_0/CTRL_OUT[7] A44_CDAC_CAP_BANK_ASSEMBLY_R8_M6_0/A44_CAP_CORE128_M6_R1_0/CAP_BOTTOM_050 GND nfet_03v3 ad=0 pd=0 as=0 ps=0 w=1.56u l=0.28u
X457 VREFN A44_DCTRL_STRIP_W_R2_0/CTRL_OUT[7] A44_CDAC_CAP_BANK_ASSEMBLY_R8_M6_0/A44_CAP_CORE128_M6_R1_0/CAP_BOTTOM_050 GND nfet_03v3 ad=0 pd=0 as=0 ps=0 w=1.56u l=0.28u
X458 VREFN A44_DCTRL_STRIP_W_R2_0/CTRL_OUT[7] A44_CDAC_CAP_BANK_ASSEMBLY_R8_M6_0/A44_CAP_CORE128_M6_R1_0/CAP_BOTTOM_050 GND nfet_03v3 ad=0 pd=0 as=0 ps=0 w=1.56u l=0.28u
X459 VREFN A44_DCTRL_STRIP_W_R2_0/CTRL_OUT[7] A44_CDAC_CAP_BANK_ASSEMBLY_R8_M6_0/A44_CAP_CORE128_M6_R1_0/CAP_BOTTOM_050 GND nfet_03v3 ad=0 pd=0 as=0 ps=0 w=1.56u l=0.28u
X460 VREFN A44_DCTRL_STRIP_W_R2_0/CTRL_OUT[7] A44_CDAC_CAP_BANK_ASSEMBLY_R8_M6_0/A44_CAP_CORE128_M6_R1_0/CAP_BOTTOM_050 GND nfet_03v3 ad=0 pd=0 as=0 ps=0 w=1.56u l=0.28u
X461 VREFN A44_DCTRL_STRIP_W_R2_0/CTRL_OUT[7] A44_CDAC_CAP_BANK_ASSEMBLY_R8_M6_0/A44_CAP_CORE128_M6_R1_0/CAP_BOTTOM_050 GND nfet_03v3 ad=0 pd=0 as=0 ps=0 w=1.56u l=0.28u
X462 VREFN A44_DCTRL_STRIP_W_R2_0/CTRL_OUT[7] A44_CDAC_CAP_BANK_ASSEMBLY_R8_M6_0/A44_CAP_CORE128_M6_R1_0/CAP_BOTTOM_050 GND nfet_03v3 ad=0 pd=0 as=0 ps=0 w=1.56u l=0.28u
X463 VREFN A44_DCTRL_STRIP_W_R2_0/CTRL_OUT[7] A44_CDAC_CAP_BANK_ASSEMBLY_R8_M6_0/A44_CAP_CORE128_M6_R1_0/CAP_BOTTOM_050 GND nfet_03v3 ad=0 pd=0 as=0 ps=0 w=1.56u l=0.28u
X464 VREFN A44_DCTRL_STRIP_W_R2_0/CTRL_OUT[7] A44_CDAC_CAP_BANK_ASSEMBLY_R8_M6_0/A44_CAP_CORE128_M6_R1_0/CAP_BOTTOM_050 GND nfet_03v3 ad=0 pd=0 as=0 ps=0 w=1.56u l=0.28u
X465 VREFN A44_DCTRL_STRIP_W_R2_0/CTRL_OUT[7] A44_CDAC_CAP_BANK_ASSEMBLY_R8_M6_0/A44_CAP_CORE128_M6_R1_0/CAP_BOTTOM_050 GND nfet_03v3 ad=0 pd=0 as=0 ps=0 w=1.56u l=0.28u
X466 VREFN A44_DCTRL_STRIP_W_R2_0/CTRL_OUT[7] A44_CDAC_CAP_BANK_ASSEMBLY_R8_M6_0/A44_CAP_CORE128_M6_R1_0/CAP_BOTTOM_050 GND nfet_03v3 ad=0 pd=0 as=0 ps=0 w=1.56u l=0.28u
X467 VREFN A44_DCTRL_STRIP_W_R2_0/CTRL_OUT[7] A44_CDAC_CAP_BANK_ASSEMBLY_R8_M6_0/A44_CAP_CORE128_M6_R1_0/CAP_BOTTOM_050 GND nfet_03v3 ad=0 pd=0 as=0 ps=0 w=1.56u l=0.28u
X468 VREFN A44_DCTRL_STRIP_W_R2_0/CTRL_OUT[7] A44_CDAC_CAP_BANK_ASSEMBLY_R8_M6_0/A44_CAP_CORE128_M6_R1_0/CAP_BOTTOM_050 GND nfet_03v3 ad=0 pd=0 as=0 ps=0 w=1.56u l=0.28u
X469 VREFN A44_DCTRL_STRIP_W_R2_0/CTRL_OUT[7] A44_CDAC_CAP_BANK_ASSEMBLY_R8_M6_0/A44_CAP_CORE128_M6_R1_0/CAP_BOTTOM_050 GND nfet_03v3 ad=0 pd=0 as=0 ps=0 w=1.56u l=0.28u
X470 VREFP A44_DCTRL_STRIP_W_R2_0/CTRL_OUT[7] A44_CDAC_CAP_BANK_ASSEMBLY_R8_M6_0/A44_CAP_CORE128_M6_R1_0/CAP_BOTTOM_047 VDD pfet_03v3 ad=0 pd=0 as=16.6842p ps=77.76u w=1.56u l=0.28u
X471 VREFP A44_DCTRL_STRIP_W_R2_0/CTRL_OUT[7] A44_CDAC_CAP_BANK_ASSEMBLY_R8_M6_0/A44_CAP_CORE128_M6_R1_0/CAP_BOTTOM_047 VDD pfet_03v3 ad=0 pd=0 as=0 ps=0 w=1.56u l=0.28u
X472 VREFP A44_DCTRL_STRIP_W_R2_0/CTRL_OUT[7] A44_CDAC_CAP_BANK_ASSEMBLY_R8_M6_0/A44_CAP_CORE128_M6_R1_0/CAP_BOTTOM_047 VDD pfet_03v3 ad=0 pd=0 as=0 ps=0 w=1.56u l=0.28u
X473 VREFP A44_DCTRL_STRIP_W_R2_0/CTRL_OUT[7] A44_CDAC_CAP_BANK_ASSEMBLY_R8_M6_0/A44_CAP_CORE128_M6_R1_0/CAP_BOTTOM_047 VDD pfet_03v3 ad=0 pd=0 as=0 ps=0 w=1.56u l=0.28u
X474 VREFP A44_DCTRL_STRIP_W_R2_0/CTRL_OUT[7] A44_CDAC_CAP_BANK_ASSEMBLY_R8_M6_0/A44_CAP_CORE128_M6_R1_0/CAP_BOTTOM_047 VDD pfet_03v3 ad=0 pd=0 as=0 ps=0 w=1.56u l=0.28u
X475 VREFP A44_DCTRL_STRIP_W_R2_0/CTRL_OUT[7] A44_CDAC_CAP_BANK_ASSEMBLY_R8_M6_0/A44_CAP_CORE128_M6_R1_0/CAP_BOTTOM_047 VDD pfet_03v3 ad=0 pd=0 as=0 ps=0 w=1.56u l=0.28u
X476 VREFP A44_DCTRL_STRIP_W_R2_0/CTRL_OUT[7] A44_CDAC_CAP_BANK_ASSEMBLY_R8_M6_0/A44_CAP_CORE128_M6_R1_0/CAP_BOTTOM_047 VDD pfet_03v3 ad=0 pd=0 as=0 ps=0 w=1.56u l=0.28u
X477 VREFP A44_DCTRL_STRIP_W_R2_0/CTRL_OUT[7] A44_CDAC_CAP_BANK_ASSEMBLY_R8_M6_0/A44_CAP_CORE128_M6_R1_0/CAP_BOTTOM_047 VDD pfet_03v3 ad=0 pd=0 as=0 ps=0 w=1.56u l=0.28u
X478 VREFP A44_DCTRL_STRIP_W_R2_0/CTRL_OUT[7] A44_CDAC_CAP_BANK_ASSEMBLY_R8_M6_0/A44_CAP_CORE128_M6_R1_0/CAP_BOTTOM_047 VDD pfet_03v3 ad=0 pd=0 as=0 ps=0 w=1.56u l=0.28u
X479 VREFP A44_DCTRL_STRIP_W_R2_0/CTRL_OUT[7] A44_CDAC_CAP_BANK_ASSEMBLY_R8_M6_0/A44_CAP_CORE128_M6_R1_0/CAP_BOTTOM_047 VDD pfet_03v3 ad=0 pd=0 as=0 ps=0 w=1.56u l=0.28u
X480 VREFP A44_DCTRL_STRIP_W_R2_0/CTRL_OUT[7] A44_CDAC_CAP_BANK_ASSEMBLY_R8_M6_0/A44_CAP_CORE128_M6_R1_0/CAP_BOTTOM_047 VDD pfet_03v3 ad=0 pd=0 as=0 ps=0 w=1.56u l=0.28u
X481 VREFP A44_DCTRL_STRIP_W_R2_0/CTRL_OUT[7] A44_CDAC_CAP_BANK_ASSEMBLY_R8_M6_0/A44_CAP_CORE128_M6_R1_0/CAP_BOTTOM_047 VDD pfet_03v3 ad=0 pd=0 as=0 ps=0 w=1.56u l=0.28u
X482 VREFP A44_DCTRL_STRIP_W_R2_0/CTRL_OUT[7] A44_CDAC_CAP_BANK_ASSEMBLY_R8_M6_0/A44_CAP_CORE128_M6_R1_0/CAP_BOTTOM_047 VDD pfet_03v3 ad=0 pd=0 as=0 ps=0 w=1.56u l=0.28u
X483 VREFP A44_DCTRL_STRIP_W_R2_0/CTRL_OUT[7] A44_CDAC_CAP_BANK_ASSEMBLY_R8_M6_0/A44_CAP_CORE128_M6_R1_0/CAP_BOTTOM_047 VDD pfet_03v3 ad=0 pd=0 as=0 ps=0 w=1.56u l=0.28u
X484 VREFP A44_DCTRL_STRIP_W_R2_0/CTRL_OUT[7] A44_CDAC_CAP_BANK_ASSEMBLY_R8_M6_0/A44_CAP_CORE128_M6_R1_0/CAP_BOTTOM_047 VDD pfet_03v3 ad=0 pd=0 as=0 ps=0 w=1.56u l=0.28u
X485 VREFP A44_DCTRL_STRIP_W_R2_0/CTRL_OUT[7] A44_CDAC_CAP_BANK_ASSEMBLY_R8_M6_0/A44_CAP_CORE128_M6_R1_0/CAP_BOTTOM_047 VDD pfet_03v3 ad=0 pd=0 as=0 ps=0 w=1.56u l=0.28u
X486 VREFP A44_DCTRL_STRIP_W_R2_0/CTRL_OUT[7] A44_CDAC_CAP_BANK_ASSEMBLY_R8_M6_0/A44_CAP_CORE128_M6_R1_0/CAP_BOTTOM_047 VDD pfet_03v3 ad=0 pd=0 as=0 ps=0 w=1.56u l=0.28u
X487 VREFP A44_DCTRL_STRIP_W_R2_0/CTRL_OUT[7] A44_CDAC_CAP_BANK_ASSEMBLY_R8_M6_0/A44_CAP_CORE128_M6_R1_0/CAP_BOTTOM_047 VDD pfet_03v3 ad=0 pd=0 as=0 ps=0 w=1.56u l=0.28u
X488 VREFN A44_DCTRL_STRIP_W_R2_0/CTRL_OUT[7] A44_CDAC_CAP_BANK_ASSEMBLY_R8_M6_0/A44_CAP_CORE128_M6_R1_0/CAP_BOTTOM_047 GND nfet_03v3 ad=0 pd=0 as=16.6842p ps=77.76u w=1.56u l=0.28u
X489 VREFN A44_DCTRL_STRIP_W_R2_0/CTRL_OUT[7] A44_CDAC_CAP_BANK_ASSEMBLY_R8_M6_0/A44_CAP_CORE128_M6_R1_0/CAP_BOTTOM_047 GND nfet_03v3 ad=0 pd=0 as=0 ps=0 w=1.56u l=0.28u
X490 VREFN A44_DCTRL_STRIP_W_R2_0/CTRL_OUT[7] A44_CDAC_CAP_BANK_ASSEMBLY_R8_M6_0/A44_CAP_CORE128_M6_R1_0/CAP_BOTTOM_047 GND nfet_03v3 ad=0 pd=0 as=0 ps=0 w=1.56u l=0.28u
X491 VREFN A44_DCTRL_STRIP_W_R2_0/CTRL_OUT[7] A44_CDAC_CAP_BANK_ASSEMBLY_R8_M6_0/A44_CAP_CORE128_M6_R1_0/CAP_BOTTOM_047 GND nfet_03v3 ad=0 pd=0 as=0 ps=0 w=1.56u l=0.28u
X492 VREFN A44_DCTRL_STRIP_W_R2_0/CTRL_OUT[7] A44_CDAC_CAP_BANK_ASSEMBLY_R8_M6_0/A44_CAP_CORE128_M6_R1_0/CAP_BOTTOM_047 GND nfet_03v3 ad=0 pd=0 as=0 ps=0 w=1.56u l=0.28u
X493 VREFN A44_DCTRL_STRIP_W_R2_0/CTRL_OUT[7] A44_CDAC_CAP_BANK_ASSEMBLY_R8_M6_0/A44_CAP_CORE128_M6_R1_0/CAP_BOTTOM_047 GND nfet_03v3 ad=0 pd=0 as=0 ps=0 w=1.56u l=0.28u
X494 VREFN A44_DCTRL_STRIP_W_R2_0/CTRL_OUT[7] A44_CDAC_CAP_BANK_ASSEMBLY_R8_M6_0/A44_CAP_CORE128_M6_R1_0/CAP_BOTTOM_047 GND nfet_03v3 ad=0 pd=0 as=0 ps=0 w=1.56u l=0.28u
X495 VREFN A44_DCTRL_STRIP_W_R2_0/CTRL_OUT[7] A44_CDAC_CAP_BANK_ASSEMBLY_R8_M6_0/A44_CAP_CORE128_M6_R1_0/CAP_BOTTOM_047 GND nfet_03v3 ad=0 pd=0 as=0 ps=0 w=1.56u l=0.28u
X496 VREFN A44_DCTRL_STRIP_W_R2_0/CTRL_OUT[7] A44_CDAC_CAP_BANK_ASSEMBLY_R8_M6_0/A44_CAP_CORE128_M6_R1_0/CAP_BOTTOM_047 GND nfet_03v3 ad=0 pd=0 as=0 ps=0 w=1.56u l=0.28u
X497 VREFN A44_DCTRL_STRIP_W_R2_0/CTRL_OUT[7] A44_CDAC_CAP_BANK_ASSEMBLY_R8_M6_0/A44_CAP_CORE128_M6_R1_0/CAP_BOTTOM_047 GND nfet_03v3 ad=0 pd=0 as=0 ps=0 w=1.56u l=0.28u
X498 VREFN A44_DCTRL_STRIP_W_R2_0/CTRL_OUT[7] A44_CDAC_CAP_BANK_ASSEMBLY_R8_M6_0/A44_CAP_CORE128_M6_R1_0/CAP_BOTTOM_047 GND nfet_03v3 ad=0 pd=0 as=0 ps=0 w=1.56u l=0.28u
X499 VREFN A44_DCTRL_STRIP_W_R2_0/CTRL_OUT[7] A44_CDAC_CAP_BANK_ASSEMBLY_R8_M6_0/A44_CAP_CORE128_M6_R1_0/CAP_BOTTOM_047 GND nfet_03v3 ad=0 pd=0 as=0 ps=0 w=1.56u l=0.28u
X500 VREFN A44_DCTRL_STRIP_W_R2_0/CTRL_OUT[7] A44_CDAC_CAP_BANK_ASSEMBLY_R8_M6_0/A44_CAP_CORE128_M6_R1_0/CAP_BOTTOM_047 GND nfet_03v3 ad=0 pd=0 as=0 ps=0 w=1.56u l=0.28u
X501 VREFN A44_DCTRL_STRIP_W_R2_0/CTRL_OUT[7] A44_CDAC_CAP_BANK_ASSEMBLY_R8_M6_0/A44_CAP_CORE128_M6_R1_0/CAP_BOTTOM_047 GND nfet_03v3 ad=0 pd=0 as=0 ps=0 w=1.56u l=0.28u
X502 VREFN A44_DCTRL_STRIP_W_R2_0/CTRL_OUT[7] A44_CDAC_CAP_BANK_ASSEMBLY_R8_M6_0/A44_CAP_CORE128_M6_R1_0/CAP_BOTTOM_047 GND nfet_03v3 ad=0 pd=0 as=0 ps=0 w=1.56u l=0.28u
X503 VREFN A44_DCTRL_STRIP_W_R2_0/CTRL_OUT[7] A44_CDAC_CAP_BANK_ASSEMBLY_R8_M6_0/A44_CAP_CORE128_M6_R1_0/CAP_BOTTOM_047 GND nfet_03v3 ad=0 pd=0 as=0 ps=0 w=1.56u l=0.28u
X504 VREFN A44_DCTRL_STRIP_W_R2_0/CTRL_OUT[7] A44_CDAC_CAP_BANK_ASSEMBLY_R8_M6_0/A44_CAP_CORE128_M6_R1_0/CAP_BOTTOM_047 GND nfet_03v3 ad=0 pd=0 as=0 ps=0 w=1.56u l=0.28u
X505 VREFN A44_DCTRL_STRIP_W_R2_0/CTRL_OUT[7] A44_CDAC_CAP_BANK_ASSEMBLY_R8_M6_0/A44_CAP_CORE128_M6_R1_0/CAP_BOTTOM_047 GND nfet_03v3 ad=0 pd=0 as=0 ps=0 w=1.56u l=0.28u
X506 VREFP A44_DCTRL_STRIP_W_R2_0/CTRL_OUT[7] A44_CDAC_CAP_BANK_ASSEMBLY_R8_M6_0/A44_CAP_CORE128_M6_R1_0/CAP_BOTTOM_008 VDD pfet_03v3 ad=0 pd=0 as=16.6842p ps=77.76u w=1.56u l=0.28u
X507 VREFP A44_DCTRL_STRIP_W_R2_0/CTRL_OUT[7] A44_CDAC_CAP_BANK_ASSEMBLY_R8_M6_0/A44_CAP_CORE128_M6_R1_0/CAP_BOTTOM_008 VDD pfet_03v3 ad=0 pd=0 as=0 ps=0 w=1.56u l=0.28u
X508 VREFP A44_DCTRL_STRIP_W_R2_0/CTRL_OUT[7] A44_CDAC_CAP_BANK_ASSEMBLY_R8_M6_0/A44_CAP_CORE128_M6_R1_0/CAP_BOTTOM_008 VDD pfet_03v3 ad=0 pd=0 as=0 ps=0 w=1.56u l=0.28u
X509 VREFP A44_DCTRL_STRIP_W_R2_0/CTRL_OUT[7] A44_CDAC_CAP_BANK_ASSEMBLY_R8_M6_0/A44_CAP_CORE128_M6_R1_0/CAP_BOTTOM_008 VDD pfet_03v3 ad=0 pd=0 as=0 ps=0 w=1.56u l=0.28u
X510 VREFP A44_DCTRL_STRIP_W_R2_0/CTRL_OUT[7] A44_CDAC_CAP_BANK_ASSEMBLY_R8_M6_0/A44_CAP_CORE128_M6_R1_0/CAP_BOTTOM_008 VDD pfet_03v3 ad=0 pd=0 as=0 ps=0 w=1.56u l=0.28u
X511 VREFP A44_DCTRL_STRIP_W_R2_0/CTRL_OUT[7] A44_CDAC_CAP_BANK_ASSEMBLY_R8_M6_0/A44_CAP_CORE128_M6_R1_0/CAP_BOTTOM_008 VDD pfet_03v3 ad=0 pd=0 as=0 ps=0 w=1.56u l=0.28u
X512 VREFP A44_DCTRL_STRIP_W_R2_0/CTRL_OUT[7] A44_CDAC_CAP_BANK_ASSEMBLY_R8_M6_0/A44_CAP_CORE128_M6_R1_0/CAP_BOTTOM_008 VDD pfet_03v3 ad=0 pd=0 as=0 ps=0 w=1.56u l=0.28u
X513 VREFP A44_DCTRL_STRIP_W_R2_0/CTRL_OUT[7] A44_CDAC_CAP_BANK_ASSEMBLY_R8_M6_0/A44_CAP_CORE128_M6_R1_0/CAP_BOTTOM_008 VDD pfet_03v3 ad=0 pd=0 as=0 ps=0 w=1.56u l=0.28u
X514 VREFP A44_DCTRL_STRIP_W_R2_0/CTRL_OUT[7] A44_CDAC_CAP_BANK_ASSEMBLY_R8_M6_0/A44_CAP_CORE128_M6_R1_0/CAP_BOTTOM_008 VDD pfet_03v3 ad=0 pd=0 as=0 ps=0 w=1.56u l=0.28u
X515 VREFP A44_DCTRL_STRIP_W_R2_0/CTRL_OUT[7] A44_CDAC_CAP_BANK_ASSEMBLY_R8_M6_0/A44_CAP_CORE128_M6_R1_0/CAP_BOTTOM_008 VDD pfet_03v3 ad=0 pd=0 as=0 ps=0 w=1.56u l=0.28u
X516 VREFP A44_DCTRL_STRIP_W_R2_0/CTRL_OUT[7] A44_CDAC_CAP_BANK_ASSEMBLY_R8_M6_0/A44_CAP_CORE128_M6_R1_0/CAP_BOTTOM_008 VDD pfet_03v3 ad=0 pd=0 as=0 ps=0 w=1.56u l=0.28u
X517 VREFP A44_DCTRL_STRIP_W_R2_0/CTRL_OUT[7] A44_CDAC_CAP_BANK_ASSEMBLY_R8_M6_0/A44_CAP_CORE128_M6_R1_0/CAP_BOTTOM_008 VDD pfet_03v3 ad=0 pd=0 as=0 ps=0 w=1.56u l=0.28u
X518 VREFP A44_DCTRL_STRIP_W_R2_0/CTRL_OUT[7] A44_CDAC_CAP_BANK_ASSEMBLY_R8_M6_0/A44_CAP_CORE128_M6_R1_0/CAP_BOTTOM_008 VDD pfet_03v3 ad=0 pd=0 as=0 ps=0 w=1.56u l=0.28u
X519 VREFP A44_DCTRL_STRIP_W_R2_0/CTRL_OUT[7] A44_CDAC_CAP_BANK_ASSEMBLY_R8_M6_0/A44_CAP_CORE128_M6_R1_0/CAP_BOTTOM_008 VDD pfet_03v3 ad=0 pd=0 as=0 ps=0 w=1.56u l=0.28u
X520 VREFP A44_DCTRL_STRIP_W_R2_0/CTRL_OUT[7] A44_CDAC_CAP_BANK_ASSEMBLY_R8_M6_0/A44_CAP_CORE128_M6_R1_0/CAP_BOTTOM_008 VDD pfet_03v3 ad=0 pd=0 as=0 ps=0 w=1.56u l=0.28u
X521 VREFP A44_DCTRL_STRIP_W_R2_0/CTRL_OUT[7] A44_CDAC_CAP_BANK_ASSEMBLY_R8_M6_0/A44_CAP_CORE128_M6_R1_0/CAP_BOTTOM_008 VDD pfet_03v3 ad=0 pd=0 as=0 ps=0 w=1.56u l=0.28u
X522 VREFP A44_DCTRL_STRIP_W_R2_0/CTRL_OUT[7] A44_CDAC_CAP_BANK_ASSEMBLY_R8_M6_0/A44_CAP_CORE128_M6_R1_0/CAP_BOTTOM_008 VDD pfet_03v3 ad=0 pd=0 as=0 ps=0 w=1.56u l=0.28u
X523 VREFP A44_DCTRL_STRIP_W_R2_0/CTRL_OUT[7] A44_CDAC_CAP_BANK_ASSEMBLY_R8_M6_0/A44_CAP_CORE128_M6_R1_0/CAP_BOTTOM_008 VDD pfet_03v3 ad=0 pd=0 as=0 ps=0 w=1.56u l=0.28u
X524 VREFN A44_DCTRL_STRIP_W_R2_0/CTRL_OUT[7] A44_CDAC_CAP_BANK_ASSEMBLY_R8_M6_0/A44_CAP_CORE128_M6_R1_0/CAP_BOTTOM_008 GND nfet_03v3 ad=0 pd=0 as=16.6842p ps=77.76u w=1.56u l=0.28u
X525 VREFN A44_DCTRL_STRIP_W_R2_0/CTRL_OUT[7] A44_CDAC_CAP_BANK_ASSEMBLY_R8_M6_0/A44_CAP_CORE128_M6_R1_0/CAP_BOTTOM_008 GND nfet_03v3 ad=0 pd=0 as=0 ps=0 w=1.56u l=0.28u
X526 VREFN A44_DCTRL_STRIP_W_R2_0/CTRL_OUT[7] A44_CDAC_CAP_BANK_ASSEMBLY_R8_M6_0/A44_CAP_CORE128_M6_R1_0/CAP_BOTTOM_008 GND nfet_03v3 ad=0 pd=0 as=0 ps=0 w=1.56u l=0.28u
X527 VREFN A44_DCTRL_STRIP_W_R2_0/CTRL_OUT[7] A44_CDAC_CAP_BANK_ASSEMBLY_R8_M6_0/A44_CAP_CORE128_M6_R1_0/CAP_BOTTOM_008 GND nfet_03v3 ad=0 pd=0 as=0 ps=0 w=1.56u l=0.28u
X528 VREFN A44_DCTRL_STRIP_W_R2_0/CTRL_OUT[7] A44_CDAC_CAP_BANK_ASSEMBLY_R8_M6_0/A44_CAP_CORE128_M6_R1_0/CAP_BOTTOM_008 GND nfet_03v3 ad=0 pd=0 as=0 ps=0 w=1.56u l=0.28u
X529 VREFN A44_DCTRL_STRIP_W_R2_0/CTRL_OUT[7] A44_CDAC_CAP_BANK_ASSEMBLY_R8_M6_0/A44_CAP_CORE128_M6_R1_0/CAP_BOTTOM_008 GND nfet_03v3 ad=0 pd=0 as=0 ps=0 w=1.56u l=0.28u
X530 VREFN A44_DCTRL_STRIP_W_R2_0/CTRL_OUT[7] A44_CDAC_CAP_BANK_ASSEMBLY_R8_M6_0/A44_CAP_CORE128_M6_R1_0/CAP_BOTTOM_008 GND nfet_03v3 ad=0 pd=0 as=0 ps=0 w=1.56u l=0.28u
X531 VREFN A44_DCTRL_STRIP_W_R2_0/CTRL_OUT[7] A44_CDAC_CAP_BANK_ASSEMBLY_R8_M6_0/A44_CAP_CORE128_M6_R1_0/CAP_BOTTOM_008 GND nfet_03v3 ad=0 pd=0 as=0 ps=0 w=1.56u l=0.28u
X532 VREFN A44_DCTRL_STRIP_W_R2_0/CTRL_OUT[7] A44_CDAC_CAP_BANK_ASSEMBLY_R8_M6_0/A44_CAP_CORE128_M6_R1_0/CAP_BOTTOM_008 GND nfet_03v3 ad=0 pd=0 as=0 ps=0 w=1.56u l=0.28u
X533 VREFN A44_DCTRL_STRIP_W_R2_0/CTRL_OUT[7] A44_CDAC_CAP_BANK_ASSEMBLY_R8_M6_0/A44_CAP_CORE128_M6_R1_0/CAP_BOTTOM_008 GND nfet_03v3 ad=0 pd=0 as=0 ps=0 w=1.56u l=0.28u
X534 VREFN A44_DCTRL_STRIP_W_R2_0/CTRL_OUT[7] A44_CDAC_CAP_BANK_ASSEMBLY_R8_M6_0/A44_CAP_CORE128_M6_R1_0/CAP_BOTTOM_008 GND nfet_03v3 ad=0 pd=0 as=0 ps=0 w=1.56u l=0.28u
X535 VREFN A44_DCTRL_STRIP_W_R2_0/CTRL_OUT[7] A44_CDAC_CAP_BANK_ASSEMBLY_R8_M6_0/A44_CAP_CORE128_M6_R1_0/CAP_BOTTOM_008 GND nfet_03v3 ad=0 pd=0 as=0 ps=0 w=1.56u l=0.28u
X536 VREFN A44_DCTRL_STRIP_W_R2_0/CTRL_OUT[7] A44_CDAC_CAP_BANK_ASSEMBLY_R8_M6_0/A44_CAP_CORE128_M6_R1_0/CAP_BOTTOM_008 GND nfet_03v3 ad=0 pd=0 as=0 ps=0 w=1.56u l=0.28u
X537 VREFN A44_DCTRL_STRIP_W_R2_0/CTRL_OUT[7] A44_CDAC_CAP_BANK_ASSEMBLY_R8_M6_0/A44_CAP_CORE128_M6_R1_0/CAP_BOTTOM_008 GND nfet_03v3 ad=0 pd=0 as=0 ps=0 w=1.56u l=0.28u
X538 VREFN A44_DCTRL_STRIP_W_R2_0/CTRL_OUT[7] A44_CDAC_CAP_BANK_ASSEMBLY_R8_M6_0/A44_CAP_CORE128_M6_R1_0/CAP_BOTTOM_008 GND nfet_03v3 ad=0 pd=0 as=0 ps=0 w=1.56u l=0.28u
X539 VREFN A44_DCTRL_STRIP_W_R2_0/CTRL_OUT[7] A44_CDAC_CAP_BANK_ASSEMBLY_R8_M6_0/A44_CAP_CORE128_M6_R1_0/CAP_BOTTOM_008 GND nfet_03v3 ad=0 pd=0 as=0 ps=0 w=1.56u l=0.28u
X540 VREFN A44_DCTRL_STRIP_W_R2_0/CTRL_OUT[7] A44_CDAC_CAP_BANK_ASSEMBLY_R8_M6_0/A44_CAP_CORE128_M6_R1_0/CAP_BOTTOM_008 GND nfet_03v3 ad=0 pd=0 as=0 ps=0 w=1.56u l=0.28u
X541 VREFN A44_DCTRL_STRIP_W_R2_0/CTRL_OUT[7] A44_CDAC_CAP_BANK_ASSEMBLY_R8_M6_0/A44_CAP_CORE128_M6_R1_0/CAP_BOTTOM_008 GND nfet_03v3 ad=0 pd=0 as=0 ps=0 w=1.56u l=0.28u
X542 VREFP A44_DCTRL_STRIP_W_R2_0/CTRL_OUT[6] A44_CDAC_CAP_BANK_ASSEMBLY_R8_M6_0/A44_CAP_CORE128_M6_R1_0/CAP_BOTTOM_034 VDD pfet_03v3 ad=0 pd=0 as=16.6842p ps=77.76u w=1.56u l=0.28u
X543 VREFP A44_DCTRL_STRIP_W_R2_0/CTRL_OUT[6] A44_CDAC_CAP_BANK_ASSEMBLY_R8_M6_0/A44_CAP_CORE128_M6_R1_0/CAP_BOTTOM_034 VDD pfet_03v3 ad=0 pd=0 as=0 ps=0 w=1.56u l=0.28u
X544 VREFP A44_DCTRL_STRIP_W_R2_0/CTRL_OUT[6] A44_CDAC_CAP_BANK_ASSEMBLY_R8_M6_0/A44_CAP_CORE128_M6_R1_0/CAP_BOTTOM_034 VDD pfet_03v3 ad=0 pd=0 as=0 ps=0 w=1.56u l=0.28u
X545 VREFP A44_DCTRL_STRIP_W_R2_0/CTRL_OUT[6] A44_CDAC_CAP_BANK_ASSEMBLY_R8_M6_0/A44_CAP_CORE128_M6_R1_0/CAP_BOTTOM_034 VDD pfet_03v3 ad=0 pd=0 as=0 ps=0 w=1.56u l=0.28u
X546 VREFP A44_DCTRL_STRIP_W_R2_0/CTRL_OUT[6] A44_CDAC_CAP_BANK_ASSEMBLY_R8_M6_0/A44_CAP_CORE128_M6_R1_0/CAP_BOTTOM_034 VDD pfet_03v3 ad=0 pd=0 as=0 ps=0 w=1.56u l=0.28u
X547 VREFP A44_DCTRL_STRIP_W_R2_0/CTRL_OUT[6] A44_CDAC_CAP_BANK_ASSEMBLY_R8_M6_0/A44_CAP_CORE128_M6_R1_0/CAP_BOTTOM_034 VDD pfet_03v3 ad=0 pd=0 as=0 ps=0 w=1.56u l=0.28u
X548 VREFP A44_DCTRL_STRIP_W_R2_0/CTRL_OUT[6] A44_CDAC_CAP_BANK_ASSEMBLY_R8_M6_0/A44_CAP_CORE128_M6_R1_0/CAP_BOTTOM_034 VDD pfet_03v3 ad=0 pd=0 as=0 ps=0 w=1.56u l=0.28u
X549 VREFP A44_DCTRL_STRIP_W_R2_0/CTRL_OUT[6] A44_CDAC_CAP_BANK_ASSEMBLY_R8_M6_0/A44_CAP_CORE128_M6_R1_0/CAP_BOTTOM_034 VDD pfet_03v3 ad=0 pd=0 as=0 ps=0 w=1.56u l=0.28u
X550 VREFP A44_DCTRL_STRIP_W_R2_0/CTRL_OUT[6] A44_CDAC_CAP_BANK_ASSEMBLY_R8_M6_0/A44_CAP_CORE128_M6_R1_0/CAP_BOTTOM_034 VDD pfet_03v3 ad=0 pd=0 as=0 ps=0 w=1.56u l=0.28u
X551 VREFP A44_DCTRL_STRIP_W_R2_0/CTRL_OUT[6] A44_CDAC_CAP_BANK_ASSEMBLY_R8_M6_0/A44_CAP_CORE128_M6_R1_0/CAP_BOTTOM_034 VDD pfet_03v3 ad=0 pd=0 as=0 ps=0 w=1.56u l=0.28u
X552 VREFP A44_DCTRL_STRIP_W_R2_0/CTRL_OUT[6] A44_CDAC_CAP_BANK_ASSEMBLY_R8_M6_0/A44_CAP_CORE128_M6_R1_0/CAP_BOTTOM_034 VDD pfet_03v3 ad=0 pd=0 as=0 ps=0 w=1.56u l=0.28u
X553 VREFP A44_DCTRL_STRIP_W_R2_0/CTRL_OUT[6] A44_CDAC_CAP_BANK_ASSEMBLY_R8_M6_0/A44_CAP_CORE128_M6_R1_0/CAP_BOTTOM_034 VDD pfet_03v3 ad=0 pd=0 as=0 ps=0 w=1.56u l=0.28u
X554 VREFP A44_DCTRL_STRIP_W_R2_0/CTRL_OUT[6] A44_CDAC_CAP_BANK_ASSEMBLY_R8_M6_0/A44_CAP_CORE128_M6_R1_0/CAP_BOTTOM_034 VDD pfet_03v3 ad=0 pd=0 as=0 ps=0 w=1.56u l=0.28u
X555 VREFP A44_DCTRL_STRIP_W_R2_0/CTRL_OUT[6] A44_CDAC_CAP_BANK_ASSEMBLY_R8_M6_0/A44_CAP_CORE128_M6_R1_0/CAP_BOTTOM_034 VDD pfet_03v3 ad=0 pd=0 as=0 ps=0 w=1.56u l=0.28u
X556 VREFP A44_DCTRL_STRIP_W_R2_0/CTRL_OUT[6] A44_CDAC_CAP_BANK_ASSEMBLY_R8_M6_0/A44_CAP_CORE128_M6_R1_0/CAP_BOTTOM_034 VDD pfet_03v3 ad=0 pd=0 as=0 ps=0 w=1.56u l=0.28u
X557 VREFP A44_DCTRL_STRIP_W_R2_0/CTRL_OUT[6] A44_CDAC_CAP_BANK_ASSEMBLY_R8_M6_0/A44_CAP_CORE128_M6_R1_0/CAP_BOTTOM_034 VDD pfet_03v3 ad=0 pd=0 as=0 ps=0 w=1.56u l=0.28u
X558 VREFP A44_DCTRL_STRIP_W_R2_0/CTRL_OUT[6] A44_CDAC_CAP_BANK_ASSEMBLY_R8_M6_0/A44_CAP_CORE128_M6_R1_0/CAP_BOTTOM_034 VDD pfet_03v3 ad=0 pd=0 as=0 ps=0 w=1.56u l=0.28u
X559 VREFP A44_DCTRL_STRIP_W_R2_0/CTRL_OUT[6] A44_CDAC_CAP_BANK_ASSEMBLY_R8_M6_0/A44_CAP_CORE128_M6_R1_0/CAP_BOTTOM_034 VDD pfet_03v3 ad=0 pd=0 as=0 ps=0 w=1.56u l=0.28u
X560 VREFN A44_DCTRL_STRIP_W_R2_0/CTRL_OUT[6] A44_CDAC_CAP_BANK_ASSEMBLY_R8_M6_0/A44_CAP_CORE128_M6_R1_0/CAP_BOTTOM_034 GND nfet_03v3 ad=0 pd=0 as=16.6842p ps=77.76u w=1.56u l=0.28u
X561 VREFN A44_DCTRL_STRIP_W_R2_0/CTRL_OUT[6] A44_CDAC_CAP_BANK_ASSEMBLY_R8_M6_0/A44_CAP_CORE128_M6_R1_0/CAP_BOTTOM_034 GND nfet_03v3 ad=0 pd=0 as=0 ps=0 w=1.56u l=0.28u
X562 VREFN A44_DCTRL_STRIP_W_R2_0/CTRL_OUT[6] A44_CDAC_CAP_BANK_ASSEMBLY_R8_M6_0/A44_CAP_CORE128_M6_R1_0/CAP_BOTTOM_034 GND nfet_03v3 ad=0 pd=0 as=0 ps=0 w=1.56u l=0.28u
X563 VREFN A44_DCTRL_STRIP_W_R2_0/CTRL_OUT[6] A44_CDAC_CAP_BANK_ASSEMBLY_R8_M6_0/A44_CAP_CORE128_M6_R1_0/CAP_BOTTOM_034 GND nfet_03v3 ad=0 pd=0 as=0 ps=0 w=1.56u l=0.28u
X564 VREFN A44_DCTRL_STRIP_W_R2_0/CTRL_OUT[6] A44_CDAC_CAP_BANK_ASSEMBLY_R8_M6_0/A44_CAP_CORE128_M6_R1_0/CAP_BOTTOM_034 GND nfet_03v3 ad=0 pd=0 as=0 ps=0 w=1.56u l=0.28u
X565 VREFN A44_DCTRL_STRIP_W_R2_0/CTRL_OUT[6] A44_CDAC_CAP_BANK_ASSEMBLY_R8_M6_0/A44_CAP_CORE128_M6_R1_0/CAP_BOTTOM_034 GND nfet_03v3 ad=0 pd=0 as=0 ps=0 w=1.56u l=0.28u
X566 VREFN A44_DCTRL_STRIP_W_R2_0/CTRL_OUT[6] A44_CDAC_CAP_BANK_ASSEMBLY_R8_M6_0/A44_CAP_CORE128_M6_R1_0/CAP_BOTTOM_034 GND nfet_03v3 ad=0 pd=0 as=0 ps=0 w=1.56u l=0.28u
X567 VREFN A44_DCTRL_STRIP_W_R2_0/CTRL_OUT[6] A44_CDAC_CAP_BANK_ASSEMBLY_R8_M6_0/A44_CAP_CORE128_M6_R1_0/CAP_BOTTOM_034 GND nfet_03v3 ad=0 pd=0 as=0 ps=0 w=1.56u l=0.28u
X568 VREFN A44_DCTRL_STRIP_W_R2_0/CTRL_OUT[6] A44_CDAC_CAP_BANK_ASSEMBLY_R8_M6_0/A44_CAP_CORE128_M6_R1_0/CAP_BOTTOM_034 GND nfet_03v3 ad=0 pd=0 as=0 ps=0 w=1.56u l=0.28u
X569 VREFN A44_DCTRL_STRIP_W_R2_0/CTRL_OUT[6] A44_CDAC_CAP_BANK_ASSEMBLY_R8_M6_0/A44_CAP_CORE128_M6_R1_0/CAP_BOTTOM_034 GND nfet_03v3 ad=0 pd=0 as=0 ps=0 w=1.56u l=0.28u
X570 VREFN A44_DCTRL_STRIP_W_R2_0/CTRL_OUT[6] A44_CDAC_CAP_BANK_ASSEMBLY_R8_M6_0/A44_CAP_CORE128_M6_R1_0/CAP_BOTTOM_034 GND nfet_03v3 ad=0 pd=0 as=0 ps=0 w=1.56u l=0.28u
X571 VREFN A44_DCTRL_STRIP_W_R2_0/CTRL_OUT[6] A44_CDAC_CAP_BANK_ASSEMBLY_R8_M6_0/A44_CAP_CORE128_M6_R1_0/CAP_BOTTOM_034 GND nfet_03v3 ad=0 pd=0 as=0 ps=0 w=1.56u l=0.28u
X572 VREFN A44_DCTRL_STRIP_W_R2_0/CTRL_OUT[6] A44_CDAC_CAP_BANK_ASSEMBLY_R8_M6_0/A44_CAP_CORE128_M6_R1_0/CAP_BOTTOM_034 GND nfet_03v3 ad=0 pd=0 as=0 ps=0 w=1.56u l=0.28u
X573 VREFN A44_DCTRL_STRIP_W_R2_0/CTRL_OUT[6] A44_CDAC_CAP_BANK_ASSEMBLY_R8_M6_0/A44_CAP_CORE128_M6_R1_0/CAP_BOTTOM_034 GND nfet_03v3 ad=0 pd=0 as=0 ps=0 w=1.56u l=0.28u
X574 VREFN A44_DCTRL_STRIP_W_R2_0/CTRL_OUT[6] A44_CDAC_CAP_BANK_ASSEMBLY_R8_M6_0/A44_CAP_CORE128_M6_R1_0/CAP_BOTTOM_034 GND nfet_03v3 ad=0 pd=0 as=0 ps=0 w=1.56u l=0.28u
X575 VREFN A44_DCTRL_STRIP_W_R2_0/CTRL_OUT[6] A44_CDAC_CAP_BANK_ASSEMBLY_R8_M6_0/A44_CAP_CORE128_M6_R1_0/CAP_BOTTOM_034 GND nfet_03v3 ad=0 pd=0 as=0 ps=0 w=1.56u l=0.28u
X576 VREFN A44_DCTRL_STRIP_W_R2_0/CTRL_OUT[6] A44_CDAC_CAP_BANK_ASSEMBLY_R8_M6_0/A44_CAP_CORE128_M6_R1_0/CAP_BOTTOM_034 GND nfet_03v3 ad=0 pd=0 as=0 ps=0 w=1.56u l=0.28u
X577 VREFN A44_DCTRL_STRIP_W_R2_0/CTRL_OUT[6] A44_CDAC_CAP_BANK_ASSEMBLY_R8_M6_0/A44_CAP_CORE128_M6_R1_0/CAP_BOTTOM_034 GND nfet_03v3 ad=0 pd=0 as=0 ps=0 w=1.56u l=0.28u
X578 VREFP A44_DCTRL_STRIP_W_R2_0/CTRL_OUT[7] A44_CDAC_CAP_BANK_ASSEMBLY_R8_M6_0/A44_CAP_CORE128_M6_R1_0/CAP_BOTTOM_031 VDD pfet_03v3 ad=0 pd=0 as=16.6842p ps=77.76u w=1.56u l=0.28u
X579 VREFP A44_DCTRL_STRIP_W_R2_0/CTRL_OUT[7] A44_CDAC_CAP_BANK_ASSEMBLY_R8_M6_0/A44_CAP_CORE128_M6_R1_0/CAP_BOTTOM_031 VDD pfet_03v3 ad=0 pd=0 as=0 ps=0 w=1.56u l=0.28u
X580 VREFP A44_DCTRL_STRIP_W_R2_0/CTRL_OUT[7] A44_CDAC_CAP_BANK_ASSEMBLY_R8_M6_0/A44_CAP_CORE128_M6_R1_0/CAP_BOTTOM_031 VDD pfet_03v3 ad=0 pd=0 as=0 ps=0 w=1.56u l=0.28u
X581 VREFP A44_DCTRL_STRIP_W_R2_0/CTRL_OUT[7] A44_CDAC_CAP_BANK_ASSEMBLY_R8_M6_0/A44_CAP_CORE128_M6_R1_0/CAP_BOTTOM_031 VDD pfet_03v3 ad=0 pd=0 as=0 ps=0 w=1.56u l=0.28u
X582 VREFP A44_DCTRL_STRIP_W_R2_0/CTRL_OUT[7] A44_CDAC_CAP_BANK_ASSEMBLY_R8_M6_0/A44_CAP_CORE128_M6_R1_0/CAP_BOTTOM_031 VDD pfet_03v3 ad=0 pd=0 as=0 ps=0 w=1.56u l=0.28u
X583 VREFP A44_DCTRL_STRIP_W_R2_0/CTRL_OUT[7] A44_CDAC_CAP_BANK_ASSEMBLY_R8_M6_0/A44_CAP_CORE128_M6_R1_0/CAP_BOTTOM_031 VDD pfet_03v3 ad=0 pd=0 as=0 ps=0 w=1.56u l=0.28u
X584 VREFP A44_DCTRL_STRIP_W_R2_0/CTRL_OUT[7] A44_CDAC_CAP_BANK_ASSEMBLY_R8_M6_0/A44_CAP_CORE128_M6_R1_0/CAP_BOTTOM_031 VDD pfet_03v3 ad=0 pd=0 as=0 ps=0 w=1.56u l=0.28u
X585 VREFP A44_DCTRL_STRIP_W_R2_0/CTRL_OUT[7] A44_CDAC_CAP_BANK_ASSEMBLY_R8_M6_0/A44_CAP_CORE128_M6_R1_0/CAP_BOTTOM_031 VDD pfet_03v3 ad=0 pd=0 as=0 ps=0 w=1.56u l=0.28u
X586 VREFP A44_DCTRL_STRIP_W_R2_0/CTRL_OUT[7] A44_CDAC_CAP_BANK_ASSEMBLY_R8_M6_0/A44_CAP_CORE128_M6_R1_0/CAP_BOTTOM_031 VDD pfet_03v3 ad=0 pd=0 as=0 ps=0 w=1.56u l=0.28u
X587 VREFP A44_DCTRL_STRIP_W_R2_0/CTRL_OUT[7] A44_CDAC_CAP_BANK_ASSEMBLY_R8_M6_0/A44_CAP_CORE128_M6_R1_0/CAP_BOTTOM_031 VDD pfet_03v3 ad=0 pd=0 as=0 ps=0 w=1.56u l=0.28u
X588 VREFP A44_DCTRL_STRIP_W_R2_0/CTRL_OUT[7] A44_CDAC_CAP_BANK_ASSEMBLY_R8_M6_0/A44_CAP_CORE128_M6_R1_0/CAP_BOTTOM_031 VDD pfet_03v3 ad=0 pd=0 as=0 ps=0 w=1.56u l=0.28u
X589 VREFP A44_DCTRL_STRIP_W_R2_0/CTRL_OUT[7] A44_CDAC_CAP_BANK_ASSEMBLY_R8_M6_0/A44_CAP_CORE128_M6_R1_0/CAP_BOTTOM_031 VDD pfet_03v3 ad=0 pd=0 as=0 ps=0 w=1.56u l=0.28u
X590 VREFP A44_DCTRL_STRIP_W_R2_0/CTRL_OUT[7] A44_CDAC_CAP_BANK_ASSEMBLY_R8_M6_0/A44_CAP_CORE128_M6_R1_0/CAP_BOTTOM_031 VDD pfet_03v3 ad=0 pd=0 as=0 ps=0 w=1.56u l=0.28u
X591 VREFP A44_DCTRL_STRIP_W_R2_0/CTRL_OUT[7] A44_CDAC_CAP_BANK_ASSEMBLY_R8_M6_0/A44_CAP_CORE128_M6_R1_0/CAP_BOTTOM_031 VDD pfet_03v3 ad=0 pd=0 as=0 ps=0 w=1.56u l=0.28u
X592 VREFP A44_DCTRL_STRIP_W_R2_0/CTRL_OUT[7] A44_CDAC_CAP_BANK_ASSEMBLY_R8_M6_0/A44_CAP_CORE128_M6_R1_0/CAP_BOTTOM_031 VDD pfet_03v3 ad=0 pd=0 as=0 ps=0 w=1.56u l=0.28u
X593 VREFP A44_DCTRL_STRIP_W_R2_0/CTRL_OUT[7] A44_CDAC_CAP_BANK_ASSEMBLY_R8_M6_0/A44_CAP_CORE128_M6_R1_0/CAP_BOTTOM_031 VDD pfet_03v3 ad=0 pd=0 as=0 ps=0 w=1.56u l=0.28u
X594 VREFP A44_DCTRL_STRIP_W_R2_0/CTRL_OUT[7] A44_CDAC_CAP_BANK_ASSEMBLY_R8_M6_0/A44_CAP_CORE128_M6_R1_0/CAP_BOTTOM_031 VDD pfet_03v3 ad=0 pd=0 as=0 ps=0 w=1.56u l=0.28u
X595 VREFP A44_DCTRL_STRIP_W_R2_0/CTRL_OUT[7] A44_CDAC_CAP_BANK_ASSEMBLY_R8_M6_0/A44_CAP_CORE128_M6_R1_0/CAP_BOTTOM_031 VDD pfet_03v3 ad=0 pd=0 as=0 ps=0 w=1.56u l=0.28u
X596 VREFN A44_DCTRL_STRIP_W_R2_0/CTRL_OUT[7] A44_CDAC_CAP_BANK_ASSEMBLY_R8_M6_0/A44_CAP_CORE128_M6_R1_0/CAP_BOTTOM_031 GND nfet_03v3 ad=0 pd=0 as=16.6842p ps=77.76u w=1.56u l=0.28u
X597 VREFN A44_DCTRL_STRIP_W_R2_0/CTRL_OUT[7] A44_CDAC_CAP_BANK_ASSEMBLY_R8_M6_0/A44_CAP_CORE128_M6_R1_0/CAP_BOTTOM_031 GND nfet_03v3 ad=0 pd=0 as=0 ps=0 w=1.56u l=0.28u
X598 VREFN A44_DCTRL_STRIP_W_R2_0/CTRL_OUT[7] A44_CDAC_CAP_BANK_ASSEMBLY_R8_M6_0/A44_CAP_CORE128_M6_R1_0/CAP_BOTTOM_031 GND nfet_03v3 ad=0 pd=0 as=0 ps=0 w=1.56u l=0.28u
X599 VREFN A44_DCTRL_STRIP_W_R2_0/CTRL_OUT[7] A44_CDAC_CAP_BANK_ASSEMBLY_R8_M6_0/A44_CAP_CORE128_M6_R1_0/CAP_BOTTOM_031 GND nfet_03v3 ad=0 pd=0 as=0 ps=0 w=1.56u l=0.28u
X600 VREFN A44_DCTRL_STRIP_W_R2_0/CTRL_OUT[7] A44_CDAC_CAP_BANK_ASSEMBLY_R8_M6_0/A44_CAP_CORE128_M6_R1_0/CAP_BOTTOM_031 GND nfet_03v3 ad=0 pd=0 as=0 ps=0 w=1.56u l=0.28u
X601 VREFN A44_DCTRL_STRIP_W_R2_0/CTRL_OUT[7] A44_CDAC_CAP_BANK_ASSEMBLY_R8_M6_0/A44_CAP_CORE128_M6_R1_0/CAP_BOTTOM_031 GND nfet_03v3 ad=0 pd=0 as=0 ps=0 w=1.56u l=0.28u
X602 VREFN A44_DCTRL_STRIP_W_R2_0/CTRL_OUT[7] A44_CDAC_CAP_BANK_ASSEMBLY_R8_M6_0/A44_CAP_CORE128_M6_R1_0/CAP_BOTTOM_031 GND nfet_03v3 ad=0 pd=0 as=0 ps=0 w=1.56u l=0.28u
X603 VREFN A44_DCTRL_STRIP_W_R2_0/CTRL_OUT[7] A44_CDAC_CAP_BANK_ASSEMBLY_R8_M6_0/A44_CAP_CORE128_M6_R1_0/CAP_BOTTOM_031 GND nfet_03v3 ad=0 pd=0 as=0 ps=0 w=1.56u l=0.28u
X604 VREFN A44_DCTRL_STRIP_W_R2_0/CTRL_OUT[7] A44_CDAC_CAP_BANK_ASSEMBLY_R8_M6_0/A44_CAP_CORE128_M6_R1_0/CAP_BOTTOM_031 GND nfet_03v3 ad=0 pd=0 as=0 ps=0 w=1.56u l=0.28u
X605 VREFN A44_DCTRL_STRIP_W_R2_0/CTRL_OUT[7] A44_CDAC_CAP_BANK_ASSEMBLY_R8_M6_0/A44_CAP_CORE128_M6_R1_0/CAP_BOTTOM_031 GND nfet_03v3 ad=0 pd=0 as=0 ps=0 w=1.56u l=0.28u
X606 VREFN A44_DCTRL_STRIP_W_R2_0/CTRL_OUT[7] A44_CDAC_CAP_BANK_ASSEMBLY_R8_M6_0/A44_CAP_CORE128_M6_R1_0/CAP_BOTTOM_031 GND nfet_03v3 ad=0 pd=0 as=0 ps=0 w=1.56u l=0.28u
X607 VREFN A44_DCTRL_STRIP_W_R2_0/CTRL_OUT[7] A44_CDAC_CAP_BANK_ASSEMBLY_R8_M6_0/A44_CAP_CORE128_M6_R1_0/CAP_BOTTOM_031 GND nfet_03v3 ad=0 pd=0 as=0 ps=0 w=1.56u l=0.28u
X608 VREFN A44_DCTRL_STRIP_W_R2_0/CTRL_OUT[7] A44_CDAC_CAP_BANK_ASSEMBLY_R8_M6_0/A44_CAP_CORE128_M6_R1_0/CAP_BOTTOM_031 GND nfet_03v3 ad=0 pd=0 as=0 ps=0 w=1.56u l=0.28u
X609 VREFN A44_DCTRL_STRIP_W_R2_0/CTRL_OUT[7] A44_CDAC_CAP_BANK_ASSEMBLY_R8_M6_0/A44_CAP_CORE128_M6_R1_0/CAP_BOTTOM_031 GND nfet_03v3 ad=0 pd=0 as=0 ps=0 w=1.56u l=0.28u
X610 VREFN A44_DCTRL_STRIP_W_R2_0/CTRL_OUT[7] A44_CDAC_CAP_BANK_ASSEMBLY_R8_M6_0/A44_CAP_CORE128_M6_R1_0/CAP_BOTTOM_031 GND nfet_03v3 ad=0 pd=0 as=0 ps=0 w=1.56u l=0.28u
X611 VREFN A44_DCTRL_STRIP_W_R2_0/CTRL_OUT[7] A44_CDAC_CAP_BANK_ASSEMBLY_R8_M6_0/A44_CAP_CORE128_M6_R1_0/CAP_BOTTOM_031 GND nfet_03v3 ad=0 pd=0 as=0 ps=0 w=1.56u l=0.28u
X612 VREFN A44_DCTRL_STRIP_W_R2_0/CTRL_OUT[7] A44_CDAC_CAP_BANK_ASSEMBLY_R8_M6_0/A44_CAP_CORE128_M6_R1_0/CAP_BOTTOM_031 GND nfet_03v3 ad=0 pd=0 as=0 ps=0 w=1.56u l=0.28u
X613 VREFN A44_DCTRL_STRIP_W_R2_0/CTRL_OUT[7] A44_CDAC_CAP_BANK_ASSEMBLY_R8_M6_0/A44_CAP_CORE128_M6_R1_0/CAP_BOTTOM_031 GND nfet_03v3 ad=0 pd=0 as=0 ps=0 w=1.56u l=0.28u
X614 VREFP A44_DCTRL_STRIP_W_R2_0/CTRL_OUT[7] A44_CDAC_CAP_BANK_ASSEMBLY_R8_M6_0/A44_CAP_CORE128_M6_R1_0/CAP_BOTTOM_058 VDD pfet_03v3 ad=0 pd=0 as=16.6842p ps=77.76u w=1.56u l=0.28u
X615 VREFP A44_DCTRL_STRIP_W_R2_0/CTRL_OUT[7] A44_CDAC_CAP_BANK_ASSEMBLY_R8_M6_0/A44_CAP_CORE128_M6_R1_0/CAP_BOTTOM_058 VDD pfet_03v3 ad=0 pd=0 as=0 ps=0 w=1.56u l=0.28u
X616 VREFP A44_DCTRL_STRIP_W_R2_0/CTRL_OUT[7] A44_CDAC_CAP_BANK_ASSEMBLY_R8_M6_0/A44_CAP_CORE128_M6_R1_0/CAP_BOTTOM_058 VDD pfet_03v3 ad=0 pd=0 as=0 ps=0 w=1.56u l=0.28u
X617 VREFP A44_DCTRL_STRIP_W_R2_0/CTRL_OUT[7] A44_CDAC_CAP_BANK_ASSEMBLY_R8_M6_0/A44_CAP_CORE128_M6_R1_0/CAP_BOTTOM_058 VDD pfet_03v3 ad=0 pd=0 as=0 ps=0 w=1.56u l=0.28u
X618 VREFP A44_DCTRL_STRIP_W_R2_0/CTRL_OUT[7] A44_CDAC_CAP_BANK_ASSEMBLY_R8_M6_0/A44_CAP_CORE128_M6_R1_0/CAP_BOTTOM_058 VDD pfet_03v3 ad=0 pd=0 as=0 ps=0 w=1.56u l=0.28u
X619 VREFP A44_DCTRL_STRIP_W_R2_0/CTRL_OUT[7] A44_CDAC_CAP_BANK_ASSEMBLY_R8_M6_0/A44_CAP_CORE128_M6_R1_0/CAP_BOTTOM_058 VDD pfet_03v3 ad=0 pd=0 as=0 ps=0 w=1.56u l=0.28u
X620 VREFP A44_DCTRL_STRIP_W_R2_0/CTRL_OUT[7] A44_CDAC_CAP_BANK_ASSEMBLY_R8_M6_0/A44_CAP_CORE128_M6_R1_0/CAP_BOTTOM_058 VDD pfet_03v3 ad=0 pd=0 as=0 ps=0 w=1.56u l=0.28u
X621 VREFP A44_DCTRL_STRIP_W_R2_0/CTRL_OUT[7] A44_CDAC_CAP_BANK_ASSEMBLY_R8_M6_0/A44_CAP_CORE128_M6_R1_0/CAP_BOTTOM_058 VDD pfet_03v3 ad=0 pd=0 as=0 ps=0 w=1.56u l=0.28u
X622 VREFP A44_DCTRL_STRIP_W_R2_0/CTRL_OUT[7] A44_CDAC_CAP_BANK_ASSEMBLY_R8_M6_0/A44_CAP_CORE128_M6_R1_0/CAP_BOTTOM_058 VDD pfet_03v3 ad=0 pd=0 as=0 ps=0 w=1.56u l=0.28u
X623 VREFP A44_DCTRL_STRIP_W_R2_0/CTRL_OUT[7] A44_CDAC_CAP_BANK_ASSEMBLY_R8_M6_0/A44_CAP_CORE128_M6_R1_0/CAP_BOTTOM_058 VDD pfet_03v3 ad=0 pd=0 as=0 ps=0 w=1.56u l=0.28u
X624 VREFP A44_DCTRL_STRIP_W_R2_0/CTRL_OUT[7] A44_CDAC_CAP_BANK_ASSEMBLY_R8_M6_0/A44_CAP_CORE128_M6_R1_0/CAP_BOTTOM_058 VDD pfet_03v3 ad=0 pd=0 as=0 ps=0 w=1.56u l=0.28u
X625 VREFP A44_DCTRL_STRIP_W_R2_0/CTRL_OUT[7] A44_CDAC_CAP_BANK_ASSEMBLY_R8_M6_0/A44_CAP_CORE128_M6_R1_0/CAP_BOTTOM_058 VDD pfet_03v3 ad=0 pd=0 as=0 ps=0 w=1.56u l=0.28u
X626 VREFP A44_DCTRL_STRIP_W_R2_0/CTRL_OUT[7] A44_CDAC_CAP_BANK_ASSEMBLY_R8_M6_0/A44_CAP_CORE128_M6_R1_0/CAP_BOTTOM_058 VDD pfet_03v3 ad=0 pd=0 as=0 ps=0 w=1.56u l=0.28u
X627 VREFP A44_DCTRL_STRIP_W_R2_0/CTRL_OUT[7] A44_CDAC_CAP_BANK_ASSEMBLY_R8_M6_0/A44_CAP_CORE128_M6_R1_0/CAP_BOTTOM_058 VDD pfet_03v3 ad=0 pd=0 as=0 ps=0 w=1.56u l=0.28u
X628 VREFP A44_DCTRL_STRIP_W_R2_0/CTRL_OUT[7] A44_CDAC_CAP_BANK_ASSEMBLY_R8_M6_0/A44_CAP_CORE128_M6_R1_0/CAP_BOTTOM_058 VDD pfet_03v3 ad=0 pd=0 as=0 ps=0 w=1.56u l=0.28u
X629 VREFP A44_DCTRL_STRIP_W_R2_0/CTRL_OUT[7] A44_CDAC_CAP_BANK_ASSEMBLY_R8_M6_0/A44_CAP_CORE128_M6_R1_0/CAP_BOTTOM_058 VDD pfet_03v3 ad=0 pd=0 as=0 ps=0 w=1.56u l=0.28u
X630 VREFP A44_DCTRL_STRIP_W_R2_0/CTRL_OUT[7] A44_CDAC_CAP_BANK_ASSEMBLY_R8_M6_0/A44_CAP_CORE128_M6_R1_0/CAP_BOTTOM_058 VDD pfet_03v3 ad=0 pd=0 as=0 ps=0 w=1.56u l=0.28u
X631 VREFP A44_DCTRL_STRIP_W_R2_0/CTRL_OUT[7] A44_CDAC_CAP_BANK_ASSEMBLY_R8_M6_0/A44_CAP_CORE128_M6_R1_0/CAP_BOTTOM_058 VDD pfet_03v3 ad=0 pd=0 as=0 ps=0 w=1.56u l=0.28u
X632 VREFN A44_DCTRL_STRIP_W_R2_0/CTRL_OUT[7] A44_CDAC_CAP_BANK_ASSEMBLY_R8_M6_0/A44_CAP_CORE128_M6_R1_0/CAP_BOTTOM_058 GND nfet_03v3 ad=0 pd=0 as=16.6842p ps=77.76u w=1.56u l=0.28u
X633 VREFN A44_DCTRL_STRIP_W_R2_0/CTRL_OUT[7] A44_CDAC_CAP_BANK_ASSEMBLY_R8_M6_0/A44_CAP_CORE128_M6_R1_0/CAP_BOTTOM_058 GND nfet_03v3 ad=0 pd=0 as=0 ps=0 w=1.56u l=0.28u
X634 VREFN A44_DCTRL_STRIP_W_R2_0/CTRL_OUT[7] A44_CDAC_CAP_BANK_ASSEMBLY_R8_M6_0/A44_CAP_CORE128_M6_R1_0/CAP_BOTTOM_058 GND nfet_03v3 ad=0 pd=0 as=0 ps=0 w=1.56u l=0.28u
X635 VREFN A44_DCTRL_STRIP_W_R2_0/CTRL_OUT[7] A44_CDAC_CAP_BANK_ASSEMBLY_R8_M6_0/A44_CAP_CORE128_M6_R1_0/CAP_BOTTOM_058 GND nfet_03v3 ad=0 pd=0 as=0 ps=0 w=1.56u l=0.28u
X636 VREFN A44_DCTRL_STRIP_W_R2_0/CTRL_OUT[7] A44_CDAC_CAP_BANK_ASSEMBLY_R8_M6_0/A44_CAP_CORE128_M6_R1_0/CAP_BOTTOM_058 GND nfet_03v3 ad=0 pd=0 as=0 ps=0 w=1.56u l=0.28u
X637 VREFN A44_DCTRL_STRIP_W_R2_0/CTRL_OUT[7] A44_CDAC_CAP_BANK_ASSEMBLY_R8_M6_0/A44_CAP_CORE128_M6_R1_0/CAP_BOTTOM_058 GND nfet_03v3 ad=0 pd=0 as=0 ps=0 w=1.56u l=0.28u
X638 VREFN A44_DCTRL_STRIP_W_R2_0/CTRL_OUT[7] A44_CDAC_CAP_BANK_ASSEMBLY_R8_M6_0/A44_CAP_CORE128_M6_R1_0/CAP_BOTTOM_058 GND nfet_03v3 ad=0 pd=0 as=0 ps=0 w=1.56u l=0.28u
X639 VREFN A44_DCTRL_STRIP_W_R2_0/CTRL_OUT[7] A44_CDAC_CAP_BANK_ASSEMBLY_R8_M6_0/A44_CAP_CORE128_M6_R1_0/CAP_BOTTOM_058 GND nfet_03v3 ad=0 pd=0 as=0 ps=0 w=1.56u l=0.28u
X640 VREFN A44_DCTRL_STRIP_W_R2_0/CTRL_OUT[7] A44_CDAC_CAP_BANK_ASSEMBLY_R8_M6_0/A44_CAP_CORE128_M6_R1_0/CAP_BOTTOM_058 GND nfet_03v3 ad=0 pd=0 as=0 ps=0 w=1.56u l=0.28u
X641 VREFN A44_DCTRL_STRIP_W_R2_0/CTRL_OUT[7] A44_CDAC_CAP_BANK_ASSEMBLY_R8_M6_0/A44_CAP_CORE128_M6_R1_0/CAP_BOTTOM_058 GND nfet_03v3 ad=0 pd=0 as=0 ps=0 w=1.56u l=0.28u
X642 VREFN A44_DCTRL_STRIP_W_R2_0/CTRL_OUT[7] A44_CDAC_CAP_BANK_ASSEMBLY_R8_M6_0/A44_CAP_CORE128_M6_R1_0/CAP_BOTTOM_058 GND nfet_03v3 ad=0 pd=0 as=0 ps=0 w=1.56u l=0.28u
X643 VREFN A44_DCTRL_STRIP_W_R2_0/CTRL_OUT[7] A44_CDAC_CAP_BANK_ASSEMBLY_R8_M6_0/A44_CAP_CORE128_M6_R1_0/CAP_BOTTOM_058 GND nfet_03v3 ad=0 pd=0 as=0 ps=0 w=1.56u l=0.28u
X644 VREFN A44_DCTRL_STRIP_W_R2_0/CTRL_OUT[7] A44_CDAC_CAP_BANK_ASSEMBLY_R8_M6_0/A44_CAP_CORE128_M6_R1_0/CAP_BOTTOM_058 GND nfet_03v3 ad=0 pd=0 as=0 ps=0 w=1.56u l=0.28u
X645 VREFN A44_DCTRL_STRIP_W_R2_0/CTRL_OUT[7] A44_CDAC_CAP_BANK_ASSEMBLY_R8_M6_0/A44_CAP_CORE128_M6_R1_0/CAP_BOTTOM_058 GND nfet_03v3 ad=0 pd=0 as=0 ps=0 w=1.56u l=0.28u
X646 VREFN A44_DCTRL_STRIP_W_R2_0/CTRL_OUT[7] A44_CDAC_CAP_BANK_ASSEMBLY_R8_M6_0/A44_CAP_CORE128_M6_R1_0/CAP_BOTTOM_058 GND nfet_03v3 ad=0 pd=0 as=0 ps=0 w=1.56u l=0.28u
X647 VREFN A44_DCTRL_STRIP_W_R2_0/CTRL_OUT[7] A44_CDAC_CAP_BANK_ASSEMBLY_R8_M6_0/A44_CAP_CORE128_M6_R1_0/CAP_BOTTOM_058 GND nfet_03v3 ad=0 pd=0 as=0 ps=0 w=1.56u l=0.28u
X648 VREFN A44_DCTRL_STRIP_W_R2_0/CTRL_OUT[7] A44_CDAC_CAP_BANK_ASSEMBLY_R8_M6_0/A44_CAP_CORE128_M6_R1_0/CAP_BOTTOM_058 GND nfet_03v3 ad=0 pd=0 as=0 ps=0 w=1.56u l=0.28u
X649 VREFN A44_DCTRL_STRIP_W_R2_0/CTRL_OUT[7] A44_CDAC_CAP_BANK_ASSEMBLY_R8_M6_0/A44_CAP_CORE128_M6_R1_0/CAP_BOTTOM_058 GND nfet_03v3 ad=0 pd=0 as=0 ps=0 w=1.56u l=0.28u
X650 VREFP A44_DCTRL_STRIP_W_R2_0/CTRL_OUT[7] A44_CDAC_CAP_BANK_ASSEMBLY_R8_M6_0/A44_CAP_CORE128_M6_R1_0/CAP_BOTTOM_021 VDD pfet_03v3 ad=0 pd=0 as=16.6842p ps=77.76u w=1.56u l=0.28u
X651 VREFP A44_DCTRL_STRIP_W_R2_0/CTRL_OUT[7] A44_CDAC_CAP_BANK_ASSEMBLY_R8_M6_0/A44_CAP_CORE128_M6_R1_0/CAP_BOTTOM_021 VDD pfet_03v3 ad=0 pd=0 as=0 ps=0 w=1.56u l=0.28u
X652 VREFP A44_DCTRL_STRIP_W_R2_0/CTRL_OUT[7] A44_CDAC_CAP_BANK_ASSEMBLY_R8_M6_0/A44_CAP_CORE128_M6_R1_0/CAP_BOTTOM_021 VDD pfet_03v3 ad=0 pd=0 as=0 ps=0 w=1.56u l=0.28u
X653 VREFP A44_DCTRL_STRIP_W_R2_0/CTRL_OUT[7] A44_CDAC_CAP_BANK_ASSEMBLY_R8_M6_0/A44_CAP_CORE128_M6_R1_0/CAP_BOTTOM_021 VDD pfet_03v3 ad=0 pd=0 as=0 ps=0 w=1.56u l=0.28u
X654 VREFP A44_DCTRL_STRIP_W_R2_0/CTRL_OUT[7] A44_CDAC_CAP_BANK_ASSEMBLY_R8_M6_0/A44_CAP_CORE128_M6_R1_0/CAP_BOTTOM_021 VDD pfet_03v3 ad=0 pd=0 as=0 ps=0 w=1.56u l=0.28u
X655 VREFP A44_DCTRL_STRIP_W_R2_0/CTRL_OUT[7] A44_CDAC_CAP_BANK_ASSEMBLY_R8_M6_0/A44_CAP_CORE128_M6_R1_0/CAP_BOTTOM_021 VDD pfet_03v3 ad=0 pd=0 as=0 ps=0 w=1.56u l=0.28u
X656 VREFP A44_DCTRL_STRIP_W_R2_0/CTRL_OUT[7] A44_CDAC_CAP_BANK_ASSEMBLY_R8_M6_0/A44_CAP_CORE128_M6_R1_0/CAP_BOTTOM_021 VDD pfet_03v3 ad=0 pd=0 as=0 ps=0 w=1.56u l=0.28u
X657 VREFP A44_DCTRL_STRIP_W_R2_0/CTRL_OUT[7] A44_CDAC_CAP_BANK_ASSEMBLY_R8_M6_0/A44_CAP_CORE128_M6_R1_0/CAP_BOTTOM_021 VDD pfet_03v3 ad=0 pd=0 as=0 ps=0 w=1.56u l=0.28u
X658 VREFP A44_DCTRL_STRIP_W_R2_0/CTRL_OUT[7] A44_CDAC_CAP_BANK_ASSEMBLY_R8_M6_0/A44_CAP_CORE128_M6_R1_0/CAP_BOTTOM_021 VDD pfet_03v3 ad=0 pd=0 as=0 ps=0 w=1.56u l=0.28u
X659 VREFP A44_DCTRL_STRIP_W_R2_0/CTRL_OUT[7] A44_CDAC_CAP_BANK_ASSEMBLY_R8_M6_0/A44_CAP_CORE128_M6_R1_0/CAP_BOTTOM_021 VDD pfet_03v3 ad=0 pd=0 as=0 ps=0 w=1.56u l=0.28u
X660 VREFP A44_DCTRL_STRIP_W_R2_0/CTRL_OUT[7] A44_CDAC_CAP_BANK_ASSEMBLY_R8_M6_0/A44_CAP_CORE128_M6_R1_0/CAP_BOTTOM_021 VDD pfet_03v3 ad=0 pd=0 as=0 ps=0 w=1.56u l=0.28u
X661 VREFP A44_DCTRL_STRIP_W_R2_0/CTRL_OUT[7] A44_CDAC_CAP_BANK_ASSEMBLY_R8_M6_0/A44_CAP_CORE128_M6_R1_0/CAP_BOTTOM_021 VDD pfet_03v3 ad=0 pd=0 as=0 ps=0 w=1.56u l=0.28u
X662 VREFP A44_DCTRL_STRIP_W_R2_0/CTRL_OUT[7] A44_CDAC_CAP_BANK_ASSEMBLY_R8_M6_0/A44_CAP_CORE128_M6_R1_0/CAP_BOTTOM_021 VDD pfet_03v3 ad=0 pd=0 as=0 ps=0 w=1.56u l=0.28u
X663 VREFP A44_DCTRL_STRIP_W_R2_0/CTRL_OUT[7] A44_CDAC_CAP_BANK_ASSEMBLY_R8_M6_0/A44_CAP_CORE128_M6_R1_0/CAP_BOTTOM_021 VDD pfet_03v3 ad=0 pd=0 as=0 ps=0 w=1.56u l=0.28u
X664 VREFP A44_DCTRL_STRIP_W_R2_0/CTRL_OUT[7] A44_CDAC_CAP_BANK_ASSEMBLY_R8_M6_0/A44_CAP_CORE128_M6_R1_0/CAP_BOTTOM_021 VDD pfet_03v3 ad=0 pd=0 as=0 ps=0 w=1.56u l=0.28u
X665 VREFP A44_DCTRL_STRIP_W_R2_0/CTRL_OUT[7] A44_CDAC_CAP_BANK_ASSEMBLY_R8_M6_0/A44_CAP_CORE128_M6_R1_0/CAP_BOTTOM_021 VDD pfet_03v3 ad=0 pd=0 as=0 ps=0 w=1.56u l=0.28u
X666 VREFP A44_DCTRL_STRIP_W_R2_0/CTRL_OUT[7] A44_CDAC_CAP_BANK_ASSEMBLY_R8_M6_0/A44_CAP_CORE128_M6_R1_0/CAP_BOTTOM_021 VDD pfet_03v3 ad=0 pd=0 as=0 ps=0 w=1.56u l=0.28u
X667 VREFP A44_DCTRL_STRIP_W_R2_0/CTRL_OUT[7] A44_CDAC_CAP_BANK_ASSEMBLY_R8_M6_0/A44_CAP_CORE128_M6_R1_0/CAP_BOTTOM_021 VDD pfet_03v3 ad=0 pd=0 as=0 ps=0 w=1.56u l=0.28u
X668 VREFN A44_DCTRL_STRIP_W_R2_0/CTRL_OUT[7] A44_CDAC_CAP_BANK_ASSEMBLY_R8_M6_0/A44_CAP_CORE128_M6_R1_0/CAP_BOTTOM_021 GND nfet_03v3 ad=0 pd=0 as=16.6842p ps=77.76u w=1.56u l=0.28u
X669 VREFN A44_DCTRL_STRIP_W_R2_0/CTRL_OUT[7] A44_CDAC_CAP_BANK_ASSEMBLY_R8_M6_0/A44_CAP_CORE128_M6_R1_0/CAP_BOTTOM_021 GND nfet_03v3 ad=0 pd=0 as=0 ps=0 w=1.56u l=0.28u
X670 VREFN A44_DCTRL_STRIP_W_R2_0/CTRL_OUT[7] A44_CDAC_CAP_BANK_ASSEMBLY_R8_M6_0/A44_CAP_CORE128_M6_R1_0/CAP_BOTTOM_021 GND nfet_03v3 ad=0 pd=0 as=0 ps=0 w=1.56u l=0.28u
X671 VREFN A44_DCTRL_STRIP_W_R2_0/CTRL_OUT[7] A44_CDAC_CAP_BANK_ASSEMBLY_R8_M6_0/A44_CAP_CORE128_M6_R1_0/CAP_BOTTOM_021 GND nfet_03v3 ad=0 pd=0 as=0 ps=0 w=1.56u l=0.28u
X672 VREFN A44_DCTRL_STRIP_W_R2_0/CTRL_OUT[7] A44_CDAC_CAP_BANK_ASSEMBLY_R8_M6_0/A44_CAP_CORE128_M6_R1_0/CAP_BOTTOM_021 GND nfet_03v3 ad=0 pd=0 as=0 ps=0 w=1.56u l=0.28u
X673 VREFN A44_DCTRL_STRIP_W_R2_0/CTRL_OUT[7] A44_CDAC_CAP_BANK_ASSEMBLY_R8_M6_0/A44_CAP_CORE128_M6_R1_0/CAP_BOTTOM_021 GND nfet_03v3 ad=0 pd=0 as=0 ps=0 w=1.56u l=0.28u
X674 VREFN A44_DCTRL_STRIP_W_R2_0/CTRL_OUT[7] A44_CDAC_CAP_BANK_ASSEMBLY_R8_M6_0/A44_CAP_CORE128_M6_R1_0/CAP_BOTTOM_021 GND nfet_03v3 ad=0 pd=0 as=0 ps=0 w=1.56u l=0.28u
X675 VREFN A44_DCTRL_STRIP_W_R2_0/CTRL_OUT[7] A44_CDAC_CAP_BANK_ASSEMBLY_R8_M6_0/A44_CAP_CORE128_M6_R1_0/CAP_BOTTOM_021 GND nfet_03v3 ad=0 pd=0 as=0 ps=0 w=1.56u l=0.28u
X676 VREFN A44_DCTRL_STRIP_W_R2_0/CTRL_OUT[7] A44_CDAC_CAP_BANK_ASSEMBLY_R8_M6_0/A44_CAP_CORE128_M6_R1_0/CAP_BOTTOM_021 GND nfet_03v3 ad=0 pd=0 as=0 ps=0 w=1.56u l=0.28u
X677 VREFN A44_DCTRL_STRIP_W_R2_0/CTRL_OUT[7] A44_CDAC_CAP_BANK_ASSEMBLY_R8_M6_0/A44_CAP_CORE128_M6_R1_0/CAP_BOTTOM_021 GND nfet_03v3 ad=0 pd=0 as=0 ps=0 w=1.56u l=0.28u
X678 VREFN A44_DCTRL_STRIP_W_R2_0/CTRL_OUT[7] A44_CDAC_CAP_BANK_ASSEMBLY_R8_M6_0/A44_CAP_CORE128_M6_R1_0/CAP_BOTTOM_021 GND nfet_03v3 ad=0 pd=0 as=0 ps=0 w=1.56u l=0.28u
X679 VREFN A44_DCTRL_STRIP_W_R2_0/CTRL_OUT[7] A44_CDAC_CAP_BANK_ASSEMBLY_R8_M6_0/A44_CAP_CORE128_M6_R1_0/CAP_BOTTOM_021 GND nfet_03v3 ad=0 pd=0 as=0 ps=0 w=1.56u l=0.28u
X680 VREFN A44_DCTRL_STRIP_W_R2_0/CTRL_OUT[7] A44_CDAC_CAP_BANK_ASSEMBLY_R8_M6_0/A44_CAP_CORE128_M6_R1_0/CAP_BOTTOM_021 GND nfet_03v3 ad=0 pd=0 as=0 ps=0 w=1.56u l=0.28u
X681 VREFN A44_DCTRL_STRIP_W_R2_0/CTRL_OUT[7] A44_CDAC_CAP_BANK_ASSEMBLY_R8_M6_0/A44_CAP_CORE128_M6_R1_0/CAP_BOTTOM_021 GND nfet_03v3 ad=0 pd=0 as=0 ps=0 w=1.56u l=0.28u
X682 VREFN A44_DCTRL_STRIP_W_R2_0/CTRL_OUT[7] A44_CDAC_CAP_BANK_ASSEMBLY_R8_M6_0/A44_CAP_CORE128_M6_R1_0/CAP_BOTTOM_021 GND nfet_03v3 ad=0 pd=0 as=0 ps=0 w=1.56u l=0.28u
X683 VREFN A44_DCTRL_STRIP_W_R2_0/CTRL_OUT[7] A44_CDAC_CAP_BANK_ASSEMBLY_R8_M6_0/A44_CAP_CORE128_M6_R1_0/CAP_BOTTOM_021 GND nfet_03v3 ad=0 pd=0 as=0 ps=0 w=1.56u l=0.28u
X684 VREFN A44_DCTRL_STRIP_W_R2_0/CTRL_OUT[7] A44_CDAC_CAP_BANK_ASSEMBLY_R8_M6_0/A44_CAP_CORE128_M6_R1_0/CAP_BOTTOM_021 GND nfet_03v3 ad=0 pd=0 as=0 ps=0 w=1.56u l=0.28u
X685 VREFN A44_DCTRL_STRIP_W_R2_0/CTRL_OUT[7] A44_CDAC_CAP_BANK_ASSEMBLY_R8_M6_0/A44_CAP_CORE128_M6_R1_0/CAP_BOTTOM_021 GND nfet_03v3 ad=0 pd=0 as=0 ps=0 w=1.56u l=0.28u
X686 VREFP A44_DCTRL_STRIP_W_R2_0/CTRL_OUT[6] A44_CDAC_CAP_BANK_ASSEMBLY_R8_M6_0/A44_CAP_CORE128_M6_R1_0/CAP_BOTTOM_015 VDD pfet_03v3 ad=0 pd=0 as=16.6842p ps=77.76u w=1.56u l=0.28u
X687 VREFP A44_DCTRL_STRIP_W_R2_0/CTRL_OUT[6] A44_CDAC_CAP_BANK_ASSEMBLY_R8_M6_0/A44_CAP_CORE128_M6_R1_0/CAP_BOTTOM_015 VDD pfet_03v3 ad=0 pd=0 as=0 ps=0 w=1.56u l=0.28u
X688 VREFP A44_DCTRL_STRIP_W_R2_0/CTRL_OUT[6] A44_CDAC_CAP_BANK_ASSEMBLY_R8_M6_0/A44_CAP_CORE128_M6_R1_0/CAP_BOTTOM_015 VDD pfet_03v3 ad=0 pd=0 as=0 ps=0 w=1.56u l=0.28u
X689 VREFP A44_DCTRL_STRIP_W_R2_0/CTRL_OUT[6] A44_CDAC_CAP_BANK_ASSEMBLY_R8_M6_0/A44_CAP_CORE128_M6_R1_0/CAP_BOTTOM_015 VDD pfet_03v3 ad=0 pd=0 as=0 ps=0 w=1.56u l=0.28u
X690 VREFP A44_DCTRL_STRIP_W_R2_0/CTRL_OUT[6] A44_CDAC_CAP_BANK_ASSEMBLY_R8_M6_0/A44_CAP_CORE128_M6_R1_0/CAP_BOTTOM_015 VDD pfet_03v3 ad=0 pd=0 as=0 ps=0 w=1.56u l=0.28u
X691 VREFP A44_DCTRL_STRIP_W_R2_0/CTRL_OUT[6] A44_CDAC_CAP_BANK_ASSEMBLY_R8_M6_0/A44_CAP_CORE128_M6_R1_0/CAP_BOTTOM_015 VDD pfet_03v3 ad=0 pd=0 as=0 ps=0 w=1.56u l=0.28u
X692 VREFP A44_DCTRL_STRIP_W_R2_0/CTRL_OUT[6] A44_CDAC_CAP_BANK_ASSEMBLY_R8_M6_0/A44_CAP_CORE128_M6_R1_0/CAP_BOTTOM_015 VDD pfet_03v3 ad=0 pd=0 as=0 ps=0 w=1.56u l=0.28u
X693 VREFP A44_DCTRL_STRIP_W_R2_0/CTRL_OUT[6] A44_CDAC_CAP_BANK_ASSEMBLY_R8_M6_0/A44_CAP_CORE128_M6_R1_0/CAP_BOTTOM_015 VDD pfet_03v3 ad=0 pd=0 as=0 ps=0 w=1.56u l=0.28u
X694 VREFP A44_DCTRL_STRIP_W_R2_0/CTRL_OUT[6] A44_CDAC_CAP_BANK_ASSEMBLY_R8_M6_0/A44_CAP_CORE128_M6_R1_0/CAP_BOTTOM_015 VDD pfet_03v3 ad=0 pd=0 as=0 ps=0 w=1.56u l=0.28u
X695 VREFP A44_DCTRL_STRIP_W_R2_0/CTRL_OUT[6] A44_CDAC_CAP_BANK_ASSEMBLY_R8_M6_0/A44_CAP_CORE128_M6_R1_0/CAP_BOTTOM_015 VDD pfet_03v3 ad=0 pd=0 as=0 ps=0 w=1.56u l=0.28u
X696 VREFP A44_DCTRL_STRIP_W_R2_0/CTRL_OUT[6] A44_CDAC_CAP_BANK_ASSEMBLY_R8_M6_0/A44_CAP_CORE128_M6_R1_0/CAP_BOTTOM_015 VDD pfet_03v3 ad=0 pd=0 as=0 ps=0 w=1.56u l=0.28u
X697 VREFP A44_DCTRL_STRIP_W_R2_0/CTRL_OUT[6] A44_CDAC_CAP_BANK_ASSEMBLY_R8_M6_0/A44_CAP_CORE128_M6_R1_0/CAP_BOTTOM_015 VDD pfet_03v3 ad=0 pd=0 as=0 ps=0 w=1.56u l=0.28u
X698 VREFP A44_DCTRL_STRIP_W_R2_0/CTRL_OUT[6] A44_CDAC_CAP_BANK_ASSEMBLY_R8_M6_0/A44_CAP_CORE128_M6_R1_0/CAP_BOTTOM_015 VDD pfet_03v3 ad=0 pd=0 as=0 ps=0 w=1.56u l=0.28u
X699 VREFP A44_DCTRL_STRIP_W_R2_0/CTRL_OUT[6] A44_CDAC_CAP_BANK_ASSEMBLY_R8_M6_0/A44_CAP_CORE128_M6_R1_0/CAP_BOTTOM_015 VDD pfet_03v3 ad=0 pd=0 as=0 ps=0 w=1.56u l=0.28u
X700 VREFP A44_DCTRL_STRIP_W_R2_0/CTRL_OUT[6] A44_CDAC_CAP_BANK_ASSEMBLY_R8_M6_0/A44_CAP_CORE128_M6_R1_0/CAP_BOTTOM_015 VDD pfet_03v3 ad=0 pd=0 as=0 ps=0 w=1.56u l=0.28u
X701 VREFP A44_DCTRL_STRIP_W_R2_0/CTRL_OUT[6] A44_CDAC_CAP_BANK_ASSEMBLY_R8_M6_0/A44_CAP_CORE128_M6_R1_0/CAP_BOTTOM_015 VDD pfet_03v3 ad=0 pd=0 as=0 ps=0 w=1.56u l=0.28u
X702 VREFP A44_DCTRL_STRIP_W_R2_0/CTRL_OUT[6] A44_CDAC_CAP_BANK_ASSEMBLY_R8_M6_0/A44_CAP_CORE128_M6_R1_0/CAP_BOTTOM_015 VDD pfet_03v3 ad=0 pd=0 as=0 ps=0 w=1.56u l=0.28u
X703 VREFP A44_DCTRL_STRIP_W_R2_0/CTRL_OUT[6] A44_CDAC_CAP_BANK_ASSEMBLY_R8_M6_0/A44_CAP_CORE128_M6_R1_0/CAP_BOTTOM_015 VDD pfet_03v3 ad=0 pd=0 as=0 ps=0 w=1.56u l=0.28u
X704 VREFN A44_DCTRL_STRIP_W_R2_0/CTRL_OUT[6] A44_CDAC_CAP_BANK_ASSEMBLY_R8_M6_0/A44_CAP_CORE128_M6_R1_0/CAP_BOTTOM_015 GND nfet_03v3 ad=0 pd=0 as=16.6842p ps=77.76u w=1.56u l=0.28u
X705 VREFN A44_DCTRL_STRIP_W_R2_0/CTRL_OUT[6] A44_CDAC_CAP_BANK_ASSEMBLY_R8_M6_0/A44_CAP_CORE128_M6_R1_0/CAP_BOTTOM_015 GND nfet_03v3 ad=0 pd=0 as=0 ps=0 w=1.56u l=0.28u
X706 VREFN A44_DCTRL_STRIP_W_R2_0/CTRL_OUT[6] A44_CDAC_CAP_BANK_ASSEMBLY_R8_M6_0/A44_CAP_CORE128_M6_R1_0/CAP_BOTTOM_015 GND nfet_03v3 ad=0 pd=0 as=0 ps=0 w=1.56u l=0.28u
X707 VREFN A44_DCTRL_STRIP_W_R2_0/CTRL_OUT[6] A44_CDAC_CAP_BANK_ASSEMBLY_R8_M6_0/A44_CAP_CORE128_M6_R1_0/CAP_BOTTOM_015 GND nfet_03v3 ad=0 pd=0 as=0 ps=0 w=1.56u l=0.28u
X708 VREFN A44_DCTRL_STRIP_W_R2_0/CTRL_OUT[6] A44_CDAC_CAP_BANK_ASSEMBLY_R8_M6_0/A44_CAP_CORE128_M6_R1_0/CAP_BOTTOM_015 GND nfet_03v3 ad=0 pd=0 as=0 ps=0 w=1.56u l=0.28u
X709 VREFN A44_DCTRL_STRIP_W_R2_0/CTRL_OUT[6] A44_CDAC_CAP_BANK_ASSEMBLY_R8_M6_0/A44_CAP_CORE128_M6_R1_0/CAP_BOTTOM_015 GND nfet_03v3 ad=0 pd=0 as=0 ps=0 w=1.56u l=0.28u
X710 VREFN A44_DCTRL_STRIP_W_R2_0/CTRL_OUT[6] A44_CDAC_CAP_BANK_ASSEMBLY_R8_M6_0/A44_CAP_CORE128_M6_R1_0/CAP_BOTTOM_015 GND nfet_03v3 ad=0 pd=0 as=0 ps=0 w=1.56u l=0.28u
X711 VREFN A44_DCTRL_STRIP_W_R2_0/CTRL_OUT[6] A44_CDAC_CAP_BANK_ASSEMBLY_R8_M6_0/A44_CAP_CORE128_M6_R1_0/CAP_BOTTOM_015 GND nfet_03v3 ad=0 pd=0 as=0 ps=0 w=1.56u l=0.28u
X712 VREFN A44_DCTRL_STRIP_W_R2_0/CTRL_OUT[6] A44_CDAC_CAP_BANK_ASSEMBLY_R8_M6_0/A44_CAP_CORE128_M6_R1_0/CAP_BOTTOM_015 GND nfet_03v3 ad=0 pd=0 as=0 ps=0 w=1.56u l=0.28u
X713 VREFN A44_DCTRL_STRIP_W_R2_0/CTRL_OUT[6] A44_CDAC_CAP_BANK_ASSEMBLY_R8_M6_0/A44_CAP_CORE128_M6_R1_0/CAP_BOTTOM_015 GND nfet_03v3 ad=0 pd=0 as=0 ps=0 w=1.56u l=0.28u
X714 VREFN A44_DCTRL_STRIP_W_R2_0/CTRL_OUT[6] A44_CDAC_CAP_BANK_ASSEMBLY_R8_M6_0/A44_CAP_CORE128_M6_R1_0/CAP_BOTTOM_015 GND nfet_03v3 ad=0 pd=0 as=0 ps=0 w=1.56u l=0.28u
X715 VREFN A44_DCTRL_STRIP_W_R2_0/CTRL_OUT[6] A44_CDAC_CAP_BANK_ASSEMBLY_R8_M6_0/A44_CAP_CORE128_M6_R1_0/CAP_BOTTOM_015 GND nfet_03v3 ad=0 pd=0 as=0 ps=0 w=1.56u l=0.28u
X716 VREFN A44_DCTRL_STRIP_W_R2_0/CTRL_OUT[6] A44_CDAC_CAP_BANK_ASSEMBLY_R8_M6_0/A44_CAP_CORE128_M6_R1_0/CAP_BOTTOM_015 GND nfet_03v3 ad=0 pd=0 as=0 ps=0 w=1.56u l=0.28u
X717 VREFN A44_DCTRL_STRIP_W_R2_0/CTRL_OUT[6] A44_CDAC_CAP_BANK_ASSEMBLY_R8_M6_0/A44_CAP_CORE128_M6_R1_0/CAP_BOTTOM_015 GND nfet_03v3 ad=0 pd=0 as=0 ps=0 w=1.56u l=0.28u
X718 VREFN A44_DCTRL_STRIP_W_R2_0/CTRL_OUT[6] A44_CDAC_CAP_BANK_ASSEMBLY_R8_M6_0/A44_CAP_CORE128_M6_R1_0/CAP_BOTTOM_015 GND nfet_03v3 ad=0 pd=0 as=0 ps=0 w=1.56u l=0.28u
X719 VREFN A44_DCTRL_STRIP_W_R2_0/CTRL_OUT[6] A44_CDAC_CAP_BANK_ASSEMBLY_R8_M6_0/A44_CAP_CORE128_M6_R1_0/CAP_BOTTOM_015 GND nfet_03v3 ad=0 pd=0 as=0 ps=0 w=1.56u l=0.28u
X720 VREFN A44_DCTRL_STRIP_W_R2_0/CTRL_OUT[6] A44_CDAC_CAP_BANK_ASSEMBLY_R8_M6_0/A44_CAP_CORE128_M6_R1_0/CAP_BOTTOM_015 GND nfet_03v3 ad=0 pd=0 as=0 ps=0 w=1.56u l=0.28u
X721 VREFN A44_DCTRL_STRIP_W_R2_0/CTRL_OUT[6] A44_CDAC_CAP_BANK_ASSEMBLY_R8_M6_0/A44_CAP_CORE128_M6_R1_0/CAP_BOTTOM_015 GND nfet_03v3 ad=0 pd=0 as=0 ps=0 w=1.56u l=0.28u
X722 VREFP A44_DCTRL_STRIP_W_R2_0/CTRL_OUT[6] A44_CDAC_CAP_BANK_ASSEMBLY_R8_M6_0/A44_CAP_CORE128_M6_R1_0/CAP_BOTTOM_042 VDD pfet_03v3 ad=0 pd=0 as=16.6842p ps=77.76u w=1.56u l=0.28u
X723 VREFP A44_DCTRL_STRIP_W_R2_0/CTRL_OUT[6] A44_CDAC_CAP_BANK_ASSEMBLY_R8_M6_0/A44_CAP_CORE128_M6_R1_0/CAP_BOTTOM_042 VDD pfet_03v3 ad=0 pd=0 as=0 ps=0 w=1.56u l=0.28u
X724 VREFP A44_DCTRL_STRIP_W_R2_0/CTRL_OUT[6] A44_CDAC_CAP_BANK_ASSEMBLY_R8_M6_0/A44_CAP_CORE128_M6_R1_0/CAP_BOTTOM_042 VDD pfet_03v3 ad=0 pd=0 as=0 ps=0 w=1.56u l=0.28u
X725 VREFP A44_DCTRL_STRIP_W_R2_0/CTRL_OUT[6] A44_CDAC_CAP_BANK_ASSEMBLY_R8_M6_0/A44_CAP_CORE128_M6_R1_0/CAP_BOTTOM_042 VDD pfet_03v3 ad=0 pd=0 as=0 ps=0 w=1.56u l=0.28u
X726 VREFP A44_DCTRL_STRIP_W_R2_0/CTRL_OUT[6] A44_CDAC_CAP_BANK_ASSEMBLY_R8_M6_0/A44_CAP_CORE128_M6_R1_0/CAP_BOTTOM_042 VDD pfet_03v3 ad=0 pd=0 as=0 ps=0 w=1.56u l=0.28u
X727 VREFP A44_DCTRL_STRIP_W_R2_0/CTRL_OUT[6] A44_CDAC_CAP_BANK_ASSEMBLY_R8_M6_0/A44_CAP_CORE128_M6_R1_0/CAP_BOTTOM_042 VDD pfet_03v3 ad=0 pd=0 as=0 ps=0 w=1.56u l=0.28u
X728 VREFP A44_DCTRL_STRIP_W_R2_0/CTRL_OUT[6] A44_CDAC_CAP_BANK_ASSEMBLY_R8_M6_0/A44_CAP_CORE128_M6_R1_0/CAP_BOTTOM_042 VDD pfet_03v3 ad=0 pd=0 as=0 ps=0 w=1.56u l=0.28u
X729 VREFP A44_DCTRL_STRIP_W_R2_0/CTRL_OUT[6] A44_CDAC_CAP_BANK_ASSEMBLY_R8_M6_0/A44_CAP_CORE128_M6_R1_0/CAP_BOTTOM_042 VDD pfet_03v3 ad=0 pd=0 as=0 ps=0 w=1.56u l=0.28u
X730 VREFP A44_DCTRL_STRIP_W_R2_0/CTRL_OUT[6] A44_CDAC_CAP_BANK_ASSEMBLY_R8_M6_0/A44_CAP_CORE128_M6_R1_0/CAP_BOTTOM_042 VDD pfet_03v3 ad=0 pd=0 as=0 ps=0 w=1.56u l=0.28u
X731 VREFP A44_DCTRL_STRIP_W_R2_0/CTRL_OUT[6] A44_CDAC_CAP_BANK_ASSEMBLY_R8_M6_0/A44_CAP_CORE128_M6_R1_0/CAP_BOTTOM_042 VDD pfet_03v3 ad=0 pd=0 as=0 ps=0 w=1.56u l=0.28u
X732 VREFP A44_DCTRL_STRIP_W_R2_0/CTRL_OUT[6] A44_CDAC_CAP_BANK_ASSEMBLY_R8_M6_0/A44_CAP_CORE128_M6_R1_0/CAP_BOTTOM_042 VDD pfet_03v3 ad=0 pd=0 as=0 ps=0 w=1.56u l=0.28u
X733 VREFP A44_DCTRL_STRIP_W_R2_0/CTRL_OUT[6] A44_CDAC_CAP_BANK_ASSEMBLY_R8_M6_0/A44_CAP_CORE128_M6_R1_0/CAP_BOTTOM_042 VDD pfet_03v3 ad=0 pd=0 as=0 ps=0 w=1.56u l=0.28u
X734 VREFP A44_DCTRL_STRIP_W_R2_0/CTRL_OUT[6] A44_CDAC_CAP_BANK_ASSEMBLY_R8_M6_0/A44_CAP_CORE128_M6_R1_0/CAP_BOTTOM_042 VDD pfet_03v3 ad=0 pd=0 as=0 ps=0 w=1.56u l=0.28u
X735 VREFP A44_DCTRL_STRIP_W_R2_0/CTRL_OUT[6] A44_CDAC_CAP_BANK_ASSEMBLY_R8_M6_0/A44_CAP_CORE128_M6_R1_0/CAP_BOTTOM_042 VDD pfet_03v3 ad=0 pd=0 as=0 ps=0 w=1.56u l=0.28u
X736 VREFP A44_DCTRL_STRIP_W_R2_0/CTRL_OUT[6] A44_CDAC_CAP_BANK_ASSEMBLY_R8_M6_0/A44_CAP_CORE128_M6_R1_0/CAP_BOTTOM_042 VDD pfet_03v3 ad=0 pd=0 as=0 ps=0 w=1.56u l=0.28u
X737 VREFP A44_DCTRL_STRIP_W_R2_0/CTRL_OUT[6] A44_CDAC_CAP_BANK_ASSEMBLY_R8_M6_0/A44_CAP_CORE128_M6_R1_0/CAP_BOTTOM_042 VDD pfet_03v3 ad=0 pd=0 as=0 ps=0 w=1.56u l=0.28u
X738 VREFP A44_DCTRL_STRIP_W_R2_0/CTRL_OUT[6] A44_CDAC_CAP_BANK_ASSEMBLY_R8_M6_0/A44_CAP_CORE128_M6_R1_0/CAP_BOTTOM_042 VDD pfet_03v3 ad=0 pd=0 as=0 ps=0 w=1.56u l=0.28u
X739 VREFP A44_DCTRL_STRIP_W_R2_0/CTRL_OUT[6] A44_CDAC_CAP_BANK_ASSEMBLY_R8_M6_0/A44_CAP_CORE128_M6_R1_0/CAP_BOTTOM_042 VDD pfet_03v3 ad=0 pd=0 as=0 ps=0 w=1.56u l=0.28u
X740 VREFN A44_DCTRL_STRIP_W_R2_0/CTRL_OUT[6] A44_CDAC_CAP_BANK_ASSEMBLY_R8_M6_0/A44_CAP_CORE128_M6_R1_0/CAP_BOTTOM_042 GND nfet_03v3 ad=0 pd=0 as=16.6842p ps=77.76u w=1.56u l=0.28u
X741 VREFN A44_DCTRL_STRIP_W_R2_0/CTRL_OUT[6] A44_CDAC_CAP_BANK_ASSEMBLY_R8_M6_0/A44_CAP_CORE128_M6_R1_0/CAP_BOTTOM_042 GND nfet_03v3 ad=0 pd=0 as=0 ps=0 w=1.56u l=0.28u
X742 VREFN A44_DCTRL_STRIP_W_R2_0/CTRL_OUT[6] A44_CDAC_CAP_BANK_ASSEMBLY_R8_M6_0/A44_CAP_CORE128_M6_R1_0/CAP_BOTTOM_042 GND nfet_03v3 ad=0 pd=0 as=0 ps=0 w=1.56u l=0.28u
X743 VREFN A44_DCTRL_STRIP_W_R2_0/CTRL_OUT[6] A44_CDAC_CAP_BANK_ASSEMBLY_R8_M6_0/A44_CAP_CORE128_M6_R1_0/CAP_BOTTOM_042 GND nfet_03v3 ad=0 pd=0 as=0 ps=0 w=1.56u l=0.28u
X744 VREFN A44_DCTRL_STRIP_W_R2_0/CTRL_OUT[6] A44_CDAC_CAP_BANK_ASSEMBLY_R8_M6_0/A44_CAP_CORE128_M6_R1_0/CAP_BOTTOM_042 GND nfet_03v3 ad=0 pd=0 as=0 ps=0 w=1.56u l=0.28u
X745 VREFN A44_DCTRL_STRIP_W_R2_0/CTRL_OUT[6] A44_CDAC_CAP_BANK_ASSEMBLY_R8_M6_0/A44_CAP_CORE128_M6_R1_0/CAP_BOTTOM_042 GND nfet_03v3 ad=0 pd=0 as=0 ps=0 w=1.56u l=0.28u
X746 VREFN A44_DCTRL_STRIP_W_R2_0/CTRL_OUT[6] A44_CDAC_CAP_BANK_ASSEMBLY_R8_M6_0/A44_CAP_CORE128_M6_R1_0/CAP_BOTTOM_042 GND nfet_03v3 ad=0 pd=0 as=0 ps=0 w=1.56u l=0.28u
X747 VREFN A44_DCTRL_STRIP_W_R2_0/CTRL_OUT[6] A44_CDAC_CAP_BANK_ASSEMBLY_R8_M6_0/A44_CAP_CORE128_M6_R1_0/CAP_BOTTOM_042 GND nfet_03v3 ad=0 pd=0 as=0 ps=0 w=1.56u l=0.28u
X748 VREFN A44_DCTRL_STRIP_W_R2_0/CTRL_OUT[6] A44_CDAC_CAP_BANK_ASSEMBLY_R8_M6_0/A44_CAP_CORE128_M6_R1_0/CAP_BOTTOM_042 GND nfet_03v3 ad=0 pd=0 as=0 ps=0 w=1.56u l=0.28u
X749 VREFN A44_DCTRL_STRIP_W_R2_0/CTRL_OUT[6] A44_CDAC_CAP_BANK_ASSEMBLY_R8_M6_0/A44_CAP_CORE128_M6_R1_0/CAP_BOTTOM_042 GND nfet_03v3 ad=0 pd=0 as=0 ps=0 w=1.56u l=0.28u
X750 VREFN A44_DCTRL_STRIP_W_R2_0/CTRL_OUT[6] A44_CDAC_CAP_BANK_ASSEMBLY_R8_M6_0/A44_CAP_CORE128_M6_R1_0/CAP_BOTTOM_042 GND nfet_03v3 ad=0 pd=0 as=0 ps=0 w=1.56u l=0.28u
X751 VREFN A44_DCTRL_STRIP_W_R2_0/CTRL_OUT[6] A44_CDAC_CAP_BANK_ASSEMBLY_R8_M6_0/A44_CAP_CORE128_M6_R1_0/CAP_BOTTOM_042 GND nfet_03v3 ad=0 pd=0 as=0 ps=0 w=1.56u l=0.28u
X752 VREFN A44_DCTRL_STRIP_W_R2_0/CTRL_OUT[6] A44_CDAC_CAP_BANK_ASSEMBLY_R8_M6_0/A44_CAP_CORE128_M6_R1_0/CAP_BOTTOM_042 GND nfet_03v3 ad=0 pd=0 as=0 ps=0 w=1.56u l=0.28u
X753 VREFN A44_DCTRL_STRIP_W_R2_0/CTRL_OUT[6] A44_CDAC_CAP_BANK_ASSEMBLY_R8_M6_0/A44_CAP_CORE128_M6_R1_0/CAP_BOTTOM_042 GND nfet_03v3 ad=0 pd=0 as=0 ps=0 w=1.56u l=0.28u
X754 VREFN A44_DCTRL_STRIP_W_R2_0/CTRL_OUT[6] A44_CDAC_CAP_BANK_ASSEMBLY_R8_M6_0/A44_CAP_CORE128_M6_R1_0/CAP_BOTTOM_042 GND nfet_03v3 ad=0 pd=0 as=0 ps=0 w=1.56u l=0.28u
X755 VREFN A44_DCTRL_STRIP_W_R2_0/CTRL_OUT[6] A44_CDAC_CAP_BANK_ASSEMBLY_R8_M6_0/A44_CAP_CORE128_M6_R1_0/CAP_BOTTOM_042 GND nfet_03v3 ad=0 pd=0 as=0 ps=0 w=1.56u l=0.28u
X756 VREFN A44_DCTRL_STRIP_W_R2_0/CTRL_OUT[6] A44_CDAC_CAP_BANK_ASSEMBLY_R8_M6_0/A44_CAP_CORE128_M6_R1_0/CAP_BOTTOM_042 GND nfet_03v3 ad=0 pd=0 as=0 ps=0 w=1.56u l=0.28u
X757 VREFN A44_DCTRL_STRIP_W_R2_0/CTRL_OUT[6] A44_CDAC_CAP_BANK_ASSEMBLY_R8_M6_0/A44_CAP_CORE128_M6_R1_0/CAP_BOTTOM_042 GND nfet_03v3 ad=0 pd=0 as=0 ps=0 w=1.56u l=0.28u
X758 VREFP A44_DCTRL_STRIP_W_R2_0/CTRL_OUT[4] A44_CDAC_CAP_BANK_ASSEMBLY_R8_M6_0/A44_CAP_CORE128_M6_R1_0/CAP_BOTTOM_005 VDD pfet_03v3 ad=0 pd=0 as=16.6842p ps=77.76u w=1.56u l=0.28u
X759 VREFP A44_DCTRL_STRIP_W_R2_0/CTRL_OUT[4] A44_CDAC_CAP_BANK_ASSEMBLY_R8_M6_0/A44_CAP_CORE128_M6_R1_0/CAP_BOTTOM_005 VDD pfet_03v3 ad=0 pd=0 as=0 ps=0 w=1.56u l=0.28u
X760 VREFP A44_DCTRL_STRIP_W_R2_0/CTRL_OUT[4] A44_CDAC_CAP_BANK_ASSEMBLY_R8_M6_0/A44_CAP_CORE128_M6_R1_0/CAP_BOTTOM_005 VDD pfet_03v3 ad=0 pd=0 as=0 ps=0 w=1.56u l=0.28u
X761 VREFP A44_DCTRL_STRIP_W_R2_0/CTRL_OUT[4] A44_CDAC_CAP_BANK_ASSEMBLY_R8_M6_0/A44_CAP_CORE128_M6_R1_0/CAP_BOTTOM_005 VDD pfet_03v3 ad=0 pd=0 as=0 ps=0 w=1.56u l=0.28u
X762 VREFP A44_DCTRL_STRIP_W_R2_0/CTRL_OUT[4] A44_CDAC_CAP_BANK_ASSEMBLY_R8_M6_0/A44_CAP_CORE128_M6_R1_0/CAP_BOTTOM_005 VDD pfet_03v3 ad=0 pd=0 as=0 ps=0 w=1.56u l=0.28u
X763 VREFP A44_DCTRL_STRIP_W_R2_0/CTRL_OUT[4] A44_CDAC_CAP_BANK_ASSEMBLY_R8_M6_0/A44_CAP_CORE128_M6_R1_0/CAP_BOTTOM_005 VDD pfet_03v3 ad=0 pd=0 as=0 ps=0 w=1.56u l=0.28u
X764 VREFP A44_DCTRL_STRIP_W_R2_0/CTRL_OUT[4] A44_CDAC_CAP_BANK_ASSEMBLY_R8_M6_0/A44_CAP_CORE128_M6_R1_0/CAP_BOTTOM_005 VDD pfet_03v3 ad=0 pd=0 as=0 ps=0 w=1.56u l=0.28u
X765 VREFP A44_DCTRL_STRIP_W_R2_0/CTRL_OUT[4] A44_CDAC_CAP_BANK_ASSEMBLY_R8_M6_0/A44_CAP_CORE128_M6_R1_0/CAP_BOTTOM_005 VDD pfet_03v3 ad=0 pd=0 as=0 ps=0 w=1.56u l=0.28u
X766 VREFP A44_DCTRL_STRIP_W_R2_0/CTRL_OUT[4] A44_CDAC_CAP_BANK_ASSEMBLY_R8_M6_0/A44_CAP_CORE128_M6_R1_0/CAP_BOTTOM_005 VDD pfet_03v3 ad=0 pd=0 as=0 ps=0 w=1.56u l=0.28u
X767 VREFP A44_DCTRL_STRIP_W_R2_0/CTRL_OUT[4] A44_CDAC_CAP_BANK_ASSEMBLY_R8_M6_0/A44_CAP_CORE128_M6_R1_0/CAP_BOTTOM_005 VDD pfet_03v3 ad=0 pd=0 as=0 ps=0 w=1.56u l=0.28u
X768 VREFP A44_DCTRL_STRIP_W_R2_0/CTRL_OUT[4] A44_CDAC_CAP_BANK_ASSEMBLY_R8_M6_0/A44_CAP_CORE128_M6_R1_0/CAP_BOTTOM_005 VDD pfet_03v3 ad=0 pd=0 as=0 ps=0 w=1.56u l=0.28u
X769 VREFP A44_DCTRL_STRIP_W_R2_0/CTRL_OUT[4] A44_CDAC_CAP_BANK_ASSEMBLY_R8_M6_0/A44_CAP_CORE128_M6_R1_0/CAP_BOTTOM_005 VDD pfet_03v3 ad=0 pd=0 as=0 ps=0 w=1.56u l=0.28u
X770 VREFP A44_DCTRL_STRIP_W_R2_0/CTRL_OUT[4] A44_CDAC_CAP_BANK_ASSEMBLY_R8_M6_0/A44_CAP_CORE128_M6_R1_0/CAP_BOTTOM_005 VDD pfet_03v3 ad=0 pd=0 as=0 ps=0 w=1.56u l=0.28u
X771 VREFP A44_DCTRL_STRIP_W_R2_0/CTRL_OUT[4] A44_CDAC_CAP_BANK_ASSEMBLY_R8_M6_0/A44_CAP_CORE128_M6_R1_0/CAP_BOTTOM_005 VDD pfet_03v3 ad=0 pd=0 as=0 ps=0 w=1.56u l=0.28u
X772 VREFP A44_DCTRL_STRIP_W_R2_0/CTRL_OUT[4] A44_CDAC_CAP_BANK_ASSEMBLY_R8_M6_0/A44_CAP_CORE128_M6_R1_0/CAP_BOTTOM_005 VDD pfet_03v3 ad=0 pd=0 as=0 ps=0 w=1.56u l=0.28u
X773 VREFP A44_DCTRL_STRIP_W_R2_0/CTRL_OUT[4] A44_CDAC_CAP_BANK_ASSEMBLY_R8_M6_0/A44_CAP_CORE128_M6_R1_0/CAP_BOTTOM_005 VDD pfet_03v3 ad=0 pd=0 as=0 ps=0 w=1.56u l=0.28u
X774 VREFP A44_DCTRL_STRIP_W_R2_0/CTRL_OUT[4] A44_CDAC_CAP_BANK_ASSEMBLY_R8_M6_0/A44_CAP_CORE128_M6_R1_0/CAP_BOTTOM_005 VDD pfet_03v3 ad=0 pd=0 as=0 ps=0 w=1.56u l=0.28u
X775 VREFP A44_DCTRL_STRIP_W_R2_0/CTRL_OUT[4] A44_CDAC_CAP_BANK_ASSEMBLY_R8_M6_0/A44_CAP_CORE128_M6_R1_0/CAP_BOTTOM_005 VDD pfet_03v3 ad=0 pd=0 as=0 ps=0 w=1.56u l=0.28u
X776 VREFN A44_DCTRL_STRIP_W_R2_0/CTRL_OUT[4] A44_CDAC_CAP_BANK_ASSEMBLY_R8_M6_0/A44_CAP_CORE128_M6_R1_0/CAP_BOTTOM_005 GND nfet_03v3 ad=0 pd=0 as=16.6842p ps=77.76u w=1.56u l=0.28u
X777 VREFN A44_DCTRL_STRIP_W_R2_0/CTRL_OUT[4] A44_CDAC_CAP_BANK_ASSEMBLY_R8_M6_0/A44_CAP_CORE128_M6_R1_0/CAP_BOTTOM_005 GND nfet_03v3 ad=0 pd=0 as=0 ps=0 w=1.56u l=0.28u
X778 VREFN A44_DCTRL_STRIP_W_R2_0/CTRL_OUT[4] A44_CDAC_CAP_BANK_ASSEMBLY_R8_M6_0/A44_CAP_CORE128_M6_R1_0/CAP_BOTTOM_005 GND nfet_03v3 ad=0 pd=0 as=0 ps=0 w=1.56u l=0.28u
X779 VREFN A44_DCTRL_STRIP_W_R2_0/CTRL_OUT[4] A44_CDAC_CAP_BANK_ASSEMBLY_R8_M6_0/A44_CAP_CORE128_M6_R1_0/CAP_BOTTOM_005 GND nfet_03v3 ad=0 pd=0 as=0 ps=0 w=1.56u l=0.28u
X780 VREFN A44_DCTRL_STRIP_W_R2_0/CTRL_OUT[4] A44_CDAC_CAP_BANK_ASSEMBLY_R8_M6_0/A44_CAP_CORE128_M6_R1_0/CAP_BOTTOM_005 GND nfet_03v3 ad=0 pd=0 as=0 ps=0 w=1.56u l=0.28u
X781 VREFN A44_DCTRL_STRIP_W_R2_0/CTRL_OUT[4] A44_CDAC_CAP_BANK_ASSEMBLY_R8_M6_0/A44_CAP_CORE128_M6_R1_0/CAP_BOTTOM_005 GND nfet_03v3 ad=0 pd=0 as=0 ps=0 w=1.56u l=0.28u
X782 VREFN A44_DCTRL_STRIP_W_R2_0/CTRL_OUT[4] A44_CDAC_CAP_BANK_ASSEMBLY_R8_M6_0/A44_CAP_CORE128_M6_R1_0/CAP_BOTTOM_005 GND nfet_03v3 ad=0 pd=0 as=0 ps=0 w=1.56u l=0.28u
X783 VREFN A44_DCTRL_STRIP_W_R2_0/CTRL_OUT[4] A44_CDAC_CAP_BANK_ASSEMBLY_R8_M6_0/A44_CAP_CORE128_M6_R1_0/CAP_BOTTOM_005 GND nfet_03v3 ad=0 pd=0 as=0 ps=0 w=1.56u l=0.28u
X784 VREFN A44_DCTRL_STRIP_W_R2_0/CTRL_OUT[4] A44_CDAC_CAP_BANK_ASSEMBLY_R8_M6_0/A44_CAP_CORE128_M6_R1_0/CAP_BOTTOM_005 GND nfet_03v3 ad=0 pd=0 as=0 ps=0 w=1.56u l=0.28u
X785 VREFN A44_DCTRL_STRIP_W_R2_0/CTRL_OUT[4] A44_CDAC_CAP_BANK_ASSEMBLY_R8_M6_0/A44_CAP_CORE128_M6_R1_0/CAP_BOTTOM_005 GND nfet_03v3 ad=0 pd=0 as=0 ps=0 w=1.56u l=0.28u
X786 VREFN A44_DCTRL_STRIP_W_R2_0/CTRL_OUT[4] A44_CDAC_CAP_BANK_ASSEMBLY_R8_M6_0/A44_CAP_CORE128_M6_R1_0/CAP_BOTTOM_005 GND nfet_03v3 ad=0 pd=0 as=0 ps=0 w=1.56u l=0.28u
X787 VREFN A44_DCTRL_STRIP_W_R2_0/CTRL_OUT[4] A44_CDAC_CAP_BANK_ASSEMBLY_R8_M6_0/A44_CAP_CORE128_M6_R1_0/CAP_BOTTOM_005 GND nfet_03v3 ad=0 pd=0 as=0 ps=0 w=1.56u l=0.28u
X788 VREFN A44_DCTRL_STRIP_W_R2_0/CTRL_OUT[4] A44_CDAC_CAP_BANK_ASSEMBLY_R8_M6_0/A44_CAP_CORE128_M6_R1_0/CAP_BOTTOM_005 GND nfet_03v3 ad=0 pd=0 as=0 ps=0 w=1.56u l=0.28u
X789 VREFN A44_DCTRL_STRIP_W_R2_0/CTRL_OUT[4] A44_CDAC_CAP_BANK_ASSEMBLY_R8_M6_0/A44_CAP_CORE128_M6_R1_0/CAP_BOTTOM_005 GND nfet_03v3 ad=0 pd=0 as=0 ps=0 w=1.56u l=0.28u
X790 VREFN A44_DCTRL_STRIP_W_R2_0/CTRL_OUT[4] A44_CDAC_CAP_BANK_ASSEMBLY_R8_M6_0/A44_CAP_CORE128_M6_R1_0/CAP_BOTTOM_005 GND nfet_03v3 ad=0 pd=0 as=0 ps=0 w=1.56u l=0.28u
X791 VREFN A44_DCTRL_STRIP_W_R2_0/CTRL_OUT[4] A44_CDAC_CAP_BANK_ASSEMBLY_R8_M6_0/A44_CAP_CORE128_M6_R1_0/CAP_BOTTOM_005 GND nfet_03v3 ad=0 pd=0 as=0 ps=0 w=1.56u l=0.28u
X792 VREFN A44_DCTRL_STRIP_W_R2_0/CTRL_OUT[4] A44_CDAC_CAP_BANK_ASSEMBLY_R8_M6_0/A44_CAP_CORE128_M6_R1_0/CAP_BOTTOM_005 GND nfet_03v3 ad=0 pd=0 as=0 ps=0 w=1.56u l=0.28u
X793 VREFN A44_DCTRL_STRIP_W_R2_0/CTRL_OUT[4] A44_CDAC_CAP_BANK_ASSEMBLY_R8_M6_0/A44_CAP_CORE128_M6_R1_0/CAP_BOTTOM_005 GND nfet_03v3 ad=0 pd=0 as=0 ps=0 w=1.56u l=0.28u
X794 VREFP A44_DCTRL_STRIP_W_R2_0/CTRL_OUT[7] A44_CDAC_CAP_BANK_ASSEMBLY_R8_M6_0/A44_CAP_CORE128_M6_R1_0/CAP_BOTTOM_029 VDD pfet_03v3 ad=0 pd=0 as=16.6842p ps=77.76u w=1.56u l=0.28u
X795 VREFP A44_DCTRL_STRIP_W_R2_0/CTRL_OUT[7] A44_CDAC_CAP_BANK_ASSEMBLY_R8_M6_0/A44_CAP_CORE128_M6_R1_0/CAP_BOTTOM_029 VDD pfet_03v3 ad=0 pd=0 as=0 ps=0 w=1.56u l=0.28u
X796 VREFP A44_DCTRL_STRIP_W_R2_0/CTRL_OUT[7] A44_CDAC_CAP_BANK_ASSEMBLY_R8_M6_0/A44_CAP_CORE128_M6_R1_0/CAP_BOTTOM_029 VDD pfet_03v3 ad=0 pd=0 as=0 ps=0 w=1.56u l=0.28u
X797 VREFP A44_DCTRL_STRIP_W_R2_0/CTRL_OUT[7] A44_CDAC_CAP_BANK_ASSEMBLY_R8_M6_0/A44_CAP_CORE128_M6_R1_0/CAP_BOTTOM_029 VDD pfet_03v3 ad=0 pd=0 as=0 ps=0 w=1.56u l=0.28u
X798 VREFP A44_DCTRL_STRIP_W_R2_0/CTRL_OUT[7] A44_CDAC_CAP_BANK_ASSEMBLY_R8_M6_0/A44_CAP_CORE128_M6_R1_0/CAP_BOTTOM_029 VDD pfet_03v3 ad=0 pd=0 as=0 ps=0 w=1.56u l=0.28u
X799 VREFP A44_DCTRL_STRIP_W_R2_0/CTRL_OUT[7] A44_CDAC_CAP_BANK_ASSEMBLY_R8_M6_0/A44_CAP_CORE128_M6_R1_0/CAP_BOTTOM_029 VDD pfet_03v3 ad=0 pd=0 as=0 ps=0 w=1.56u l=0.28u
X800 VREFP A44_DCTRL_STRIP_W_R2_0/CTRL_OUT[7] A44_CDAC_CAP_BANK_ASSEMBLY_R8_M6_0/A44_CAP_CORE128_M6_R1_0/CAP_BOTTOM_029 VDD pfet_03v3 ad=0 pd=0 as=0 ps=0 w=1.56u l=0.28u
X801 VREFP A44_DCTRL_STRIP_W_R2_0/CTRL_OUT[7] A44_CDAC_CAP_BANK_ASSEMBLY_R8_M6_0/A44_CAP_CORE128_M6_R1_0/CAP_BOTTOM_029 VDD pfet_03v3 ad=0 pd=0 as=0 ps=0 w=1.56u l=0.28u
X802 VREFP A44_DCTRL_STRIP_W_R2_0/CTRL_OUT[7] A44_CDAC_CAP_BANK_ASSEMBLY_R8_M6_0/A44_CAP_CORE128_M6_R1_0/CAP_BOTTOM_029 VDD pfet_03v3 ad=0 pd=0 as=0 ps=0 w=1.56u l=0.28u
X803 VREFP A44_DCTRL_STRIP_W_R2_0/CTRL_OUT[7] A44_CDAC_CAP_BANK_ASSEMBLY_R8_M6_0/A44_CAP_CORE128_M6_R1_0/CAP_BOTTOM_029 VDD pfet_03v3 ad=0 pd=0 as=0 ps=0 w=1.56u l=0.28u
X804 VREFP A44_DCTRL_STRIP_W_R2_0/CTRL_OUT[7] A44_CDAC_CAP_BANK_ASSEMBLY_R8_M6_0/A44_CAP_CORE128_M6_R1_0/CAP_BOTTOM_029 VDD pfet_03v3 ad=0 pd=0 as=0 ps=0 w=1.56u l=0.28u
X805 VREFP A44_DCTRL_STRIP_W_R2_0/CTRL_OUT[7] A44_CDAC_CAP_BANK_ASSEMBLY_R8_M6_0/A44_CAP_CORE128_M6_R1_0/CAP_BOTTOM_029 VDD pfet_03v3 ad=0 pd=0 as=0 ps=0 w=1.56u l=0.28u
X806 VREFP A44_DCTRL_STRIP_W_R2_0/CTRL_OUT[7] A44_CDAC_CAP_BANK_ASSEMBLY_R8_M6_0/A44_CAP_CORE128_M6_R1_0/CAP_BOTTOM_029 VDD pfet_03v3 ad=0 pd=0 as=0 ps=0 w=1.56u l=0.28u
X807 VREFP A44_DCTRL_STRIP_W_R2_0/CTRL_OUT[7] A44_CDAC_CAP_BANK_ASSEMBLY_R8_M6_0/A44_CAP_CORE128_M6_R1_0/CAP_BOTTOM_029 VDD pfet_03v3 ad=0 pd=0 as=0 ps=0 w=1.56u l=0.28u
X808 VREFP A44_DCTRL_STRIP_W_R2_0/CTRL_OUT[7] A44_CDAC_CAP_BANK_ASSEMBLY_R8_M6_0/A44_CAP_CORE128_M6_R1_0/CAP_BOTTOM_029 VDD pfet_03v3 ad=0 pd=0 as=0 ps=0 w=1.56u l=0.28u
X809 VREFP A44_DCTRL_STRIP_W_R2_0/CTRL_OUT[7] A44_CDAC_CAP_BANK_ASSEMBLY_R8_M6_0/A44_CAP_CORE128_M6_R1_0/CAP_BOTTOM_029 VDD pfet_03v3 ad=0 pd=0 as=0 ps=0 w=1.56u l=0.28u
X810 VREFP A44_DCTRL_STRIP_W_R2_0/CTRL_OUT[7] A44_CDAC_CAP_BANK_ASSEMBLY_R8_M6_0/A44_CAP_CORE128_M6_R1_0/CAP_BOTTOM_029 VDD pfet_03v3 ad=0 pd=0 as=0 ps=0 w=1.56u l=0.28u
X811 VREFP A44_DCTRL_STRIP_W_R2_0/CTRL_OUT[7] A44_CDAC_CAP_BANK_ASSEMBLY_R8_M6_0/A44_CAP_CORE128_M6_R1_0/CAP_BOTTOM_029 VDD pfet_03v3 ad=0 pd=0 as=0 ps=0 w=1.56u l=0.28u
X812 VREFN A44_DCTRL_STRIP_W_R2_0/CTRL_OUT[7] A44_CDAC_CAP_BANK_ASSEMBLY_R8_M6_0/A44_CAP_CORE128_M6_R1_0/CAP_BOTTOM_029 GND nfet_03v3 ad=0 pd=0 as=16.6842p ps=77.76u w=1.56u l=0.28u
X813 VREFN A44_DCTRL_STRIP_W_R2_0/CTRL_OUT[7] A44_CDAC_CAP_BANK_ASSEMBLY_R8_M6_0/A44_CAP_CORE128_M6_R1_0/CAP_BOTTOM_029 GND nfet_03v3 ad=0 pd=0 as=0 ps=0 w=1.56u l=0.28u
X814 VREFN A44_DCTRL_STRIP_W_R2_0/CTRL_OUT[7] A44_CDAC_CAP_BANK_ASSEMBLY_R8_M6_0/A44_CAP_CORE128_M6_R1_0/CAP_BOTTOM_029 GND nfet_03v3 ad=0 pd=0 as=0 ps=0 w=1.56u l=0.28u
X815 VREFN A44_DCTRL_STRIP_W_R2_0/CTRL_OUT[7] A44_CDAC_CAP_BANK_ASSEMBLY_R8_M6_0/A44_CAP_CORE128_M6_R1_0/CAP_BOTTOM_029 GND nfet_03v3 ad=0 pd=0 as=0 ps=0 w=1.56u l=0.28u
X816 VREFN A44_DCTRL_STRIP_W_R2_0/CTRL_OUT[7] A44_CDAC_CAP_BANK_ASSEMBLY_R8_M6_0/A44_CAP_CORE128_M6_R1_0/CAP_BOTTOM_029 GND nfet_03v3 ad=0 pd=0 as=0 ps=0 w=1.56u l=0.28u
X817 VREFN A44_DCTRL_STRIP_W_R2_0/CTRL_OUT[7] A44_CDAC_CAP_BANK_ASSEMBLY_R8_M6_0/A44_CAP_CORE128_M6_R1_0/CAP_BOTTOM_029 GND nfet_03v3 ad=0 pd=0 as=0 ps=0 w=1.56u l=0.28u
X818 VREFN A44_DCTRL_STRIP_W_R2_0/CTRL_OUT[7] A44_CDAC_CAP_BANK_ASSEMBLY_R8_M6_0/A44_CAP_CORE128_M6_R1_0/CAP_BOTTOM_029 GND nfet_03v3 ad=0 pd=0 as=0 ps=0 w=1.56u l=0.28u
X819 VREFN A44_DCTRL_STRIP_W_R2_0/CTRL_OUT[7] A44_CDAC_CAP_BANK_ASSEMBLY_R8_M6_0/A44_CAP_CORE128_M6_R1_0/CAP_BOTTOM_029 GND nfet_03v3 ad=0 pd=0 as=0 ps=0 w=1.56u l=0.28u
X820 VREFN A44_DCTRL_STRIP_W_R2_0/CTRL_OUT[7] A44_CDAC_CAP_BANK_ASSEMBLY_R8_M6_0/A44_CAP_CORE128_M6_R1_0/CAP_BOTTOM_029 GND nfet_03v3 ad=0 pd=0 as=0 ps=0 w=1.56u l=0.28u
X821 VREFN A44_DCTRL_STRIP_W_R2_0/CTRL_OUT[7] A44_CDAC_CAP_BANK_ASSEMBLY_R8_M6_0/A44_CAP_CORE128_M6_R1_0/CAP_BOTTOM_029 GND nfet_03v3 ad=0 pd=0 as=0 ps=0 w=1.56u l=0.28u
X822 VREFN A44_DCTRL_STRIP_W_R2_0/CTRL_OUT[7] A44_CDAC_CAP_BANK_ASSEMBLY_R8_M6_0/A44_CAP_CORE128_M6_R1_0/CAP_BOTTOM_029 GND nfet_03v3 ad=0 pd=0 as=0 ps=0 w=1.56u l=0.28u
X823 VREFN A44_DCTRL_STRIP_W_R2_0/CTRL_OUT[7] A44_CDAC_CAP_BANK_ASSEMBLY_R8_M6_0/A44_CAP_CORE128_M6_R1_0/CAP_BOTTOM_029 GND nfet_03v3 ad=0 pd=0 as=0 ps=0 w=1.56u l=0.28u
X824 VREFN A44_DCTRL_STRIP_W_R2_0/CTRL_OUT[7] A44_CDAC_CAP_BANK_ASSEMBLY_R8_M6_0/A44_CAP_CORE128_M6_R1_0/CAP_BOTTOM_029 GND nfet_03v3 ad=0 pd=0 as=0 ps=0 w=1.56u l=0.28u
X825 VREFN A44_DCTRL_STRIP_W_R2_0/CTRL_OUT[7] A44_CDAC_CAP_BANK_ASSEMBLY_R8_M6_0/A44_CAP_CORE128_M6_R1_0/CAP_BOTTOM_029 GND nfet_03v3 ad=0 pd=0 as=0 ps=0 w=1.56u l=0.28u
X826 VREFN A44_DCTRL_STRIP_W_R2_0/CTRL_OUT[7] A44_CDAC_CAP_BANK_ASSEMBLY_R8_M6_0/A44_CAP_CORE128_M6_R1_0/CAP_BOTTOM_029 GND nfet_03v3 ad=0 pd=0 as=0 ps=0 w=1.56u l=0.28u
X827 VREFN A44_DCTRL_STRIP_W_R2_0/CTRL_OUT[7] A44_CDAC_CAP_BANK_ASSEMBLY_R8_M6_0/A44_CAP_CORE128_M6_R1_0/CAP_BOTTOM_029 GND nfet_03v3 ad=0 pd=0 as=0 ps=0 w=1.56u l=0.28u
X828 VREFN A44_DCTRL_STRIP_W_R2_0/CTRL_OUT[7] A44_CDAC_CAP_BANK_ASSEMBLY_R8_M6_0/A44_CAP_CORE128_M6_R1_0/CAP_BOTTOM_029 GND nfet_03v3 ad=0 pd=0 as=0 ps=0 w=1.56u l=0.28u
X829 VREFN A44_DCTRL_STRIP_W_R2_0/CTRL_OUT[7] A44_CDAC_CAP_BANK_ASSEMBLY_R8_M6_0/A44_CAP_CORE128_M6_R1_0/CAP_BOTTOM_029 GND nfet_03v3 ad=0 pd=0 as=0 ps=0 w=1.56u l=0.28u
X830 VREFP A44_DCTRL_STRIP_W_R2_0/CTRL_OUT[1] A44_CDAC_CAP_BANK_ASSEMBLY_R8_M6_0/A44_CAP_CORE128_M6_R1_0/CAP_BOTTOM_055 VDD pfet_03v3 ad=0 pd=0 as=16.6842p ps=77.76u w=1.56u l=0.28u
X831 VREFP A44_DCTRL_STRIP_W_R2_0/CTRL_OUT[1] A44_CDAC_CAP_BANK_ASSEMBLY_R8_M6_0/A44_CAP_CORE128_M6_R1_0/CAP_BOTTOM_055 VDD pfet_03v3 ad=0 pd=0 as=0 ps=0 w=1.56u l=0.28u
X832 VREFP A44_DCTRL_STRIP_W_R2_0/CTRL_OUT[1] A44_CDAC_CAP_BANK_ASSEMBLY_R8_M6_0/A44_CAP_CORE128_M6_R1_0/CAP_BOTTOM_055 VDD pfet_03v3 ad=0 pd=0 as=0 ps=0 w=1.56u l=0.28u
X833 VREFP A44_DCTRL_STRIP_W_R2_0/CTRL_OUT[1] A44_CDAC_CAP_BANK_ASSEMBLY_R8_M6_0/A44_CAP_CORE128_M6_R1_0/CAP_BOTTOM_055 VDD pfet_03v3 ad=0 pd=0 as=0 ps=0 w=1.56u l=0.28u
X834 VREFP A44_DCTRL_STRIP_W_R2_0/CTRL_OUT[1] A44_CDAC_CAP_BANK_ASSEMBLY_R8_M6_0/A44_CAP_CORE128_M6_R1_0/CAP_BOTTOM_055 VDD pfet_03v3 ad=0 pd=0 as=0 ps=0 w=1.56u l=0.28u
X835 VREFP A44_DCTRL_STRIP_W_R2_0/CTRL_OUT[1] A44_CDAC_CAP_BANK_ASSEMBLY_R8_M6_0/A44_CAP_CORE128_M6_R1_0/CAP_BOTTOM_055 VDD pfet_03v3 ad=0 pd=0 as=0 ps=0 w=1.56u l=0.28u
X836 VREFP A44_DCTRL_STRIP_W_R2_0/CTRL_OUT[1] A44_CDAC_CAP_BANK_ASSEMBLY_R8_M6_0/A44_CAP_CORE128_M6_R1_0/CAP_BOTTOM_055 VDD pfet_03v3 ad=0 pd=0 as=0 ps=0 w=1.56u l=0.28u
X837 VREFP A44_DCTRL_STRIP_W_R2_0/CTRL_OUT[1] A44_CDAC_CAP_BANK_ASSEMBLY_R8_M6_0/A44_CAP_CORE128_M6_R1_0/CAP_BOTTOM_055 VDD pfet_03v3 ad=0 pd=0 as=0 ps=0 w=1.56u l=0.28u
X838 VREFP A44_DCTRL_STRIP_W_R2_0/CTRL_OUT[1] A44_CDAC_CAP_BANK_ASSEMBLY_R8_M6_0/A44_CAP_CORE128_M6_R1_0/CAP_BOTTOM_055 VDD pfet_03v3 ad=0 pd=0 as=0 ps=0 w=1.56u l=0.28u
X839 VREFP A44_DCTRL_STRIP_W_R2_0/CTRL_OUT[1] A44_CDAC_CAP_BANK_ASSEMBLY_R8_M6_0/A44_CAP_CORE128_M6_R1_0/CAP_BOTTOM_055 VDD pfet_03v3 ad=0 pd=0 as=0 ps=0 w=1.56u l=0.28u
X840 VREFP A44_DCTRL_STRIP_W_R2_0/CTRL_OUT[1] A44_CDAC_CAP_BANK_ASSEMBLY_R8_M6_0/A44_CAP_CORE128_M6_R1_0/CAP_BOTTOM_055 VDD pfet_03v3 ad=0 pd=0 as=0 ps=0 w=1.56u l=0.28u
X841 VREFP A44_DCTRL_STRIP_W_R2_0/CTRL_OUT[1] A44_CDAC_CAP_BANK_ASSEMBLY_R8_M6_0/A44_CAP_CORE128_M6_R1_0/CAP_BOTTOM_055 VDD pfet_03v3 ad=0 pd=0 as=0 ps=0 w=1.56u l=0.28u
X842 VREFP A44_DCTRL_STRIP_W_R2_0/CTRL_OUT[1] A44_CDAC_CAP_BANK_ASSEMBLY_R8_M6_0/A44_CAP_CORE128_M6_R1_0/CAP_BOTTOM_055 VDD pfet_03v3 ad=0 pd=0 as=0 ps=0 w=1.56u l=0.28u
X843 VREFP A44_DCTRL_STRIP_W_R2_0/CTRL_OUT[1] A44_CDAC_CAP_BANK_ASSEMBLY_R8_M6_0/A44_CAP_CORE128_M6_R1_0/CAP_BOTTOM_055 VDD pfet_03v3 ad=0 pd=0 as=0 ps=0 w=1.56u l=0.28u
X844 VREFP A44_DCTRL_STRIP_W_R2_0/CTRL_OUT[1] A44_CDAC_CAP_BANK_ASSEMBLY_R8_M6_0/A44_CAP_CORE128_M6_R1_0/CAP_BOTTOM_055 VDD pfet_03v3 ad=0 pd=0 as=0 ps=0 w=1.56u l=0.28u
X845 VREFP A44_DCTRL_STRIP_W_R2_0/CTRL_OUT[1] A44_CDAC_CAP_BANK_ASSEMBLY_R8_M6_0/A44_CAP_CORE128_M6_R1_0/CAP_BOTTOM_055 VDD pfet_03v3 ad=0 pd=0 as=0 ps=0 w=1.56u l=0.28u
X846 VREFP A44_DCTRL_STRIP_W_R2_0/CTRL_OUT[1] A44_CDAC_CAP_BANK_ASSEMBLY_R8_M6_0/A44_CAP_CORE128_M6_R1_0/CAP_BOTTOM_055 VDD pfet_03v3 ad=0 pd=0 as=0 ps=0 w=1.56u l=0.28u
X847 VREFP A44_DCTRL_STRIP_W_R2_0/CTRL_OUT[1] A44_CDAC_CAP_BANK_ASSEMBLY_R8_M6_0/A44_CAP_CORE128_M6_R1_0/CAP_BOTTOM_055 VDD pfet_03v3 ad=0 pd=0 as=0 ps=0 w=1.56u l=0.28u
X848 VREFN A44_DCTRL_STRIP_W_R2_0/CTRL_OUT[1] A44_CDAC_CAP_BANK_ASSEMBLY_R8_M6_0/A44_CAP_CORE128_M6_R1_0/CAP_BOTTOM_055 GND nfet_03v3 ad=0 pd=0 as=16.6842p ps=77.76u w=1.56u l=0.28u
X849 VREFN A44_DCTRL_STRIP_W_R2_0/CTRL_OUT[1] A44_CDAC_CAP_BANK_ASSEMBLY_R8_M6_0/A44_CAP_CORE128_M6_R1_0/CAP_BOTTOM_055 GND nfet_03v3 ad=0 pd=0 as=0 ps=0 w=1.56u l=0.28u
X850 VREFN A44_DCTRL_STRIP_W_R2_0/CTRL_OUT[1] A44_CDAC_CAP_BANK_ASSEMBLY_R8_M6_0/A44_CAP_CORE128_M6_R1_0/CAP_BOTTOM_055 GND nfet_03v3 ad=0 pd=0 as=0 ps=0 w=1.56u l=0.28u
X851 VREFN A44_DCTRL_STRIP_W_R2_0/CTRL_OUT[1] A44_CDAC_CAP_BANK_ASSEMBLY_R8_M6_0/A44_CAP_CORE128_M6_R1_0/CAP_BOTTOM_055 GND nfet_03v3 ad=0 pd=0 as=0 ps=0 w=1.56u l=0.28u
X852 VREFN A44_DCTRL_STRIP_W_R2_0/CTRL_OUT[1] A44_CDAC_CAP_BANK_ASSEMBLY_R8_M6_0/A44_CAP_CORE128_M6_R1_0/CAP_BOTTOM_055 GND nfet_03v3 ad=0 pd=0 as=0 ps=0 w=1.56u l=0.28u
X853 VREFN A44_DCTRL_STRIP_W_R2_0/CTRL_OUT[1] A44_CDAC_CAP_BANK_ASSEMBLY_R8_M6_0/A44_CAP_CORE128_M6_R1_0/CAP_BOTTOM_055 GND nfet_03v3 ad=0 pd=0 as=0 ps=0 w=1.56u l=0.28u
X854 VREFN A44_DCTRL_STRIP_W_R2_0/CTRL_OUT[1] A44_CDAC_CAP_BANK_ASSEMBLY_R8_M6_0/A44_CAP_CORE128_M6_R1_0/CAP_BOTTOM_055 GND nfet_03v3 ad=0 pd=0 as=0 ps=0 w=1.56u l=0.28u
X855 VREFN A44_DCTRL_STRIP_W_R2_0/CTRL_OUT[1] A44_CDAC_CAP_BANK_ASSEMBLY_R8_M6_0/A44_CAP_CORE128_M6_R1_0/CAP_BOTTOM_055 GND nfet_03v3 ad=0 pd=0 as=0 ps=0 w=1.56u l=0.28u
X856 VREFN A44_DCTRL_STRIP_W_R2_0/CTRL_OUT[1] A44_CDAC_CAP_BANK_ASSEMBLY_R8_M6_0/A44_CAP_CORE128_M6_R1_0/CAP_BOTTOM_055 GND nfet_03v3 ad=0 pd=0 as=0 ps=0 w=1.56u l=0.28u
X857 VREFN A44_DCTRL_STRIP_W_R2_0/CTRL_OUT[1] A44_CDAC_CAP_BANK_ASSEMBLY_R8_M6_0/A44_CAP_CORE128_M6_R1_0/CAP_BOTTOM_055 GND nfet_03v3 ad=0 pd=0 as=0 ps=0 w=1.56u l=0.28u
X858 VREFN A44_DCTRL_STRIP_W_R2_0/CTRL_OUT[1] A44_CDAC_CAP_BANK_ASSEMBLY_R8_M6_0/A44_CAP_CORE128_M6_R1_0/CAP_BOTTOM_055 GND nfet_03v3 ad=0 pd=0 as=0 ps=0 w=1.56u l=0.28u
X859 VREFN A44_DCTRL_STRIP_W_R2_0/CTRL_OUT[1] A44_CDAC_CAP_BANK_ASSEMBLY_R8_M6_0/A44_CAP_CORE128_M6_R1_0/CAP_BOTTOM_055 GND nfet_03v3 ad=0 pd=0 as=0 ps=0 w=1.56u l=0.28u
X860 VREFN A44_DCTRL_STRIP_W_R2_0/CTRL_OUT[1] A44_CDAC_CAP_BANK_ASSEMBLY_R8_M6_0/A44_CAP_CORE128_M6_R1_0/CAP_BOTTOM_055 GND nfet_03v3 ad=0 pd=0 as=0 ps=0 w=1.56u l=0.28u
X861 VREFN A44_DCTRL_STRIP_W_R2_0/CTRL_OUT[1] A44_CDAC_CAP_BANK_ASSEMBLY_R8_M6_0/A44_CAP_CORE128_M6_R1_0/CAP_BOTTOM_055 GND nfet_03v3 ad=0 pd=0 as=0 ps=0 w=1.56u l=0.28u
X862 VREFN A44_DCTRL_STRIP_W_R2_0/CTRL_OUT[1] A44_CDAC_CAP_BANK_ASSEMBLY_R8_M6_0/A44_CAP_CORE128_M6_R1_0/CAP_BOTTOM_055 GND nfet_03v3 ad=0 pd=0 as=0 ps=0 w=1.56u l=0.28u
X863 VREFN A44_DCTRL_STRIP_W_R2_0/CTRL_OUT[1] A44_CDAC_CAP_BANK_ASSEMBLY_R8_M6_0/A44_CAP_CORE128_M6_R1_0/CAP_BOTTOM_055 GND nfet_03v3 ad=0 pd=0 as=0 ps=0 w=1.56u l=0.28u
X864 VREFN A44_DCTRL_STRIP_W_R2_0/CTRL_OUT[1] A44_CDAC_CAP_BANK_ASSEMBLY_R8_M6_0/A44_CAP_CORE128_M6_R1_0/CAP_BOTTOM_055 GND nfet_03v3 ad=0 pd=0 as=0 ps=0 w=1.56u l=0.28u
X865 VREFN A44_DCTRL_STRIP_W_R2_0/CTRL_OUT[1] A44_CDAC_CAP_BANK_ASSEMBLY_R8_M6_0/A44_CAP_CORE128_M6_R1_0/CAP_BOTTOM_055 GND nfet_03v3 ad=0 pd=0 as=0 ps=0 w=1.56u l=0.28u
X866 VREFP A44_DCTRL_STRIP_W_R2_0/CTRL_OUT[5] A44_CDAC_CAP_BANK_ASSEMBLY_R8_M6_0/A44_CAP_CORE128_M6_R1_0/CAP_BOTTOM_018 VDD pfet_03v3 ad=0 pd=0 as=16.6842p ps=77.76u w=1.56u l=0.28u
X867 VREFP A44_DCTRL_STRIP_W_R2_0/CTRL_OUT[5] A44_CDAC_CAP_BANK_ASSEMBLY_R8_M6_0/A44_CAP_CORE128_M6_R1_0/CAP_BOTTOM_018 VDD pfet_03v3 ad=0 pd=0 as=0 ps=0 w=1.56u l=0.28u
X868 VREFP A44_DCTRL_STRIP_W_R2_0/CTRL_OUT[5] A44_CDAC_CAP_BANK_ASSEMBLY_R8_M6_0/A44_CAP_CORE128_M6_R1_0/CAP_BOTTOM_018 VDD pfet_03v3 ad=0 pd=0 as=0 ps=0 w=1.56u l=0.28u
X869 VREFP A44_DCTRL_STRIP_W_R2_0/CTRL_OUT[5] A44_CDAC_CAP_BANK_ASSEMBLY_R8_M6_0/A44_CAP_CORE128_M6_R1_0/CAP_BOTTOM_018 VDD pfet_03v3 ad=0 pd=0 as=0 ps=0 w=1.56u l=0.28u
X870 VREFP A44_DCTRL_STRIP_W_R2_0/CTRL_OUT[5] A44_CDAC_CAP_BANK_ASSEMBLY_R8_M6_0/A44_CAP_CORE128_M6_R1_0/CAP_BOTTOM_018 VDD pfet_03v3 ad=0 pd=0 as=0 ps=0 w=1.56u l=0.28u
X871 VREFP A44_DCTRL_STRIP_W_R2_0/CTRL_OUT[5] A44_CDAC_CAP_BANK_ASSEMBLY_R8_M6_0/A44_CAP_CORE128_M6_R1_0/CAP_BOTTOM_018 VDD pfet_03v3 ad=0 pd=0 as=0 ps=0 w=1.56u l=0.28u
X872 VREFP A44_DCTRL_STRIP_W_R2_0/CTRL_OUT[5] A44_CDAC_CAP_BANK_ASSEMBLY_R8_M6_0/A44_CAP_CORE128_M6_R1_0/CAP_BOTTOM_018 VDD pfet_03v3 ad=0 pd=0 as=0 ps=0 w=1.56u l=0.28u
X873 VREFP A44_DCTRL_STRIP_W_R2_0/CTRL_OUT[5] A44_CDAC_CAP_BANK_ASSEMBLY_R8_M6_0/A44_CAP_CORE128_M6_R1_0/CAP_BOTTOM_018 VDD pfet_03v3 ad=0 pd=0 as=0 ps=0 w=1.56u l=0.28u
X874 VREFP A44_DCTRL_STRIP_W_R2_0/CTRL_OUT[5] A44_CDAC_CAP_BANK_ASSEMBLY_R8_M6_0/A44_CAP_CORE128_M6_R1_0/CAP_BOTTOM_018 VDD pfet_03v3 ad=0 pd=0 as=0 ps=0 w=1.56u l=0.28u
X875 VREFP A44_DCTRL_STRIP_W_R2_0/CTRL_OUT[5] A44_CDAC_CAP_BANK_ASSEMBLY_R8_M6_0/A44_CAP_CORE128_M6_R1_0/CAP_BOTTOM_018 VDD pfet_03v3 ad=0 pd=0 as=0 ps=0 w=1.56u l=0.28u
X876 VREFP A44_DCTRL_STRIP_W_R2_0/CTRL_OUT[5] A44_CDAC_CAP_BANK_ASSEMBLY_R8_M6_0/A44_CAP_CORE128_M6_R1_0/CAP_BOTTOM_018 VDD pfet_03v3 ad=0 pd=0 as=0 ps=0 w=1.56u l=0.28u
X877 VREFP A44_DCTRL_STRIP_W_R2_0/CTRL_OUT[5] A44_CDAC_CAP_BANK_ASSEMBLY_R8_M6_0/A44_CAP_CORE128_M6_R1_0/CAP_BOTTOM_018 VDD pfet_03v3 ad=0 pd=0 as=0 ps=0 w=1.56u l=0.28u
X878 VREFP A44_DCTRL_STRIP_W_R2_0/CTRL_OUT[5] A44_CDAC_CAP_BANK_ASSEMBLY_R8_M6_0/A44_CAP_CORE128_M6_R1_0/CAP_BOTTOM_018 VDD pfet_03v3 ad=0 pd=0 as=0 ps=0 w=1.56u l=0.28u
X879 VREFP A44_DCTRL_STRIP_W_R2_0/CTRL_OUT[5] A44_CDAC_CAP_BANK_ASSEMBLY_R8_M6_0/A44_CAP_CORE128_M6_R1_0/CAP_BOTTOM_018 VDD pfet_03v3 ad=0 pd=0 as=0 ps=0 w=1.56u l=0.28u
X880 VREFP A44_DCTRL_STRIP_W_R2_0/CTRL_OUT[5] A44_CDAC_CAP_BANK_ASSEMBLY_R8_M6_0/A44_CAP_CORE128_M6_R1_0/CAP_BOTTOM_018 VDD pfet_03v3 ad=0 pd=0 as=0 ps=0 w=1.56u l=0.28u
X881 VREFP A44_DCTRL_STRIP_W_R2_0/CTRL_OUT[5] A44_CDAC_CAP_BANK_ASSEMBLY_R8_M6_0/A44_CAP_CORE128_M6_R1_0/CAP_BOTTOM_018 VDD pfet_03v3 ad=0 pd=0 as=0 ps=0 w=1.56u l=0.28u
X882 VREFP A44_DCTRL_STRIP_W_R2_0/CTRL_OUT[5] A44_CDAC_CAP_BANK_ASSEMBLY_R8_M6_0/A44_CAP_CORE128_M6_R1_0/CAP_BOTTOM_018 VDD pfet_03v3 ad=0 pd=0 as=0 ps=0 w=1.56u l=0.28u
X883 VREFP A44_DCTRL_STRIP_W_R2_0/CTRL_OUT[5] A44_CDAC_CAP_BANK_ASSEMBLY_R8_M6_0/A44_CAP_CORE128_M6_R1_0/CAP_BOTTOM_018 VDD pfet_03v3 ad=0 pd=0 as=0 ps=0 w=1.56u l=0.28u
X884 VREFN A44_DCTRL_STRIP_W_R2_0/CTRL_OUT[5] A44_CDAC_CAP_BANK_ASSEMBLY_R8_M6_0/A44_CAP_CORE128_M6_R1_0/CAP_BOTTOM_018 GND nfet_03v3 ad=0 pd=0 as=16.6842p ps=77.76u w=1.56u l=0.28u
X885 VREFN A44_DCTRL_STRIP_W_R2_0/CTRL_OUT[5] A44_CDAC_CAP_BANK_ASSEMBLY_R8_M6_0/A44_CAP_CORE128_M6_R1_0/CAP_BOTTOM_018 GND nfet_03v3 ad=0 pd=0 as=0 ps=0 w=1.56u l=0.28u
X886 VREFN A44_DCTRL_STRIP_W_R2_0/CTRL_OUT[5] A44_CDAC_CAP_BANK_ASSEMBLY_R8_M6_0/A44_CAP_CORE128_M6_R1_0/CAP_BOTTOM_018 GND nfet_03v3 ad=0 pd=0 as=0 ps=0 w=1.56u l=0.28u
X887 VREFN A44_DCTRL_STRIP_W_R2_0/CTRL_OUT[5] A44_CDAC_CAP_BANK_ASSEMBLY_R8_M6_0/A44_CAP_CORE128_M6_R1_0/CAP_BOTTOM_018 GND nfet_03v3 ad=0 pd=0 as=0 ps=0 w=1.56u l=0.28u
X888 VREFN A44_DCTRL_STRIP_W_R2_0/CTRL_OUT[5] A44_CDAC_CAP_BANK_ASSEMBLY_R8_M6_0/A44_CAP_CORE128_M6_R1_0/CAP_BOTTOM_018 GND nfet_03v3 ad=0 pd=0 as=0 ps=0 w=1.56u l=0.28u
X889 VREFN A44_DCTRL_STRIP_W_R2_0/CTRL_OUT[5] A44_CDAC_CAP_BANK_ASSEMBLY_R8_M6_0/A44_CAP_CORE128_M6_R1_0/CAP_BOTTOM_018 GND nfet_03v3 ad=0 pd=0 as=0 ps=0 w=1.56u l=0.28u
X890 VREFN A44_DCTRL_STRIP_W_R2_0/CTRL_OUT[5] A44_CDAC_CAP_BANK_ASSEMBLY_R8_M6_0/A44_CAP_CORE128_M6_R1_0/CAP_BOTTOM_018 GND nfet_03v3 ad=0 pd=0 as=0 ps=0 w=1.56u l=0.28u
X891 VREFN A44_DCTRL_STRIP_W_R2_0/CTRL_OUT[5] A44_CDAC_CAP_BANK_ASSEMBLY_R8_M6_0/A44_CAP_CORE128_M6_R1_0/CAP_BOTTOM_018 GND nfet_03v3 ad=0 pd=0 as=0 ps=0 w=1.56u l=0.28u
X892 VREFN A44_DCTRL_STRIP_W_R2_0/CTRL_OUT[5] A44_CDAC_CAP_BANK_ASSEMBLY_R8_M6_0/A44_CAP_CORE128_M6_R1_0/CAP_BOTTOM_018 GND nfet_03v3 ad=0 pd=0 as=0 ps=0 w=1.56u l=0.28u
X893 VREFN A44_DCTRL_STRIP_W_R2_0/CTRL_OUT[5] A44_CDAC_CAP_BANK_ASSEMBLY_R8_M6_0/A44_CAP_CORE128_M6_R1_0/CAP_BOTTOM_018 GND nfet_03v3 ad=0 pd=0 as=0 ps=0 w=1.56u l=0.28u
X894 VREFN A44_DCTRL_STRIP_W_R2_0/CTRL_OUT[5] A44_CDAC_CAP_BANK_ASSEMBLY_R8_M6_0/A44_CAP_CORE128_M6_R1_0/CAP_BOTTOM_018 GND nfet_03v3 ad=0 pd=0 as=0 ps=0 w=1.56u l=0.28u
X895 VREFN A44_DCTRL_STRIP_W_R2_0/CTRL_OUT[5] A44_CDAC_CAP_BANK_ASSEMBLY_R8_M6_0/A44_CAP_CORE128_M6_R1_0/CAP_BOTTOM_018 GND nfet_03v3 ad=0 pd=0 as=0 ps=0 w=1.56u l=0.28u
X896 VREFN A44_DCTRL_STRIP_W_R2_0/CTRL_OUT[5] A44_CDAC_CAP_BANK_ASSEMBLY_R8_M6_0/A44_CAP_CORE128_M6_R1_0/CAP_BOTTOM_018 GND nfet_03v3 ad=0 pd=0 as=0 ps=0 w=1.56u l=0.28u
X897 VREFN A44_DCTRL_STRIP_W_R2_0/CTRL_OUT[5] A44_CDAC_CAP_BANK_ASSEMBLY_R8_M6_0/A44_CAP_CORE128_M6_R1_0/CAP_BOTTOM_018 GND nfet_03v3 ad=0 pd=0 as=0 ps=0 w=1.56u l=0.28u
X898 VREFN A44_DCTRL_STRIP_W_R2_0/CTRL_OUT[5] A44_CDAC_CAP_BANK_ASSEMBLY_R8_M6_0/A44_CAP_CORE128_M6_R1_0/CAP_BOTTOM_018 GND nfet_03v3 ad=0 pd=0 as=0 ps=0 w=1.56u l=0.28u
X899 VREFN A44_DCTRL_STRIP_W_R2_0/CTRL_OUT[5] A44_CDAC_CAP_BANK_ASSEMBLY_R8_M6_0/A44_CAP_CORE128_M6_R1_0/CAP_BOTTOM_018 GND nfet_03v3 ad=0 pd=0 as=0 ps=0 w=1.56u l=0.28u
X900 VREFN A44_DCTRL_STRIP_W_R2_0/CTRL_OUT[5] A44_CDAC_CAP_BANK_ASSEMBLY_R8_M6_0/A44_CAP_CORE128_M6_R1_0/CAP_BOTTOM_018 GND nfet_03v3 ad=0 pd=0 as=0 ps=0 w=1.56u l=0.28u
X901 VREFN A44_DCTRL_STRIP_W_R2_0/CTRL_OUT[5] A44_CDAC_CAP_BANK_ASSEMBLY_R8_M6_0/A44_CAP_CORE128_M6_R1_0/CAP_BOTTOM_018 GND nfet_03v3 ad=0 pd=0 as=0 ps=0 w=1.56u l=0.28u
X902 VREFP A44_DCTRL_STRIP_W_R2_0/CTRL_OUT[5] A44_CDAC_CAP_BANK_ASSEMBLY_R8_M6_0/A44_CAP_CORE128_M6_R1_0/CAP_BOTTOM_013 VDD pfet_03v3 ad=0 pd=0 as=16.6842p ps=77.76u w=1.56u l=0.28u
X903 VREFP A44_DCTRL_STRIP_W_R2_0/CTRL_OUT[5] A44_CDAC_CAP_BANK_ASSEMBLY_R8_M6_0/A44_CAP_CORE128_M6_R1_0/CAP_BOTTOM_013 VDD pfet_03v3 ad=0 pd=0 as=0 ps=0 w=1.56u l=0.28u
X904 VREFP A44_DCTRL_STRIP_W_R2_0/CTRL_OUT[5] A44_CDAC_CAP_BANK_ASSEMBLY_R8_M6_0/A44_CAP_CORE128_M6_R1_0/CAP_BOTTOM_013 VDD pfet_03v3 ad=0 pd=0 as=0 ps=0 w=1.56u l=0.28u
X905 VREFP A44_DCTRL_STRIP_W_R2_0/CTRL_OUT[5] A44_CDAC_CAP_BANK_ASSEMBLY_R8_M6_0/A44_CAP_CORE128_M6_R1_0/CAP_BOTTOM_013 VDD pfet_03v3 ad=0 pd=0 as=0 ps=0 w=1.56u l=0.28u
X906 VREFP A44_DCTRL_STRIP_W_R2_0/CTRL_OUT[5] A44_CDAC_CAP_BANK_ASSEMBLY_R8_M6_0/A44_CAP_CORE128_M6_R1_0/CAP_BOTTOM_013 VDD pfet_03v3 ad=0 pd=0 as=0 ps=0 w=1.56u l=0.28u
X907 VREFP A44_DCTRL_STRIP_W_R2_0/CTRL_OUT[5] A44_CDAC_CAP_BANK_ASSEMBLY_R8_M6_0/A44_CAP_CORE128_M6_R1_0/CAP_BOTTOM_013 VDD pfet_03v3 ad=0 pd=0 as=0 ps=0 w=1.56u l=0.28u
X908 VREFP A44_DCTRL_STRIP_W_R2_0/CTRL_OUT[5] A44_CDAC_CAP_BANK_ASSEMBLY_R8_M6_0/A44_CAP_CORE128_M6_R1_0/CAP_BOTTOM_013 VDD pfet_03v3 ad=0 pd=0 as=0 ps=0 w=1.56u l=0.28u
X909 VREFP A44_DCTRL_STRIP_W_R2_0/CTRL_OUT[5] A44_CDAC_CAP_BANK_ASSEMBLY_R8_M6_0/A44_CAP_CORE128_M6_R1_0/CAP_BOTTOM_013 VDD pfet_03v3 ad=0 pd=0 as=0 ps=0 w=1.56u l=0.28u
X910 VREFP A44_DCTRL_STRIP_W_R2_0/CTRL_OUT[5] A44_CDAC_CAP_BANK_ASSEMBLY_R8_M6_0/A44_CAP_CORE128_M6_R1_0/CAP_BOTTOM_013 VDD pfet_03v3 ad=0 pd=0 as=0 ps=0 w=1.56u l=0.28u
X911 VREFP A44_DCTRL_STRIP_W_R2_0/CTRL_OUT[5] A44_CDAC_CAP_BANK_ASSEMBLY_R8_M6_0/A44_CAP_CORE128_M6_R1_0/CAP_BOTTOM_013 VDD pfet_03v3 ad=0 pd=0 as=0 ps=0 w=1.56u l=0.28u
X912 VREFP A44_DCTRL_STRIP_W_R2_0/CTRL_OUT[5] A44_CDAC_CAP_BANK_ASSEMBLY_R8_M6_0/A44_CAP_CORE128_M6_R1_0/CAP_BOTTOM_013 VDD pfet_03v3 ad=0 pd=0 as=0 ps=0 w=1.56u l=0.28u
X913 VREFP A44_DCTRL_STRIP_W_R2_0/CTRL_OUT[5] A44_CDAC_CAP_BANK_ASSEMBLY_R8_M6_0/A44_CAP_CORE128_M6_R1_0/CAP_BOTTOM_013 VDD pfet_03v3 ad=0 pd=0 as=0 ps=0 w=1.56u l=0.28u
X914 VREFP A44_DCTRL_STRIP_W_R2_0/CTRL_OUT[5] A44_CDAC_CAP_BANK_ASSEMBLY_R8_M6_0/A44_CAP_CORE128_M6_R1_0/CAP_BOTTOM_013 VDD pfet_03v3 ad=0 pd=0 as=0 ps=0 w=1.56u l=0.28u
X915 VREFP A44_DCTRL_STRIP_W_R2_0/CTRL_OUT[5] A44_CDAC_CAP_BANK_ASSEMBLY_R8_M6_0/A44_CAP_CORE128_M6_R1_0/CAP_BOTTOM_013 VDD pfet_03v3 ad=0 pd=0 as=0 ps=0 w=1.56u l=0.28u
X916 VREFP A44_DCTRL_STRIP_W_R2_0/CTRL_OUT[5] A44_CDAC_CAP_BANK_ASSEMBLY_R8_M6_0/A44_CAP_CORE128_M6_R1_0/CAP_BOTTOM_013 VDD pfet_03v3 ad=0 pd=0 as=0 ps=0 w=1.56u l=0.28u
X917 VREFP A44_DCTRL_STRIP_W_R2_0/CTRL_OUT[5] A44_CDAC_CAP_BANK_ASSEMBLY_R8_M6_0/A44_CAP_CORE128_M6_R1_0/CAP_BOTTOM_013 VDD pfet_03v3 ad=0 pd=0 as=0 ps=0 w=1.56u l=0.28u
X918 VREFP A44_DCTRL_STRIP_W_R2_0/CTRL_OUT[5] A44_CDAC_CAP_BANK_ASSEMBLY_R8_M6_0/A44_CAP_CORE128_M6_R1_0/CAP_BOTTOM_013 VDD pfet_03v3 ad=0 pd=0 as=0 ps=0 w=1.56u l=0.28u
X919 VREFP A44_DCTRL_STRIP_W_R2_0/CTRL_OUT[5] A44_CDAC_CAP_BANK_ASSEMBLY_R8_M6_0/A44_CAP_CORE128_M6_R1_0/CAP_BOTTOM_013 VDD pfet_03v3 ad=0 pd=0 as=0 ps=0 w=1.56u l=0.28u
X920 VREFN A44_DCTRL_STRIP_W_R2_0/CTRL_OUT[5] A44_CDAC_CAP_BANK_ASSEMBLY_R8_M6_0/A44_CAP_CORE128_M6_R1_0/CAP_BOTTOM_013 GND nfet_03v3 ad=0 pd=0 as=16.6842p ps=77.76u w=1.56u l=0.28u
X921 VREFN A44_DCTRL_STRIP_W_R2_0/CTRL_OUT[5] A44_CDAC_CAP_BANK_ASSEMBLY_R8_M6_0/A44_CAP_CORE128_M6_R1_0/CAP_BOTTOM_013 GND nfet_03v3 ad=0 pd=0 as=0 ps=0 w=1.56u l=0.28u
X922 VREFN A44_DCTRL_STRIP_W_R2_0/CTRL_OUT[5] A44_CDAC_CAP_BANK_ASSEMBLY_R8_M6_0/A44_CAP_CORE128_M6_R1_0/CAP_BOTTOM_013 GND nfet_03v3 ad=0 pd=0 as=0 ps=0 w=1.56u l=0.28u
X923 VREFN A44_DCTRL_STRIP_W_R2_0/CTRL_OUT[5] A44_CDAC_CAP_BANK_ASSEMBLY_R8_M6_0/A44_CAP_CORE128_M6_R1_0/CAP_BOTTOM_013 GND nfet_03v3 ad=0 pd=0 as=0 ps=0 w=1.56u l=0.28u
X924 VREFN A44_DCTRL_STRIP_W_R2_0/CTRL_OUT[5] A44_CDAC_CAP_BANK_ASSEMBLY_R8_M6_0/A44_CAP_CORE128_M6_R1_0/CAP_BOTTOM_013 GND nfet_03v3 ad=0 pd=0 as=0 ps=0 w=1.56u l=0.28u
X925 VREFN A44_DCTRL_STRIP_W_R2_0/CTRL_OUT[5] A44_CDAC_CAP_BANK_ASSEMBLY_R8_M6_0/A44_CAP_CORE128_M6_R1_0/CAP_BOTTOM_013 GND nfet_03v3 ad=0 pd=0 as=0 ps=0 w=1.56u l=0.28u
X926 VREFN A44_DCTRL_STRIP_W_R2_0/CTRL_OUT[5] A44_CDAC_CAP_BANK_ASSEMBLY_R8_M6_0/A44_CAP_CORE128_M6_R1_0/CAP_BOTTOM_013 GND nfet_03v3 ad=0 pd=0 as=0 ps=0 w=1.56u l=0.28u
X927 VREFN A44_DCTRL_STRIP_W_R2_0/CTRL_OUT[5] A44_CDAC_CAP_BANK_ASSEMBLY_R8_M6_0/A44_CAP_CORE128_M6_R1_0/CAP_BOTTOM_013 GND nfet_03v3 ad=0 pd=0 as=0 ps=0 w=1.56u l=0.28u
X928 VREFN A44_DCTRL_STRIP_W_R2_0/CTRL_OUT[5] A44_CDAC_CAP_BANK_ASSEMBLY_R8_M6_0/A44_CAP_CORE128_M6_R1_0/CAP_BOTTOM_013 GND nfet_03v3 ad=0 pd=0 as=0 ps=0 w=1.56u l=0.28u
X929 VREFN A44_DCTRL_STRIP_W_R2_0/CTRL_OUT[5] A44_CDAC_CAP_BANK_ASSEMBLY_R8_M6_0/A44_CAP_CORE128_M6_R1_0/CAP_BOTTOM_013 GND nfet_03v3 ad=0 pd=0 as=0 ps=0 w=1.56u l=0.28u
X930 VREFN A44_DCTRL_STRIP_W_R2_0/CTRL_OUT[5] A44_CDAC_CAP_BANK_ASSEMBLY_R8_M6_0/A44_CAP_CORE128_M6_R1_0/CAP_BOTTOM_013 GND nfet_03v3 ad=0 pd=0 as=0 ps=0 w=1.56u l=0.28u
X931 VREFN A44_DCTRL_STRIP_W_R2_0/CTRL_OUT[5] A44_CDAC_CAP_BANK_ASSEMBLY_R8_M6_0/A44_CAP_CORE128_M6_R1_0/CAP_BOTTOM_013 GND nfet_03v3 ad=0 pd=0 as=0 ps=0 w=1.56u l=0.28u
X932 VREFN A44_DCTRL_STRIP_W_R2_0/CTRL_OUT[5] A44_CDAC_CAP_BANK_ASSEMBLY_R8_M6_0/A44_CAP_CORE128_M6_R1_0/CAP_BOTTOM_013 GND nfet_03v3 ad=0 pd=0 as=0 ps=0 w=1.56u l=0.28u
X933 VREFN A44_DCTRL_STRIP_W_R2_0/CTRL_OUT[5] A44_CDAC_CAP_BANK_ASSEMBLY_R8_M6_0/A44_CAP_CORE128_M6_R1_0/CAP_BOTTOM_013 GND nfet_03v3 ad=0 pd=0 as=0 ps=0 w=1.56u l=0.28u
X934 VREFN A44_DCTRL_STRIP_W_R2_0/CTRL_OUT[5] A44_CDAC_CAP_BANK_ASSEMBLY_R8_M6_0/A44_CAP_CORE128_M6_R1_0/CAP_BOTTOM_013 GND nfet_03v3 ad=0 pd=0 as=0 ps=0 w=1.56u l=0.28u
X935 VREFN A44_DCTRL_STRIP_W_R2_0/CTRL_OUT[5] A44_CDAC_CAP_BANK_ASSEMBLY_R8_M6_0/A44_CAP_CORE128_M6_R1_0/CAP_BOTTOM_013 GND nfet_03v3 ad=0 pd=0 as=0 ps=0 w=1.56u l=0.28u
X936 VREFN A44_DCTRL_STRIP_W_R2_0/CTRL_OUT[5] A44_CDAC_CAP_BANK_ASSEMBLY_R8_M6_0/A44_CAP_CORE128_M6_R1_0/CAP_BOTTOM_013 GND nfet_03v3 ad=0 pd=0 as=0 ps=0 w=1.56u l=0.28u
X937 VREFN A44_DCTRL_STRIP_W_R2_0/CTRL_OUT[5] A44_CDAC_CAP_BANK_ASSEMBLY_R8_M6_0/A44_CAP_CORE128_M6_R1_0/CAP_BOTTOM_013 GND nfet_03v3 ad=0 pd=0 as=0 ps=0 w=1.56u l=0.28u
X938 VREFP A44_DCTRL_STRIP_W_R2_0/CTRL_OUT[7] A44_CDAC_CAP_BANK_ASSEMBLY_R8_M6_0/A44_CAP_CORE128_M6_R1_0/CAP_BOTTOM_039 VDD pfet_03v3 ad=0 pd=0 as=16.6842p ps=77.76u w=1.56u l=0.28u
X939 VREFP A44_DCTRL_STRIP_W_R2_0/CTRL_OUT[7] A44_CDAC_CAP_BANK_ASSEMBLY_R8_M6_0/A44_CAP_CORE128_M6_R1_0/CAP_BOTTOM_039 VDD pfet_03v3 ad=0 pd=0 as=0 ps=0 w=1.56u l=0.28u
X940 VREFP A44_DCTRL_STRIP_W_R2_0/CTRL_OUT[7] A44_CDAC_CAP_BANK_ASSEMBLY_R8_M6_0/A44_CAP_CORE128_M6_R1_0/CAP_BOTTOM_039 VDD pfet_03v3 ad=0 pd=0 as=0 ps=0 w=1.56u l=0.28u
X941 VREFP A44_DCTRL_STRIP_W_R2_0/CTRL_OUT[7] A44_CDAC_CAP_BANK_ASSEMBLY_R8_M6_0/A44_CAP_CORE128_M6_R1_0/CAP_BOTTOM_039 VDD pfet_03v3 ad=0 pd=0 as=0 ps=0 w=1.56u l=0.28u
X942 VREFP A44_DCTRL_STRIP_W_R2_0/CTRL_OUT[7] A44_CDAC_CAP_BANK_ASSEMBLY_R8_M6_0/A44_CAP_CORE128_M6_R1_0/CAP_BOTTOM_039 VDD pfet_03v3 ad=0 pd=0 as=0 ps=0 w=1.56u l=0.28u
X943 VREFP A44_DCTRL_STRIP_W_R2_0/CTRL_OUT[7] A44_CDAC_CAP_BANK_ASSEMBLY_R8_M6_0/A44_CAP_CORE128_M6_R1_0/CAP_BOTTOM_039 VDD pfet_03v3 ad=0 pd=0 as=0 ps=0 w=1.56u l=0.28u
X944 VREFP A44_DCTRL_STRIP_W_R2_0/CTRL_OUT[7] A44_CDAC_CAP_BANK_ASSEMBLY_R8_M6_0/A44_CAP_CORE128_M6_R1_0/CAP_BOTTOM_039 VDD pfet_03v3 ad=0 pd=0 as=0 ps=0 w=1.56u l=0.28u
X945 VREFP A44_DCTRL_STRIP_W_R2_0/CTRL_OUT[7] A44_CDAC_CAP_BANK_ASSEMBLY_R8_M6_0/A44_CAP_CORE128_M6_R1_0/CAP_BOTTOM_039 VDD pfet_03v3 ad=0 pd=0 as=0 ps=0 w=1.56u l=0.28u
X946 VREFP A44_DCTRL_STRIP_W_R2_0/CTRL_OUT[7] A44_CDAC_CAP_BANK_ASSEMBLY_R8_M6_0/A44_CAP_CORE128_M6_R1_0/CAP_BOTTOM_039 VDD pfet_03v3 ad=0 pd=0 as=0 ps=0 w=1.56u l=0.28u
X947 VREFP A44_DCTRL_STRIP_W_R2_0/CTRL_OUT[7] A44_CDAC_CAP_BANK_ASSEMBLY_R8_M6_0/A44_CAP_CORE128_M6_R1_0/CAP_BOTTOM_039 VDD pfet_03v3 ad=0 pd=0 as=0 ps=0 w=1.56u l=0.28u
X948 VREFP A44_DCTRL_STRIP_W_R2_0/CTRL_OUT[7] A44_CDAC_CAP_BANK_ASSEMBLY_R8_M6_0/A44_CAP_CORE128_M6_R1_0/CAP_BOTTOM_039 VDD pfet_03v3 ad=0 pd=0 as=0 ps=0 w=1.56u l=0.28u
X949 VREFP A44_DCTRL_STRIP_W_R2_0/CTRL_OUT[7] A44_CDAC_CAP_BANK_ASSEMBLY_R8_M6_0/A44_CAP_CORE128_M6_R1_0/CAP_BOTTOM_039 VDD pfet_03v3 ad=0 pd=0 as=0 ps=0 w=1.56u l=0.28u
X950 VREFP A44_DCTRL_STRIP_W_R2_0/CTRL_OUT[7] A44_CDAC_CAP_BANK_ASSEMBLY_R8_M6_0/A44_CAP_CORE128_M6_R1_0/CAP_BOTTOM_039 VDD pfet_03v3 ad=0 pd=0 as=0 ps=0 w=1.56u l=0.28u
X951 VREFP A44_DCTRL_STRIP_W_R2_0/CTRL_OUT[7] A44_CDAC_CAP_BANK_ASSEMBLY_R8_M6_0/A44_CAP_CORE128_M6_R1_0/CAP_BOTTOM_039 VDD pfet_03v3 ad=0 pd=0 as=0 ps=0 w=1.56u l=0.28u
X952 VREFP A44_DCTRL_STRIP_W_R2_0/CTRL_OUT[7] A44_CDAC_CAP_BANK_ASSEMBLY_R8_M6_0/A44_CAP_CORE128_M6_R1_0/CAP_BOTTOM_039 VDD pfet_03v3 ad=0 pd=0 as=0 ps=0 w=1.56u l=0.28u
X953 VREFP A44_DCTRL_STRIP_W_R2_0/CTRL_OUT[7] A44_CDAC_CAP_BANK_ASSEMBLY_R8_M6_0/A44_CAP_CORE128_M6_R1_0/CAP_BOTTOM_039 VDD pfet_03v3 ad=0 pd=0 as=0 ps=0 w=1.56u l=0.28u
X954 VREFP A44_DCTRL_STRIP_W_R2_0/CTRL_OUT[7] A44_CDAC_CAP_BANK_ASSEMBLY_R8_M6_0/A44_CAP_CORE128_M6_R1_0/CAP_BOTTOM_039 VDD pfet_03v3 ad=0 pd=0 as=0 ps=0 w=1.56u l=0.28u
X955 VREFP A44_DCTRL_STRIP_W_R2_0/CTRL_OUT[7] A44_CDAC_CAP_BANK_ASSEMBLY_R8_M6_0/A44_CAP_CORE128_M6_R1_0/CAP_BOTTOM_039 VDD pfet_03v3 ad=0 pd=0 as=0 ps=0 w=1.56u l=0.28u
X956 VREFN A44_DCTRL_STRIP_W_R2_0/CTRL_OUT[7] A44_CDAC_CAP_BANK_ASSEMBLY_R8_M6_0/A44_CAP_CORE128_M6_R1_0/CAP_BOTTOM_039 GND nfet_03v3 ad=0 pd=0 as=16.6842p ps=77.76u w=1.56u l=0.28u
X957 VREFN A44_DCTRL_STRIP_W_R2_0/CTRL_OUT[7] A44_CDAC_CAP_BANK_ASSEMBLY_R8_M6_0/A44_CAP_CORE128_M6_R1_0/CAP_BOTTOM_039 GND nfet_03v3 ad=0 pd=0 as=0 ps=0 w=1.56u l=0.28u
X958 VREFN A44_DCTRL_STRIP_W_R2_0/CTRL_OUT[7] A44_CDAC_CAP_BANK_ASSEMBLY_R8_M6_0/A44_CAP_CORE128_M6_R1_0/CAP_BOTTOM_039 GND nfet_03v3 ad=0 pd=0 as=0 ps=0 w=1.56u l=0.28u
X959 VREFN A44_DCTRL_STRIP_W_R2_0/CTRL_OUT[7] A44_CDAC_CAP_BANK_ASSEMBLY_R8_M6_0/A44_CAP_CORE128_M6_R1_0/CAP_BOTTOM_039 GND nfet_03v3 ad=0 pd=0 as=0 ps=0 w=1.56u l=0.28u
X960 VREFN A44_DCTRL_STRIP_W_R2_0/CTRL_OUT[7] A44_CDAC_CAP_BANK_ASSEMBLY_R8_M6_0/A44_CAP_CORE128_M6_R1_0/CAP_BOTTOM_039 GND nfet_03v3 ad=0 pd=0 as=0 ps=0 w=1.56u l=0.28u
X961 VREFN A44_DCTRL_STRIP_W_R2_0/CTRL_OUT[7] A44_CDAC_CAP_BANK_ASSEMBLY_R8_M6_0/A44_CAP_CORE128_M6_R1_0/CAP_BOTTOM_039 GND nfet_03v3 ad=0 pd=0 as=0 ps=0 w=1.56u l=0.28u
X962 VREFN A44_DCTRL_STRIP_W_R2_0/CTRL_OUT[7] A44_CDAC_CAP_BANK_ASSEMBLY_R8_M6_0/A44_CAP_CORE128_M6_R1_0/CAP_BOTTOM_039 GND nfet_03v3 ad=0 pd=0 as=0 ps=0 w=1.56u l=0.28u
X963 VREFN A44_DCTRL_STRIP_W_R2_0/CTRL_OUT[7] A44_CDAC_CAP_BANK_ASSEMBLY_R8_M6_0/A44_CAP_CORE128_M6_R1_0/CAP_BOTTOM_039 GND nfet_03v3 ad=0 pd=0 as=0 ps=0 w=1.56u l=0.28u
X964 VREFN A44_DCTRL_STRIP_W_R2_0/CTRL_OUT[7] A44_CDAC_CAP_BANK_ASSEMBLY_R8_M6_0/A44_CAP_CORE128_M6_R1_0/CAP_BOTTOM_039 GND nfet_03v3 ad=0 pd=0 as=0 ps=0 w=1.56u l=0.28u
X965 VREFN A44_DCTRL_STRIP_W_R2_0/CTRL_OUT[7] A44_CDAC_CAP_BANK_ASSEMBLY_R8_M6_0/A44_CAP_CORE128_M6_R1_0/CAP_BOTTOM_039 GND nfet_03v3 ad=0 pd=0 as=0 ps=0 w=1.56u l=0.28u
X966 VREFN A44_DCTRL_STRIP_W_R2_0/CTRL_OUT[7] A44_CDAC_CAP_BANK_ASSEMBLY_R8_M6_0/A44_CAP_CORE128_M6_R1_0/CAP_BOTTOM_039 GND nfet_03v3 ad=0 pd=0 as=0 ps=0 w=1.56u l=0.28u
X967 VREFN A44_DCTRL_STRIP_W_R2_0/CTRL_OUT[7] A44_CDAC_CAP_BANK_ASSEMBLY_R8_M6_0/A44_CAP_CORE128_M6_R1_0/CAP_BOTTOM_039 GND nfet_03v3 ad=0 pd=0 as=0 ps=0 w=1.56u l=0.28u
X968 VREFN A44_DCTRL_STRIP_W_R2_0/CTRL_OUT[7] A44_CDAC_CAP_BANK_ASSEMBLY_R8_M6_0/A44_CAP_CORE128_M6_R1_0/CAP_BOTTOM_039 GND nfet_03v3 ad=0 pd=0 as=0 ps=0 w=1.56u l=0.28u
X969 VREFN A44_DCTRL_STRIP_W_R2_0/CTRL_OUT[7] A44_CDAC_CAP_BANK_ASSEMBLY_R8_M6_0/A44_CAP_CORE128_M6_R1_0/CAP_BOTTOM_039 GND nfet_03v3 ad=0 pd=0 as=0 ps=0 w=1.56u l=0.28u
X970 VREFN A44_DCTRL_STRIP_W_R2_0/CTRL_OUT[7] A44_CDAC_CAP_BANK_ASSEMBLY_R8_M6_0/A44_CAP_CORE128_M6_R1_0/CAP_BOTTOM_039 GND nfet_03v3 ad=0 pd=0 as=0 ps=0 w=1.56u l=0.28u
X971 VREFN A44_DCTRL_STRIP_W_R2_0/CTRL_OUT[7] A44_CDAC_CAP_BANK_ASSEMBLY_R8_M6_0/A44_CAP_CORE128_M6_R1_0/CAP_BOTTOM_039 GND nfet_03v3 ad=0 pd=0 as=0 ps=0 w=1.56u l=0.28u
X972 VREFN A44_DCTRL_STRIP_W_R2_0/CTRL_OUT[7] A44_CDAC_CAP_BANK_ASSEMBLY_R8_M6_0/A44_CAP_CORE128_M6_R1_0/CAP_BOTTOM_039 GND nfet_03v3 ad=0 pd=0 as=0 ps=0 w=1.56u l=0.28u
X973 VREFN A44_DCTRL_STRIP_W_R2_0/CTRL_OUT[7] A44_CDAC_CAP_BANK_ASSEMBLY_R8_M6_0/A44_CAP_CORE128_M6_R1_0/CAP_BOTTOM_039 GND nfet_03v3 ad=0 pd=0 as=0 ps=0 w=1.56u l=0.28u
X974 VREFP A44_DCTRL_STRIP_W_R2_0/CTRL_OUT[7] A44_CDAC_CAP_BANK_ASSEMBLY_R8_M6_0/A44_CAP_CORE128_M6_R1_0/CAP_BOTTOM_002 VDD pfet_03v3 ad=0 pd=0 as=16.6842p ps=77.76u w=1.56u l=0.28u
X975 VREFP A44_DCTRL_STRIP_W_R2_0/CTRL_OUT[7] A44_CDAC_CAP_BANK_ASSEMBLY_R8_M6_0/A44_CAP_CORE128_M6_R1_0/CAP_BOTTOM_002 VDD pfet_03v3 ad=0 pd=0 as=0 ps=0 w=1.56u l=0.28u
X976 VREFP A44_DCTRL_STRIP_W_R2_0/CTRL_OUT[7] A44_CDAC_CAP_BANK_ASSEMBLY_R8_M6_0/A44_CAP_CORE128_M6_R1_0/CAP_BOTTOM_002 VDD pfet_03v3 ad=0 pd=0 as=0 ps=0 w=1.56u l=0.28u
X977 VREFP A44_DCTRL_STRIP_W_R2_0/CTRL_OUT[7] A44_CDAC_CAP_BANK_ASSEMBLY_R8_M6_0/A44_CAP_CORE128_M6_R1_0/CAP_BOTTOM_002 VDD pfet_03v3 ad=0 pd=0 as=0 ps=0 w=1.56u l=0.28u
X978 VREFP A44_DCTRL_STRIP_W_R2_0/CTRL_OUT[7] A44_CDAC_CAP_BANK_ASSEMBLY_R8_M6_0/A44_CAP_CORE128_M6_R1_0/CAP_BOTTOM_002 VDD pfet_03v3 ad=0 pd=0 as=0 ps=0 w=1.56u l=0.28u
X979 VREFP A44_DCTRL_STRIP_W_R2_0/CTRL_OUT[7] A44_CDAC_CAP_BANK_ASSEMBLY_R8_M6_0/A44_CAP_CORE128_M6_R1_0/CAP_BOTTOM_002 VDD pfet_03v3 ad=0 pd=0 as=0 ps=0 w=1.56u l=0.28u
X980 VREFP A44_DCTRL_STRIP_W_R2_0/CTRL_OUT[7] A44_CDAC_CAP_BANK_ASSEMBLY_R8_M6_0/A44_CAP_CORE128_M6_R1_0/CAP_BOTTOM_002 VDD pfet_03v3 ad=0 pd=0 as=0 ps=0 w=1.56u l=0.28u
X981 VREFP A44_DCTRL_STRIP_W_R2_0/CTRL_OUT[7] A44_CDAC_CAP_BANK_ASSEMBLY_R8_M6_0/A44_CAP_CORE128_M6_R1_0/CAP_BOTTOM_002 VDD pfet_03v3 ad=0 pd=0 as=0 ps=0 w=1.56u l=0.28u
X982 VREFP A44_DCTRL_STRIP_W_R2_0/CTRL_OUT[7] A44_CDAC_CAP_BANK_ASSEMBLY_R8_M6_0/A44_CAP_CORE128_M6_R1_0/CAP_BOTTOM_002 VDD pfet_03v3 ad=0 pd=0 as=0 ps=0 w=1.56u l=0.28u
X983 VREFP A44_DCTRL_STRIP_W_R2_0/CTRL_OUT[7] A44_CDAC_CAP_BANK_ASSEMBLY_R8_M6_0/A44_CAP_CORE128_M6_R1_0/CAP_BOTTOM_002 VDD pfet_03v3 ad=0 pd=0 as=0 ps=0 w=1.56u l=0.28u
X984 VREFP A44_DCTRL_STRIP_W_R2_0/CTRL_OUT[7] A44_CDAC_CAP_BANK_ASSEMBLY_R8_M6_0/A44_CAP_CORE128_M6_R1_0/CAP_BOTTOM_002 VDD pfet_03v3 ad=0 pd=0 as=0 ps=0 w=1.56u l=0.28u
X985 VREFP A44_DCTRL_STRIP_W_R2_0/CTRL_OUT[7] A44_CDAC_CAP_BANK_ASSEMBLY_R8_M6_0/A44_CAP_CORE128_M6_R1_0/CAP_BOTTOM_002 VDD pfet_03v3 ad=0 pd=0 as=0 ps=0 w=1.56u l=0.28u
X986 VREFP A44_DCTRL_STRIP_W_R2_0/CTRL_OUT[7] A44_CDAC_CAP_BANK_ASSEMBLY_R8_M6_0/A44_CAP_CORE128_M6_R1_0/CAP_BOTTOM_002 VDD pfet_03v3 ad=0 pd=0 as=0 ps=0 w=1.56u l=0.28u
X987 VREFP A44_DCTRL_STRIP_W_R2_0/CTRL_OUT[7] A44_CDAC_CAP_BANK_ASSEMBLY_R8_M6_0/A44_CAP_CORE128_M6_R1_0/CAP_BOTTOM_002 VDD pfet_03v3 ad=0 pd=0 as=0 ps=0 w=1.56u l=0.28u
X988 VREFP A44_DCTRL_STRIP_W_R2_0/CTRL_OUT[7] A44_CDAC_CAP_BANK_ASSEMBLY_R8_M6_0/A44_CAP_CORE128_M6_R1_0/CAP_BOTTOM_002 VDD pfet_03v3 ad=0 pd=0 as=0 ps=0 w=1.56u l=0.28u
X989 VREFP A44_DCTRL_STRIP_W_R2_0/CTRL_OUT[7] A44_CDAC_CAP_BANK_ASSEMBLY_R8_M6_0/A44_CAP_CORE128_M6_R1_0/CAP_BOTTOM_002 VDD pfet_03v3 ad=0 pd=0 as=0 ps=0 w=1.56u l=0.28u
X990 VREFP A44_DCTRL_STRIP_W_R2_0/CTRL_OUT[7] A44_CDAC_CAP_BANK_ASSEMBLY_R8_M6_0/A44_CAP_CORE128_M6_R1_0/CAP_BOTTOM_002 VDD pfet_03v3 ad=0 pd=0 as=0 ps=0 w=1.56u l=0.28u
X991 VREFP A44_DCTRL_STRIP_W_R2_0/CTRL_OUT[7] A44_CDAC_CAP_BANK_ASSEMBLY_R8_M6_0/A44_CAP_CORE128_M6_R1_0/CAP_BOTTOM_002 VDD pfet_03v3 ad=0 pd=0 as=0 ps=0 w=1.56u l=0.28u
X992 VREFN A44_DCTRL_STRIP_W_R2_0/CTRL_OUT[7] A44_CDAC_CAP_BANK_ASSEMBLY_R8_M6_0/A44_CAP_CORE128_M6_R1_0/CAP_BOTTOM_002 GND nfet_03v3 ad=0 pd=0 as=16.6842p ps=77.76u w=1.56u l=0.28u
X993 VREFN A44_DCTRL_STRIP_W_R2_0/CTRL_OUT[7] A44_CDAC_CAP_BANK_ASSEMBLY_R8_M6_0/A44_CAP_CORE128_M6_R1_0/CAP_BOTTOM_002 GND nfet_03v3 ad=0 pd=0 as=0 ps=0 w=1.56u l=0.28u
X994 VREFN A44_DCTRL_STRIP_W_R2_0/CTRL_OUT[7] A44_CDAC_CAP_BANK_ASSEMBLY_R8_M6_0/A44_CAP_CORE128_M6_R1_0/CAP_BOTTOM_002 GND nfet_03v3 ad=0 pd=0 as=0 ps=0 w=1.56u l=0.28u
X995 VREFN A44_DCTRL_STRIP_W_R2_0/CTRL_OUT[7] A44_CDAC_CAP_BANK_ASSEMBLY_R8_M6_0/A44_CAP_CORE128_M6_R1_0/CAP_BOTTOM_002 GND nfet_03v3 ad=0 pd=0 as=0 ps=0 w=1.56u l=0.28u
X996 VREFN A44_DCTRL_STRIP_W_R2_0/CTRL_OUT[7] A44_CDAC_CAP_BANK_ASSEMBLY_R8_M6_0/A44_CAP_CORE128_M6_R1_0/CAP_BOTTOM_002 GND nfet_03v3 ad=0 pd=0 as=0 ps=0 w=1.56u l=0.28u
X997 VREFN A44_DCTRL_STRIP_W_R2_0/CTRL_OUT[7] A44_CDAC_CAP_BANK_ASSEMBLY_R8_M6_0/A44_CAP_CORE128_M6_R1_0/CAP_BOTTOM_002 GND nfet_03v3 ad=0 pd=0 as=0 ps=0 w=1.56u l=0.28u
X998 VREFN A44_DCTRL_STRIP_W_R2_0/CTRL_OUT[7] A44_CDAC_CAP_BANK_ASSEMBLY_R8_M6_0/A44_CAP_CORE128_M6_R1_0/CAP_BOTTOM_002 GND nfet_03v3 ad=0 pd=0 as=0 ps=0 w=1.56u l=0.28u
X999 VREFN A44_DCTRL_STRIP_W_R2_0/CTRL_OUT[7] A44_CDAC_CAP_BANK_ASSEMBLY_R8_M6_0/A44_CAP_CORE128_M6_R1_0/CAP_BOTTOM_002 GND nfet_03v3 ad=0 pd=0 as=0 ps=0 w=1.56u l=0.28u
X1000 VREFN A44_DCTRL_STRIP_W_R2_0/CTRL_OUT[7] A44_CDAC_CAP_BANK_ASSEMBLY_R8_M6_0/A44_CAP_CORE128_M6_R1_0/CAP_BOTTOM_002 GND nfet_03v3 ad=0 pd=0 as=0 ps=0 w=1.56u l=0.28u
X1001 VREFN A44_DCTRL_STRIP_W_R2_0/CTRL_OUT[7] A44_CDAC_CAP_BANK_ASSEMBLY_R8_M6_0/A44_CAP_CORE128_M6_R1_0/CAP_BOTTOM_002 GND nfet_03v3 ad=0 pd=0 as=0 ps=0 w=1.56u l=0.28u
X1002 VREFN A44_DCTRL_STRIP_W_R2_0/CTRL_OUT[7] A44_CDAC_CAP_BANK_ASSEMBLY_R8_M6_0/A44_CAP_CORE128_M6_R1_0/CAP_BOTTOM_002 GND nfet_03v3 ad=0 pd=0 as=0 ps=0 w=1.56u l=0.28u
X1003 VREFN A44_DCTRL_STRIP_W_R2_0/CTRL_OUT[7] A44_CDAC_CAP_BANK_ASSEMBLY_R8_M6_0/A44_CAP_CORE128_M6_R1_0/CAP_BOTTOM_002 GND nfet_03v3 ad=0 pd=0 as=0 ps=0 w=1.56u l=0.28u
X1004 VREFN A44_DCTRL_STRIP_W_R2_0/CTRL_OUT[7] A44_CDAC_CAP_BANK_ASSEMBLY_R8_M6_0/A44_CAP_CORE128_M6_R1_0/CAP_BOTTOM_002 GND nfet_03v3 ad=0 pd=0 as=0 ps=0 w=1.56u l=0.28u
X1005 VREFN A44_DCTRL_STRIP_W_R2_0/CTRL_OUT[7] A44_CDAC_CAP_BANK_ASSEMBLY_R8_M6_0/A44_CAP_CORE128_M6_R1_0/CAP_BOTTOM_002 GND nfet_03v3 ad=0 pd=0 as=0 ps=0 w=1.56u l=0.28u
X1006 VREFN A44_DCTRL_STRIP_W_R2_0/CTRL_OUT[7] A44_CDAC_CAP_BANK_ASSEMBLY_R8_M6_0/A44_CAP_CORE128_M6_R1_0/CAP_BOTTOM_002 GND nfet_03v3 ad=0 pd=0 as=0 ps=0 w=1.56u l=0.28u
X1007 VREFN A44_DCTRL_STRIP_W_R2_0/CTRL_OUT[7] A44_CDAC_CAP_BANK_ASSEMBLY_R8_M6_0/A44_CAP_CORE128_M6_R1_0/CAP_BOTTOM_002 GND nfet_03v3 ad=0 pd=0 as=0 ps=0 w=1.56u l=0.28u
X1008 VREFN A44_DCTRL_STRIP_W_R2_0/CTRL_OUT[7] A44_CDAC_CAP_BANK_ASSEMBLY_R8_M6_0/A44_CAP_CORE128_M6_R1_0/CAP_BOTTOM_002 GND nfet_03v3 ad=0 pd=0 as=0 ps=0 w=1.56u l=0.28u
X1009 VREFN A44_DCTRL_STRIP_W_R2_0/CTRL_OUT[7] A44_CDAC_CAP_BANK_ASSEMBLY_R8_M6_0/A44_CAP_CORE128_M6_R1_0/CAP_BOTTOM_002 GND nfet_03v3 ad=0 pd=0 as=0 ps=0 w=1.56u l=0.28u
X1010 VREFP A44_DCTRL_STRIP_W_R2_0/CTRL_OUT[7] A44_CDAC_CAP_BANK_ASSEMBLY_R8_M6_0/A44_CAP_CORE128_M6_R1_0/CAP_BOTTOM_062 VDD pfet_03v3 ad=0 pd=0 as=16.6842p ps=77.76u w=1.56u l=0.28u
X1011 VREFP A44_DCTRL_STRIP_W_R2_0/CTRL_OUT[7] A44_CDAC_CAP_BANK_ASSEMBLY_R8_M6_0/A44_CAP_CORE128_M6_R1_0/CAP_BOTTOM_062 VDD pfet_03v3 ad=0 pd=0 as=0 ps=0 w=1.56u l=0.28u
X1012 VREFP A44_DCTRL_STRIP_W_R2_0/CTRL_OUT[7] A44_CDAC_CAP_BANK_ASSEMBLY_R8_M6_0/A44_CAP_CORE128_M6_R1_0/CAP_BOTTOM_062 VDD pfet_03v3 ad=0 pd=0 as=0 ps=0 w=1.56u l=0.28u
X1013 VREFP A44_DCTRL_STRIP_W_R2_0/CTRL_OUT[7] A44_CDAC_CAP_BANK_ASSEMBLY_R8_M6_0/A44_CAP_CORE128_M6_R1_0/CAP_BOTTOM_062 VDD pfet_03v3 ad=0 pd=0 as=0 ps=0 w=1.56u l=0.28u
X1014 VREFP A44_DCTRL_STRIP_W_R2_0/CTRL_OUT[7] A44_CDAC_CAP_BANK_ASSEMBLY_R8_M6_0/A44_CAP_CORE128_M6_R1_0/CAP_BOTTOM_062 VDD pfet_03v3 ad=0 pd=0 as=0 ps=0 w=1.56u l=0.28u
X1015 VREFP A44_DCTRL_STRIP_W_R2_0/CTRL_OUT[7] A44_CDAC_CAP_BANK_ASSEMBLY_R8_M6_0/A44_CAP_CORE128_M6_R1_0/CAP_BOTTOM_062 VDD pfet_03v3 ad=0 pd=0 as=0 ps=0 w=1.56u l=0.28u
X1016 VREFP A44_DCTRL_STRIP_W_R2_0/CTRL_OUT[7] A44_CDAC_CAP_BANK_ASSEMBLY_R8_M6_0/A44_CAP_CORE128_M6_R1_0/CAP_BOTTOM_062 VDD pfet_03v3 ad=0 pd=0 as=0 ps=0 w=1.56u l=0.28u
X1017 VREFP A44_DCTRL_STRIP_W_R2_0/CTRL_OUT[7] A44_CDAC_CAP_BANK_ASSEMBLY_R8_M6_0/A44_CAP_CORE128_M6_R1_0/CAP_BOTTOM_062 VDD pfet_03v3 ad=0 pd=0 as=0 ps=0 w=1.56u l=0.28u
X1018 VREFP A44_DCTRL_STRIP_W_R2_0/CTRL_OUT[7] A44_CDAC_CAP_BANK_ASSEMBLY_R8_M6_0/A44_CAP_CORE128_M6_R1_0/CAP_BOTTOM_062 VDD pfet_03v3 ad=0 pd=0 as=0 ps=0 w=1.56u l=0.28u
X1019 VREFP A44_DCTRL_STRIP_W_R2_0/CTRL_OUT[7] A44_CDAC_CAP_BANK_ASSEMBLY_R8_M6_0/A44_CAP_CORE128_M6_R1_0/CAP_BOTTOM_062 VDD pfet_03v3 ad=0 pd=0 as=0 ps=0 w=1.56u l=0.28u
X1020 VREFP A44_DCTRL_STRIP_W_R2_0/CTRL_OUT[7] A44_CDAC_CAP_BANK_ASSEMBLY_R8_M6_0/A44_CAP_CORE128_M6_R1_0/CAP_BOTTOM_062 VDD pfet_03v3 ad=0 pd=0 as=0 ps=0 w=1.56u l=0.28u
X1021 VREFP A44_DCTRL_STRIP_W_R2_0/CTRL_OUT[7] A44_CDAC_CAP_BANK_ASSEMBLY_R8_M6_0/A44_CAP_CORE128_M6_R1_0/CAP_BOTTOM_062 VDD pfet_03v3 ad=0 pd=0 as=0 ps=0 w=1.56u l=0.28u
X1022 VREFP A44_DCTRL_STRIP_W_R2_0/CTRL_OUT[7] A44_CDAC_CAP_BANK_ASSEMBLY_R8_M6_0/A44_CAP_CORE128_M6_R1_0/CAP_BOTTOM_062 VDD pfet_03v3 ad=0 pd=0 as=0 ps=0 w=1.56u l=0.28u
X1023 VREFP A44_DCTRL_STRIP_W_R2_0/CTRL_OUT[7] A44_CDAC_CAP_BANK_ASSEMBLY_R8_M6_0/A44_CAP_CORE128_M6_R1_0/CAP_BOTTOM_062 VDD pfet_03v3 ad=0 pd=0 as=0 ps=0 w=1.56u l=0.28u
X1024 VREFP A44_DCTRL_STRIP_W_R2_0/CTRL_OUT[7] A44_CDAC_CAP_BANK_ASSEMBLY_R8_M6_0/A44_CAP_CORE128_M6_R1_0/CAP_BOTTOM_062 VDD pfet_03v3 ad=0 pd=0 as=0 ps=0 w=1.56u l=0.28u
X1025 VREFP A44_DCTRL_STRIP_W_R2_0/CTRL_OUT[7] A44_CDAC_CAP_BANK_ASSEMBLY_R8_M6_0/A44_CAP_CORE128_M6_R1_0/CAP_BOTTOM_062 VDD pfet_03v3 ad=0 pd=0 as=0 ps=0 w=1.56u l=0.28u
X1026 VREFP A44_DCTRL_STRIP_W_R2_0/CTRL_OUT[7] A44_CDAC_CAP_BANK_ASSEMBLY_R8_M6_0/A44_CAP_CORE128_M6_R1_0/CAP_BOTTOM_062 VDD pfet_03v3 ad=0 pd=0 as=0 ps=0 w=1.56u l=0.28u
X1027 VREFP A44_DCTRL_STRIP_W_R2_0/CTRL_OUT[7] A44_CDAC_CAP_BANK_ASSEMBLY_R8_M6_0/A44_CAP_CORE128_M6_R1_0/CAP_BOTTOM_062 VDD pfet_03v3 ad=0 pd=0 as=0 ps=0 w=1.56u l=0.28u
X1028 VREFN A44_DCTRL_STRIP_W_R2_0/CTRL_OUT[7] A44_CDAC_CAP_BANK_ASSEMBLY_R8_M6_0/A44_CAP_CORE128_M6_R1_0/CAP_BOTTOM_062 GND nfet_03v3 ad=0 pd=0 as=16.6842p ps=77.76u w=1.56u l=0.28u
X1029 VREFN A44_DCTRL_STRIP_W_R2_0/CTRL_OUT[7] A44_CDAC_CAP_BANK_ASSEMBLY_R8_M6_0/A44_CAP_CORE128_M6_R1_0/CAP_BOTTOM_062 GND nfet_03v3 ad=0 pd=0 as=0 ps=0 w=1.56u l=0.28u
X1030 VREFN A44_DCTRL_STRIP_W_R2_0/CTRL_OUT[7] A44_CDAC_CAP_BANK_ASSEMBLY_R8_M6_0/A44_CAP_CORE128_M6_R1_0/CAP_BOTTOM_062 GND nfet_03v3 ad=0 pd=0 as=0 ps=0 w=1.56u l=0.28u
X1031 VREFN A44_DCTRL_STRIP_W_R2_0/CTRL_OUT[7] A44_CDAC_CAP_BANK_ASSEMBLY_R8_M6_0/A44_CAP_CORE128_M6_R1_0/CAP_BOTTOM_062 GND nfet_03v3 ad=0 pd=0 as=0 ps=0 w=1.56u l=0.28u
X1032 VREFN A44_DCTRL_STRIP_W_R2_0/CTRL_OUT[7] A44_CDAC_CAP_BANK_ASSEMBLY_R8_M6_0/A44_CAP_CORE128_M6_R1_0/CAP_BOTTOM_062 GND nfet_03v3 ad=0 pd=0 as=0 ps=0 w=1.56u l=0.28u
X1033 VREFN A44_DCTRL_STRIP_W_R2_0/CTRL_OUT[7] A44_CDAC_CAP_BANK_ASSEMBLY_R8_M6_0/A44_CAP_CORE128_M6_R1_0/CAP_BOTTOM_062 GND nfet_03v3 ad=0 pd=0 as=0 ps=0 w=1.56u l=0.28u
X1034 VREFN A44_DCTRL_STRIP_W_R2_0/CTRL_OUT[7] A44_CDAC_CAP_BANK_ASSEMBLY_R8_M6_0/A44_CAP_CORE128_M6_R1_0/CAP_BOTTOM_062 GND nfet_03v3 ad=0 pd=0 as=0 ps=0 w=1.56u l=0.28u
X1035 VREFN A44_DCTRL_STRIP_W_R2_0/CTRL_OUT[7] A44_CDAC_CAP_BANK_ASSEMBLY_R8_M6_0/A44_CAP_CORE128_M6_R1_0/CAP_BOTTOM_062 GND nfet_03v3 ad=0 pd=0 as=0 ps=0 w=1.56u l=0.28u
X1036 VREFN A44_DCTRL_STRIP_W_R2_0/CTRL_OUT[7] A44_CDAC_CAP_BANK_ASSEMBLY_R8_M6_0/A44_CAP_CORE128_M6_R1_0/CAP_BOTTOM_062 GND nfet_03v3 ad=0 pd=0 as=0 ps=0 w=1.56u l=0.28u
X1037 VREFN A44_DCTRL_STRIP_W_R2_0/CTRL_OUT[7] A44_CDAC_CAP_BANK_ASSEMBLY_R8_M6_0/A44_CAP_CORE128_M6_R1_0/CAP_BOTTOM_062 GND nfet_03v3 ad=0 pd=0 as=0 ps=0 w=1.56u l=0.28u
X1038 VREFN A44_DCTRL_STRIP_W_R2_0/CTRL_OUT[7] A44_CDAC_CAP_BANK_ASSEMBLY_R8_M6_0/A44_CAP_CORE128_M6_R1_0/CAP_BOTTOM_062 GND nfet_03v3 ad=0 pd=0 as=0 ps=0 w=1.56u l=0.28u
X1039 VREFN A44_DCTRL_STRIP_W_R2_0/CTRL_OUT[7] A44_CDAC_CAP_BANK_ASSEMBLY_R8_M6_0/A44_CAP_CORE128_M6_R1_0/CAP_BOTTOM_062 GND nfet_03v3 ad=0 pd=0 as=0 ps=0 w=1.56u l=0.28u
X1040 VREFN A44_DCTRL_STRIP_W_R2_0/CTRL_OUT[7] A44_CDAC_CAP_BANK_ASSEMBLY_R8_M6_0/A44_CAP_CORE128_M6_R1_0/CAP_BOTTOM_062 GND nfet_03v3 ad=0 pd=0 as=0 ps=0 w=1.56u l=0.28u
X1041 VREFN A44_DCTRL_STRIP_W_R2_0/CTRL_OUT[7] A44_CDAC_CAP_BANK_ASSEMBLY_R8_M6_0/A44_CAP_CORE128_M6_R1_0/CAP_BOTTOM_062 GND nfet_03v3 ad=0 pd=0 as=0 ps=0 w=1.56u l=0.28u
X1042 VREFN A44_DCTRL_STRIP_W_R2_0/CTRL_OUT[7] A44_CDAC_CAP_BANK_ASSEMBLY_R8_M6_0/A44_CAP_CORE128_M6_R1_0/CAP_BOTTOM_062 GND nfet_03v3 ad=0 pd=0 as=0 ps=0 w=1.56u l=0.28u
X1043 VREFN A44_DCTRL_STRIP_W_R2_0/CTRL_OUT[7] A44_CDAC_CAP_BANK_ASSEMBLY_R8_M6_0/A44_CAP_CORE128_M6_R1_0/CAP_BOTTOM_062 GND nfet_03v3 ad=0 pd=0 as=0 ps=0 w=1.56u l=0.28u
X1044 VREFN A44_DCTRL_STRIP_W_R2_0/CTRL_OUT[7] A44_CDAC_CAP_BANK_ASSEMBLY_R8_M6_0/A44_CAP_CORE128_M6_R1_0/CAP_BOTTOM_062 GND nfet_03v3 ad=0 pd=0 as=0 ps=0 w=1.56u l=0.28u
X1045 VREFN A44_DCTRL_STRIP_W_R2_0/CTRL_OUT[7] A44_CDAC_CAP_BANK_ASSEMBLY_R8_M6_0/A44_CAP_CORE128_M6_R1_0/CAP_BOTTOM_062 GND nfet_03v3 ad=0 pd=0 as=0 ps=0 w=1.56u l=0.28u
X1046 VREFP A44_DCTRL_STRIP_W_R2_0/CTRL_OUT[2] A44_CDAC_CAP_BANK_ASSEMBLY_R8_M6_0/A44_CAP_CORE128_M6_R1_0/CAP_BOTTOM_026 VDD pfet_03v3 ad=0 pd=0 as=16.6842p ps=77.76u w=1.56u l=0.28u
X1047 VREFP A44_DCTRL_STRIP_W_R2_0/CTRL_OUT[2] A44_CDAC_CAP_BANK_ASSEMBLY_R8_M6_0/A44_CAP_CORE128_M6_R1_0/CAP_BOTTOM_026 VDD pfet_03v3 ad=0 pd=0 as=0 ps=0 w=1.56u l=0.28u
X1048 VREFP A44_DCTRL_STRIP_W_R2_0/CTRL_OUT[2] A44_CDAC_CAP_BANK_ASSEMBLY_R8_M6_0/A44_CAP_CORE128_M6_R1_0/CAP_BOTTOM_026 VDD pfet_03v3 ad=0 pd=0 as=0 ps=0 w=1.56u l=0.28u
X1049 VREFP A44_DCTRL_STRIP_W_R2_0/CTRL_OUT[2] A44_CDAC_CAP_BANK_ASSEMBLY_R8_M6_0/A44_CAP_CORE128_M6_R1_0/CAP_BOTTOM_026 VDD pfet_03v3 ad=0 pd=0 as=0 ps=0 w=1.56u l=0.28u
X1050 VREFP A44_DCTRL_STRIP_W_R2_0/CTRL_OUT[2] A44_CDAC_CAP_BANK_ASSEMBLY_R8_M6_0/A44_CAP_CORE128_M6_R1_0/CAP_BOTTOM_026 VDD pfet_03v3 ad=0 pd=0 as=0 ps=0 w=1.56u l=0.28u
X1051 VREFP A44_DCTRL_STRIP_W_R2_0/CTRL_OUT[2] A44_CDAC_CAP_BANK_ASSEMBLY_R8_M6_0/A44_CAP_CORE128_M6_R1_0/CAP_BOTTOM_026 VDD pfet_03v3 ad=0 pd=0 as=0 ps=0 w=1.56u l=0.28u
X1052 VREFP A44_DCTRL_STRIP_W_R2_0/CTRL_OUT[2] A44_CDAC_CAP_BANK_ASSEMBLY_R8_M6_0/A44_CAP_CORE128_M6_R1_0/CAP_BOTTOM_026 VDD pfet_03v3 ad=0 pd=0 as=0 ps=0 w=1.56u l=0.28u
X1053 VREFP A44_DCTRL_STRIP_W_R2_0/CTRL_OUT[2] A44_CDAC_CAP_BANK_ASSEMBLY_R8_M6_0/A44_CAP_CORE128_M6_R1_0/CAP_BOTTOM_026 VDD pfet_03v3 ad=0 pd=0 as=0 ps=0 w=1.56u l=0.28u
X1054 VREFP A44_DCTRL_STRIP_W_R2_0/CTRL_OUT[2] A44_CDAC_CAP_BANK_ASSEMBLY_R8_M6_0/A44_CAP_CORE128_M6_R1_0/CAP_BOTTOM_026 VDD pfet_03v3 ad=0 pd=0 as=0 ps=0 w=1.56u l=0.28u
X1055 VREFP A44_DCTRL_STRIP_W_R2_0/CTRL_OUT[2] A44_CDAC_CAP_BANK_ASSEMBLY_R8_M6_0/A44_CAP_CORE128_M6_R1_0/CAP_BOTTOM_026 VDD pfet_03v3 ad=0 pd=0 as=0 ps=0 w=1.56u l=0.28u
X1056 VREFP A44_DCTRL_STRIP_W_R2_0/CTRL_OUT[2] A44_CDAC_CAP_BANK_ASSEMBLY_R8_M6_0/A44_CAP_CORE128_M6_R1_0/CAP_BOTTOM_026 VDD pfet_03v3 ad=0 pd=0 as=0 ps=0 w=1.56u l=0.28u
X1057 VREFP A44_DCTRL_STRIP_W_R2_0/CTRL_OUT[2] A44_CDAC_CAP_BANK_ASSEMBLY_R8_M6_0/A44_CAP_CORE128_M6_R1_0/CAP_BOTTOM_026 VDD pfet_03v3 ad=0 pd=0 as=0 ps=0 w=1.56u l=0.28u
X1058 VREFP A44_DCTRL_STRIP_W_R2_0/CTRL_OUT[2] A44_CDAC_CAP_BANK_ASSEMBLY_R8_M6_0/A44_CAP_CORE128_M6_R1_0/CAP_BOTTOM_026 VDD pfet_03v3 ad=0 pd=0 as=0 ps=0 w=1.56u l=0.28u
X1059 VREFP A44_DCTRL_STRIP_W_R2_0/CTRL_OUT[2] A44_CDAC_CAP_BANK_ASSEMBLY_R8_M6_0/A44_CAP_CORE128_M6_R1_0/CAP_BOTTOM_026 VDD pfet_03v3 ad=0 pd=0 as=0 ps=0 w=1.56u l=0.28u
X1060 VREFP A44_DCTRL_STRIP_W_R2_0/CTRL_OUT[2] A44_CDAC_CAP_BANK_ASSEMBLY_R8_M6_0/A44_CAP_CORE128_M6_R1_0/CAP_BOTTOM_026 VDD pfet_03v3 ad=0 pd=0 as=0 ps=0 w=1.56u l=0.28u
X1061 VREFP A44_DCTRL_STRIP_W_R2_0/CTRL_OUT[2] A44_CDAC_CAP_BANK_ASSEMBLY_R8_M6_0/A44_CAP_CORE128_M6_R1_0/CAP_BOTTOM_026 VDD pfet_03v3 ad=0 pd=0 as=0 ps=0 w=1.56u l=0.28u
X1062 VREFP A44_DCTRL_STRIP_W_R2_0/CTRL_OUT[2] A44_CDAC_CAP_BANK_ASSEMBLY_R8_M6_0/A44_CAP_CORE128_M6_R1_0/CAP_BOTTOM_026 VDD pfet_03v3 ad=0 pd=0 as=0 ps=0 w=1.56u l=0.28u
X1063 VREFP A44_DCTRL_STRIP_W_R2_0/CTRL_OUT[2] A44_CDAC_CAP_BANK_ASSEMBLY_R8_M6_0/A44_CAP_CORE128_M6_R1_0/CAP_BOTTOM_026 VDD pfet_03v3 ad=0 pd=0 as=0 ps=0 w=1.56u l=0.28u
X1064 VREFN A44_DCTRL_STRIP_W_R2_0/CTRL_OUT[2] A44_CDAC_CAP_BANK_ASSEMBLY_R8_M6_0/A44_CAP_CORE128_M6_R1_0/CAP_BOTTOM_026 GND nfet_03v3 ad=0 pd=0 as=16.6842p ps=77.76u w=1.56u l=0.28u
X1065 VREFN A44_DCTRL_STRIP_W_R2_0/CTRL_OUT[2] A44_CDAC_CAP_BANK_ASSEMBLY_R8_M6_0/A44_CAP_CORE128_M6_R1_0/CAP_BOTTOM_026 GND nfet_03v3 ad=0 pd=0 as=0 ps=0 w=1.56u l=0.28u
X1066 VREFN A44_DCTRL_STRIP_W_R2_0/CTRL_OUT[2] A44_CDAC_CAP_BANK_ASSEMBLY_R8_M6_0/A44_CAP_CORE128_M6_R1_0/CAP_BOTTOM_026 GND nfet_03v3 ad=0 pd=0 as=0 ps=0 w=1.56u l=0.28u
X1067 VREFN A44_DCTRL_STRIP_W_R2_0/CTRL_OUT[2] A44_CDAC_CAP_BANK_ASSEMBLY_R8_M6_0/A44_CAP_CORE128_M6_R1_0/CAP_BOTTOM_026 GND nfet_03v3 ad=0 pd=0 as=0 ps=0 w=1.56u l=0.28u
X1068 VREFN A44_DCTRL_STRIP_W_R2_0/CTRL_OUT[2] A44_CDAC_CAP_BANK_ASSEMBLY_R8_M6_0/A44_CAP_CORE128_M6_R1_0/CAP_BOTTOM_026 GND nfet_03v3 ad=0 pd=0 as=0 ps=0 w=1.56u l=0.28u
X1069 VREFN A44_DCTRL_STRIP_W_R2_0/CTRL_OUT[2] A44_CDAC_CAP_BANK_ASSEMBLY_R8_M6_0/A44_CAP_CORE128_M6_R1_0/CAP_BOTTOM_026 GND nfet_03v3 ad=0 pd=0 as=0 ps=0 w=1.56u l=0.28u
X1070 VREFN A44_DCTRL_STRIP_W_R2_0/CTRL_OUT[2] A44_CDAC_CAP_BANK_ASSEMBLY_R8_M6_0/A44_CAP_CORE128_M6_R1_0/CAP_BOTTOM_026 GND nfet_03v3 ad=0 pd=0 as=0 ps=0 w=1.56u l=0.28u
X1071 VREFN A44_DCTRL_STRIP_W_R2_0/CTRL_OUT[2] A44_CDAC_CAP_BANK_ASSEMBLY_R8_M6_0/A44_CAP_CORE128_M6_R1_0/CAP_BOTTOM_026 GND nfet_03v3 ad=0 pd=0 as=0 ps=0 w=1.56u l=0.28u
X1072 VREFN A44_DCTRL_STRIP_W_R2_0/CTRL_OUT[2] A44_CDAC_CAP_BANK_ASSEMBLY_R8_M6_0/A44_CAP_CORE128_M6_R1_0/CAP_BOTTOM_026 GND nfet_03v3 ad=0 pd=0 as=0 ps=0 w=1.56u l=0.28u
X1073 VREFN A44_DCTRL_STRIP_W_R2_0/CTRL_OUT[2] A44_CDAC_CAP_BANK_ASSEMBLY_R8_M6_0/A44_CAP_CORE128_M6_R1_0/CAP_BOTTOM_026 GND nfet_03v3 ad=0 pd=0 as=0 ps=0 w=1.56u l=0.28u
X1074 VREFN A44_DCTRL_STRIP_W_R2_0/CTRL_OUT[2] A44_CDAC_CAP_BANK_ASSEMBLY_R8_M6_0/A44_CAP_CORE128_M6_R1_0/CAP_BOTTOM_026 GND nfet_03v3 ad=0 pd=0 as=0 ps=0 w=1.56u l=0.28u
X1075 VREFN A44_DCTRL_STRIP_W_R2_0/CTRL_OUT[2] A44_CDAC_CAP_BANK_ASSEMBLY_R8_M6_0/A44_CAP_CORE128_M6_R1_0/CAP_BOTTOM_026 GND nfet_03v3 ad=0 pd=0 as=0 ps=0 w=1.56u l=0.28u
X1076 VREFN A44_DCTRL_STRIP_W_R2_0/CTRL_OUT[2] A44_CDAC_CAP_BANK_ASSEMBLY_R8_M6_0/A44_CAP_CORE128_M6_R1_0/CAP_BOTTOM_026 GND nfet_03v3 ad=0 pd=0 as=0 ps=0 w=1.56u l=0.28u
X1077 VREFN A44_DCTRL_STRIP_W_R2_0/CTRL_OUT[2] A44_CDAC_CAP_BANK_ASSEMBLY_R8_M6_0/A44_CAP_CORE128_M6_R1_0/CAP_BOTTOM_026 GND nfet_03v3 ad=0 pd=0 as=0 ps=0 w=1.56u l=0.28u
X1078 VREFN A44_DCTRL_STRIP_W_R2_0/CTRL_OUT[2] A44_CDAC_CAP_BANK_ASSEMBLY_R8_M6_0/A44_CAP_CORE128_M6_R1_0/CAP_BOTTOM_026 GND nfet_03v3 ad=0 pd=0 as=0 ps=0 w=1.56u l=0.28u
X1079 VREFN A44_DCTRL_STRIP_W_R2_0/CTRL_OUT[2] A44_CDAC_CAP_BANK_ASSEMBLY_R8_M6_0/A44_CAP_CORE128_M6_R1_0/CAP_BOTTOM_026 GND nfet_03v3 ad=0 pd=0 as=0 ps=0 w=1.56u l=0.28u
X1080 VREFN A44_DCTRL_STRIP_W_R2_0/CTRL_OUT[2] A44_CDAC_CAP_BANK_ASSEMBLY_R8_M6_0/A44_CAP_CORE128_M6_R1_0/CAP_BOTTOM_026 GND nfet_03v3 ad=0 pd=0 as=0 ps=0 w=1.56u l=0.28u
X1081 VREFN A44_DCTRL_STRIP_W_R2_0/CTRL_OUT[2] A44_CDAC_CAP_BANK_ASSEMBLY_R8_M6_0/A44_CAP_CORE128_M6_R1_0/CAP_BOTTOM_026 GND nfet_03v3 ad=0 pd=0 as=0 ps=0 w=1.56u l=0.28u
X1082 VREFP A44_DCTRL_STRIP_W_R2_0/CTRL_OUT[7] A44_CDAC_CAP_BANK_ASSEMBLY_R8_M6_0/A44_CAP_CORE128_M6_R1_0/CAP_BOTTOM_052 VDD pfet_03v3 ad=0 pd=0 as=16.6842p ps=77.76u w=1.56u l=0.28u
X1083 VREFP A44_DCTRL_STRIP_W_R2_0/CTRL_OUT[7] A44_CDAC_CAP_BANK_ASSEMBLY_R8_M6_0/A44_CAP_CORE128_M6_R1_0/CAP_BOTTOM_052 VDD pfet_03v3 ad=0 pd=0 as=0 ps=0 w=1.56u l=0.28u
X1084 VREFP A44_DCTRL_STRIP_W_R2_0/CTRL_OUT[7] A44_CDAC_CAP_BANK_ASSEMBLY_R8_M6_0/A44_CAP_CORE128_M6_R1_0/CAP_BOTTOM_052 VDD pfet_03v3 ad=0 pd=0 as=0 ps=0 w=1.56u l=0.28u
X1085 VREFP A44_DCTRL_STRIP_W_R2_0/CTRL_OUT[7] A44_CDAC_CAP_BANK_ASSEMBLY_R8_M6_0/A44_CAP_CORE128_M6_R1_0/CAP_BOTTOM_052 VDD pfet_03v3 ad=0 pd=0 as=0 ps=0 w=1.56u l=0.28u
X1086 VREFP A44_DCTRL_STRIP_W_R2_0/CTRL_OUT[7] A44_CDAC_CAP_BANK_ASSEMBLY_R8_M6_0/A44_CAP_CORE128_M6_R1_0/CAP_BOTTOM_052 VDD pfet_03v3 ad=0 pd=0 as=0 ps=0 w=1.56u l=0.28u
X1087 VREFP A44_DCTRL_STRIP_W_R2_0/CTRL_OUT[7] A44_CDAC_CAP_BANK_ASSEMBLY_R8_M6_0/A44_CAP_CORE128_M6_R1_0/CAP_BOTTOM_052 VDD pfet_03v3 ad=0 pd=0 as=0 ps=0 w=1.56u l=0.28u
X1088 VREFP A44_DCTRL_STRIP_W_R2_0/CTRL_OUT[7] A44_CDAC_CAP_BANK_ASSEMBLY_R8_M6_0/A44_CAP_CORE128_M6_R1_0/CAP_BOTTOM_052 VDD pfet_03v3 ad=0 pd=0 as=0 ps=0 w=1.56u l=0.28u
X1089 VREFP A44_DCTRL_STRIP_W_R2_0/CTRL_OUT[7] A44_CDAC_CAP_BANK_ASSEMBLY_R8_M6_0/A44_CAP_CORE128_M6_R1_0/CAP_BOTTOM_052 VDD pfet_03v3 ad=0 pd=0 as=0 ps=0 w=1.56u l=0.28u
X1090 VREFP A44_DCTRL_STRIP_W_R2_0/CTRL_OUT[7] A44_CDAC_CAP_BANK_ASSEMBLY_R8_M6_0/A44_CAP_CORE128_M6_R1_0/CAP_BOTTOM_052 VDD pfet_03v3 ad=0 pd=0 as=0 ps=0 w=1.56u l=0.28u
X1091 VREFP A44_DCTRL_STRIP_W_R2_0/CTRL_OUT[7] A44_CDAC_CAP_BANK_ASSEMBLY_R8_M6_0/A44_CAP_CORE128_M6_R1_0/CAP_BOTTOM_052 VDD pfet_03v3 ad=0 pd=0 as=0 ps=0 w=1.56u l=0.28u
X1092 VREFP A44_DCTRL_STRIP_W_R2_0/CTRL_OUT[7] A44_CDAC_CAP_BANK_ASSEMBLY_R8_M6_0/A44_CAP_CORE128_M6_R1_0/CAP_BOTTOM_052 VDD pfet_03v3 ad=0 pd=0 as=0 ps=0 w=1.56u l=0.28u
X1093 VREFP A44_DCTRL_STRIP_W_R2_0/CTRL_OUT[7] A44_CDAC_CAP_BANK_ASSEMBLY_R8_M6_0/A44_CAP_CORE128_M6_R1_0/CAP_BOTTOM_052 VDD pfet_03v3 ad=0 pd=0 as=0 ps=0 w=1.56u l=0.28u
X1094 VREFP A44_DCTRL_STRIP_W_R2_0/CTRL_OUT[7] A44_CDAC_CAP_BANK_ASSEMBLY_R8_M6_0/A44_CAP_CORE128_M6_R1_0/CAP_BOTTOM_052 VDD pfet_03v3 ad=0 pd=0 as=0 ps=0 w=1.56u l=0.28u
X1095 VREFP A44_DCTRL_STRIP_W_R2_0/CTRL_OUT[7] A44_CDAC_CAP_BANK_ASSEMBLY_R8_M6_0/A44_CAP_CORE128_M6_R1_0/CAP_BOTTOM_052 VDD pfet_03v3 ad=0 pd=0 as=0 ps=0 w=1.56u l=0.28u
X1096 VREFP A44_DCTRL_STRIP_W_R2_0/CTRL_OUT[7] A44_CDAC_CAP_BANK_ASSEMBLY_R8_M6_0/A44_CAP_CORE128_M6_R1_0/CAP_BOTTOM_052 VDD pfet_03v3 ad=0 pd=0 as=0 ps=0 w=1.56u l=0.28u
X1097 VREFP A44_DCTRL_STRIP_W_R2_0/CTRL_OUT[7] A44_CDAC_CAP_BANK_ASSEMBLY_R8_M6_0/A44_CAP_CORE128_M6_R1_0/CAP_BOTTOM_052 VDD pfet_03v3 ad=0 pd=0 as=0 ps=0 w=1.56u l=0.28u
X1098 VREFP A44_DCTRL_STRIP_W_R2_0/CTRL_OUT[7] A44_CDAC_CAP_BANK_ASSEMBLY_R8_M6_0/A44_CAP_CORE128_M6_R1_0/CAP_BOTTOM_052 VDD pfet_03v3 ad=0 pd=0 as=0 ps=0 w=1.56u l=0.28u
X1099 VREFP A44_DCTRL_STRIP_W_R2_0/CTRL_OUT[7] A44_CDAC_CAP_BANK_ASSEMBLY_R8_M6_0/A44_CAP_CORE128_M6_R1_0/CAP_BOTTOM_052 VDD pfet_03v3 ad=0 pd=0 as=0 ps=0 w=1.56u l=0.28u
X1100 VREFN A44_DCTRL_STRIP_W_R2_0/CTRL_OUT[7] A44_CDAC_CAP_BANK_ASSEMBLY_R8_M6_0/A44_CAP_CORE128_M6_R1_0/CAP_BOTTOM_052 GND nfet_03v3 ad=0 pd=0 as=16.6842p ps=77.76u w=1.56u l=0.28u
X1101 VREFN A44_DCTRL_STRIP_W_R2_0/CTRL_OUT[7] A44_CDAC_CAP_BANK_ASSEMBLY_R8_M6_0/A44_CAP_CORE128_M6_R1_0/CAP_BOTTOM_052 GND nfet_03v3 ad=0 pd=0 as=0 ps=0 w=1.56u l=0.28u
X1102 VREFN A44_DCTRL_STRIP_W_R2_0/CTRL_OUT[7] A44_CDAC_CAP_BANK_ASSEMBLY_R8_M6_0/A44_CAP_CORE128_M6_R1_0/CAP_BOTTOM_052 GND nfet_03v3 ad=0 pd=0 as=0 ps=0 w=1.56u l=0.28u
X1103 VREFN A44_DCTRL_STRIP_W_R2_0/CTRL_OUT[7] A44_CDAC_CAP_BANK_ASSEMBLY_R8_M6_0/A44_CAP_CORE128_M6_R1_0/CAP_BOTTOM_052 GND nfet_03v3 ad=0 pd=0 as=0 ps=0 w=1.56u l=0.28u
X1104 VREFN A44_DCTRL_STRIP_W_R2_0/CTRL_OUT[7] A44_CDAC_CAP_BANK_ASSEMBLY_R8_M6_0/A44_CAP_CORE128_M6_R1_0/CAP_BOTTOM_052 GND nfet_03v3 ad=0 pd=0 as=0 ps=0 w=1.56u l=0.28u
X1105 VREFN A44_DCTRL_STRIP_W_R2_0/CTRL_OUT[7] A44_CDAC_CAP_BANK_ASSEMBLY_R8_M6_0/A44_CAP_CORE128_M6_R1_0/CAP_BOTTOM_052 GND nfet_03v3 ad=0 pd=0 as=0 ps=0 w=1.56u l=0.28u
X1106 VREFN A44_DCTRL_STRIP_W_R2_0/CTRL_OUT[7] A44_CDAC_CAP_BANK_ASSEMBLY_R8_M6_0/A44_CAP_CORE128_M6_R1_0/CAP_BOTTOM_052 GND nfet_03v3 ad=0 pd=0 as=0 ps=0 w=1.56u l=0.28u
X1107 VREFN A44_DCTRL_STRIP_W_R2_0/CTRL_OUT[7] A44_CDAC_CAP_BANK_ASSEMBLY_R8_M6_0/A44_CAP_CORE128_M6_R1_0/CAP_BOTTOM_052 GND nfet_03v3 ad=0 pd=0 as=0 ps=0 w=1.56u l=0.28u
X1108 VREFN A44_DCTRL_STRIP_W_R2_0/CTRL_OUT[7] A44_CDAC_CAP_BANK_ASSEMBLY_R8_M6_0/A44_CAP_CORE128_M6_R1_0/CAP_BOTTOM_052 GND nfet_03v3 ad=0 pd=0 as=0 ps=0 w=1.56u l=0.28u
X1109 VREFN A44_DCTRL_STRIP_W_R2_0/CTRL_OUT[7] A44_CDAC_CAP_BANK_ASSEMBLY_R8_M6_0/A44_CAP_CORE128_M6_R1_0/CAP_BOTTOM_052 GND nfet_03v3 ad=0 pd=0 as=0 ps=0 w=1.56u l=0.28u
X1110 VREFN A44_DCTRL_STRIP_W_R2_0/CTRL_OUT[7] A44_CDAC_CAP_BANK_ASSEMBLY_R8_M6_0/A44_CAP_CORE128_M6_R1_0/CAP_BOTTOM_052 GND nfet_03v3 ad=0 pd=0 as=0 ps=0 w=1.56u l=0.28u
X1111 VREFN A44_DCTRL_STRIP_W_R2_0/CTRL_OUT[7] A44_CDAC_CAP_BANK_ASSEMBLY_R8_M6_0/A44_CAP_CORE128_M6_R1_0/CAP_BOTTOM_052 GND nfet_03v3 ad=0 pd=0 as=0 ps=0 w=1.56u l=0.28u
X1112 VREFN A44_DCTRL_STRIP_W_R2_0/CTRL_OUT[7] A44_CDAC_CAP_BANK_ASSEMBLY_R8_M6_0/A44_CAP_CORE128_M6_R1_0/CAP_BOTTOM_052 GND nfet_03v3 ad=0 pd=0 as=0 ps=0 w=1.56u l=0.28u
X1113 VREFN A44_DCTRL_STRIP_W_R2_0/CTRL_OUT[7] A44_CDAC_CAP_BANK_ASSEMBLY_R8_M6_0/A44_CAP_CORE128_M6_R1_0/CAP_BOTTOM_052 GND nfet_03v3 ad=0 pd=0 as=0 ps=0 w=1.56u l=0.28u
X1114 VREFN A44_DCTRL_STRIP_W_R2_0/CTRL_OUT[7] A44_CDAC_CAP_BANK_ASSEMBLY_R8_M6_0/A44_CAP_CORE128_M6_R1_0/CAP_BOTTOM_052 GND nfet_03v3 ad=0 pd=0 as=0 ps=0 w=1.56u l=0.28u
X1115 VREFN A44_DCTRL_STRIP_W_R2_0/CTRL_OUT[7] A44_CDAC_CAP_BANK_ASSEMBLY_R8_M6_0/A44_CAP_CORE128_M6_R1_0/CAP_BOTTOM_052 GND nfet_03v3 ad=0 pd=0 as=0 ps=0 w=1.56u l=0.28u
X1116 VREFN A44_DCTRL_STRIP_W_R2_0/CTRL_OUT[7] A44_CDAC_CAP_BANK_ASSEMBLY_R8_M6_0/A44_CAP_CORE128_M6_R1_0/CAP_BOTTOM_052 GND nfet_03v3 ad=0 pd=0 as=0 ps=0 w=1.56u l=0.28u
X1117 VREFN A44_DCTRL_STRIP_W_R2_0/CTRL_OUT[7] A44_CDAC_CAP_BANK_ASSEMBLY_R8_M6_0/A44_CAP_CORE128_M6_R1_0/CAP_BOTTOM_052 GND nfet_03v3 ad=0 pd=0 as=0 ps=0 w=1.56u l=0.28u
X1118 VREFP A44_DCTRL_STRIP_W_R2_0/CTRL_OUT[6] A44_CDAC_CAP_BANK_ASSEMBLY_R8_M6_0/A44_CAP_CORE128_M6_R1_0/CAP_BOTTOM_046 VDD pfet_03v3 ad=0 pd=0 as=16.6842p ps=77.76u w=1.56u l=0.28u
X1119 VREFP A44_DCTRL_STRIP_W_R2_0/CTRL_OUT[6] A44_CDAC_CAP_BANK_ASSEMBLY_R8_M6_0/A44_CAP_CORE128_M6_R1_0/CAP_BOTTOM_046 VDD pfet_03v3 ad=0 pd=0 as=0 ps=0 w=1.56u l=0.28u
X1120 VREFP A44_DCTRL_STRIP_W_R2_0/CTRL_OUT[6] A44_CDAC_CAP_BANK_ASSEMBLY_R8_M6_0/A44_CAP_CORE128_M6_R1_0/CAP_BOTTOM_046 VDD pfet_03v3 ad=0 pd=0 as=0 ps=0 w=1.56u l=0.28u
X1121 VREFP A44_DCTRL_STRIP_W_R2_0/CTRL_OUT[6] A44_CDAC_CAP_BANK_ASSEMBLY_R8_M6_0/A44_CAP_CORE128_M6_R1_0/CAP_BOTTOM_046 VDD pfet_03v3 ad=0 pd=0 as=0 ps=0 w=1.56u l=0.28u
X1122 VREFP A44_DCTRL_STRIP_W_R2_0/CTRL_OUT[6] A44_CDAC_CAP_BANK_ASSEMBLY_R8_M6_0/A44_CAP_CORE128_M6_R1_0/CAP_BOTTOM_046 VDD pfet_03v3 ad=0 pd=0 as=0 ps=0 w=1.56u l=0.28u
X1123 VREFP A44_DCTRL_STRIP_W_R2_0/CTRL_OUT[6] A44_CDAC_CAP_BANK_ASSEMBLY_R8_M6_0/A44_CAP_CORE128_M6_R1_0/CAP_BOTTOM_046 VDD pfet_03v3 ad=0 pd=0 as=0 ps=0 w=1.56u l=0.28u
X1124 VREFP A44_DCTRL_STRIP_W_R2_0/CTRL_OUT[6] A44_CDAC_CAP_BANK_ASSEMBLY_R8_M6_0/A44_CAP_CORE128_M6_R1_0/CAP_BOTTOM_046 VDD pfet_03v3 ad=0 pd=0 as=0 ps=0 w=1.56u l=0.28u
X1125 VREFP A44_DCTRL_STRIP_W_R2_0/CTRL_OUT[6] A44_CDAC_CAP_BANK_ASSEMBLY_R8_M6_0/A44_CAP_CORE128_M6_R1_0/CAP_BOTTOM_046 VDD pfet_03v3 ad=0 pd=0 as=0 ps=0 w=1.56u l=0.28u
X1126 VREFP A44_DCTRL_STRIP_W_R2_0/CTRL_OUT[6] A44_CDAC_CAP_BANK_ASSEMBLY_R8_M6_0/A44_CAP_CORE128_M6_R1_0/CAP_BOTTOM_046 VDD pfet_03v3 ad=0 pd=0 as=0 ps=0 w=1.56u l=0.28u
X1127 VREFP A44_DCTRL_STRIP_W_R2_0/CTRL_OUT[6] A44_CDAC_CAP_BANK_ASSEMBLY_R8_M6_0/A44_CAP_CORE128_M6_R1_0/CAP_BOTTOM_046 VDD pfet_03v3 ad=0 pd=0 as=0 ps=0 w=1.56u l=0.28u
X1128 VREFP A44_DCTRL_STRIP_W_R2_0/CTRL_OUT[6] A44_CDAC_CAP_BANK_ASSEMBLY_R8_M6_0/A44_CAP_CORE128_M6_R1_0/CAP_BOTTOM_046 VDD pfet_03v3 ad=0 pd=0 as=0 ps=0 w=1.56u l=0.28u
X1129 VREFP A44_DCTRL_STRIP_W_R2_0/CTRL_OUT[6] A44_CDAC_CAP_BANK_ASSEMBLY_R8_M6_0/A44_CAP_CORE128_M6_R1_0/CAP_BOTTOM_046 VDD pfet_03v3 ad=0 pd=0 as=0 ps=0 w=1.56u l=0.28u
X1130 VREFP A44_DCTRL_STRIP_W_R2_0/CTRL_OUT[6] A44_CDAC_CAP_BANK_ASSEMBLY_R8_M6_0/A44_CAP_CORE128_M6_R1_0/CAP_BOTTOM_046 VDD pfet_03v3 ad=0 pd=0 as=0 ps=0 w=1.56u l=0.28u
X1131 VREFP A44_DCTRL_STRIP_W_R2_0/CTRL_OUT[6] A44_CDAC_CAP_BANK_ASSEMBLY_R8_M6_0/A44_CAP_CORE128_M6_R1_0/CAP_BOTTOM_046 VDD pfet_03v3 ad=0 pd=0 as=0 ps=0 w=1.56u l=0.28u
X1132 VREFP A44_DCTRL_STRIP_W_R2_0/CTRL_OUT[6] A44_CDAC_CAP_BANK_ASSEMBLY_R8_M6_0/A44_CAP_CORE128_M6_R1_0/CAP_BOTTOM_046 VDD pfet_03v3 ad=0 pd=0 as=0 ps=0 w=1.56u l=0.28u
X1133 VREFP A44_DCTRL_STRIP_W_R2_0/CTRL_OUT[6] A44_CDAC_CAP_BANK_ASSEMBLY_R8_M6_0/A44_CAP_CORE128_M6_R1_0/CAP_BOTTOM_046 VDD pfet_03v3 ad=0 pd=0 as=0 ps=0 w=1.56u l=0.28u
X1134 VREFP A44_DCTRL_STRIP_W_R2_0/CTRL_OUT[6] A44_CDAC_CAP_BANK_ASSEMBLY_R8_M6_0/A44_CAP_CORE128_M6_R1_0/CAP_BOTTOM_046 VDD pfet_03v3 ad=0 pd=0 as=0 ps=0 w=1.56u l=0.28u
X1135 VREFP A44_DCTRL_STRIP_W_R2_0/CTRL_OUT[6] A44_CDAC_CAP_BANK_ASSEMBLY_R8_M6_0/A44_CAP_CORE128_M6_R1_0/CAP_BOTTOM_046 VDD pfet_03v3 ad=0 pd=0 as=0 ps=0 w=1.56u l=0.28u
X1136 VREFN A44_DCTRL_STRIP_W_R2_0/CTRL_OUT[6] A44_CDAC_CAP_BANK_ASSEMBLY_R8_M6_0/A44_CAP_CORE128_M6_R1_0/CAP_BOTTOM_046 GND nfet_03v3 ad=0 pd=0 as=16.6842p ps=77.76u w=1.56u l=0.28u
X1137 VREFN A44_DCTRL_STRIP_W_R2_0/CTRL_OUT[6] A44_CDAC_CAP_BANK_ASSEMBLY_R8_M6_0/A44_CAP_CORE128_M6_R1_0/CAP_BOTTOM_046 GND nfet_03v3 ad=0 pd=0 as=0 ps=0 w=1.56u l=0.28u
X1138 VREFN A44_DCTRL_STRIP_W_R2_0/CTRL_OUT[6] A44_CDAC_CAP_BANK_ASSEMBLY_R8_M6_0/A44_CAP_CORE128_M6_R1_0/CAP_BOTTOM_046 GND nfet_03v3 ad=0 pd=0 as=0 ps=0 w=1.56u l=0.28u
X1139 VREFN A44_DCTRL_STRIP_W_R2_0/CTRL_OUT[6] A44_CDAC_CAP_BANK_ASSEMBLY_R8_M6_0/A44_CAP_CORE128_M6_R1_0/CAP_BOTTOM_046 GND nfet_03v3 ad=0 pd=0 as=0 ps=0 w=1.56u l=0.28u
X1140 VREFN A44_DCTRL_STRIP_W_R2_0/CTRL_OUT[6] A44_CDAC_CAP_BANK_ASSEMBLY_R8_M6_0/A44_CAP_CORE128_M6_R1_0/CAP_BOTTOM_046 GND nfet_03v3 ad=0 pd=0 as=0 ps=0 w=1.56u l=0.28u
X1141 VREFN A44_DCTRL_STRIP_W_R2_0/CTRL_OUT[6] A44_CDAC_CAP_BANK_ASSEMBLY_R8_M6_0/A44_CAP_CORE128_M6_R1_0/CAP_BOTTOM_046 GND nfet_03v3 ad=0 pd=0 as=0 ps=0 w=1.56u l=0.28u
X1142 VREFN A44_DCTRL_STRIP_W_R2_0/CTRL_OUT[6] A44_CDAC_CAP_BANK_ASSEMBLY_R8_M6_0/A44_CAP_CORE128_M6_R1_0/CAP_BOTTOM_046 GND nfet_03v3 ad=0 pd=0 as=0 ps=0 w=1.56u l=0.28u
X1143 VREFN A44_DCTRL_STRIP_W_R2_0/CTRL_OUT[6] A44_CDAC_CAP_BANK_ASSEMBLY_R8_M6_0/A44_CAP_CORE128_M6_R1_0/CAP_BOTTOM_046 GND nfet_03v3 ad=0 pd=0 as=0 ps=0 w=1.56u l=0.28u
X1144 VREFN A44_DCTRL_STRIP_W_R2_0/CTRL_OUT[6] A44_CDAC_CAP_BANK_ASSEMBLY_R8_M6_0/A44_CAP_CORE128_M6_R1_0/CAP_BOTTOM_046 GND nfet_03v3 ad=0 pd=0 as=0 ps=0 w=1.56u l=0.28u
X1145 VREFN A44_DCTRL_STRIP_W_R2_0/CTRL_OUT[6] A44_CDAC_CAP_BANK_ASSEMBLY_R8_M6_0/A44_CAP_CORE128_M6_R1_0/CAP_BOTTOM_046 GND nfet_03v3 ad=0 pd=0 as=0 ps=0 w=1.56u l=0.28u
X1146 VREFN A44_DCTRL_STRIP_W_R2_0/CTRL_OUT[6] A44_CDAC_CAP_BANK_ASSEMBLY_R8_M6_0/A44_CAP_CORE128_M6_R1_0/CAP_BOTTOM_046 GND nfet_03v3 ad=0 pd=0 as=0 ps=0 w=1.56u l=0.28u
X1147 VREFN A44_DCTRL_STRIP_W_R2_0/CTRL_OUT[6] A44_CDAC_CAP_BANK_ASSEMBLY_R8_M6_0/A44_CAP_CORE128_M6_R1_0/CAP_BOTTOM_046 GND nfet_03v3 ad=0 pd=0 as=0 ps=0 w=1.56u l=0.28u
X1148 VREFN A44_DCTRL_STRIP_W_R2_0/CTRL_OUT[6] A44_CDAC_CAP_BANK_ASSEMBLY_R8_M6_0/A44_CAP_CORE128_M6_R1_0/CAP_BOTTOM_046 GND nfet_03v3 ad=0 pd=0 as=0 ps=0 w=1.56u l=0.28u
X1149 VREFN A44_DCTRL_STRIP_W_R2_0/CTRL_OUT[6] A44_CDAC_CAP_BANK_ASSEMBLY_R8_M6_0/A44_CAP_CORE128_M6_R1_0/CAP_BOTTOM_046 GND nfet_03v3 ad=0 pd=0 as=0 ps=0 w=1.56u l=0.28u
X1150 VREFN A44_DCTRL_STRIP_W_R2_0/CTRL_OUT[6] A44_CDAC_CAP_BANK_ASSEMBLY_R8_M6_0/A44_CAP_CORE128_M6_R1_0/CAP_BOTTOM_046 GND nfet_03v3 ad=0 pd=0 as=0 ps=0 w=1.56u l=0.28u
X1151 VREFN A44_DCTRL_STRIP_W_R2_0/CTRL_OUT[6] A44_CDAC_CAP_BANK_ASSEMBLY_R8_M6_0/A44_CAP_CORE128_M6_R1_0/CAP_BOTTOM_046 GND nfet_03v3 ad=0 pd=0 as=0 ps=0 w=1.56u l=0.28u
X1152 VREFN A44_DCTRL_STRIP_W_R2_0/CTRL_OUT[6] A44_CDAC_CAP_BANK_ASSEMBLY_R8_M6_0/A44_CAP_CORE128_M6_R1_0/CAP_BOTTOM_046 GND nfet_03v3 ad=0 pd=0 as=0 ps=0 w=1.56u l=0.28u
X1153 VREFN A44_DCTRL_STRIP_W_R2_0/CTRL_OUT[6] A44_CDAC_CAP_BANK_ASSEMBLY_R8_M6_0/A44_CAP_CORE128_M6_R1_0/CAP_BOTTOM_046 GND nfet_03v3 ad=0 pd=0 as=0 ps=0 w=1.56u l=0.28u
X1154 VREFP A44_DCTRL_STRIP_W_R2_0/CTRL_OUT[7] A44_CDAC_CAP_BANK_ASSEMBLY_R8_M6_0/A44_CAP_CORE128_M6_R1_0/CAP_BOTTOM_010 VDD pfet_03v3 ad=0 pd=0 as=16.6842p ps=77.76u w=1.56u l=0.28u
X1155 VREFP A44_DCTRL_STRIP_W_R2_0/CTRL_OUT[7] A44_CDAC_CAP_BANK_ASSEMBLY_R8_M6_0/A44_CAP_CORE128_M6_R1_0/CAP_BOTTOM_010 VDD pfet_03v3 ad=0 pd=0 as=0 ps=0 w=1.56u l=0.28u
X1156 VREFP A44_DCTRL_STRIP_W_R2_0/CTRL_OUT[7] A44_CDAC_CAP_BANK_ASSEMBLY_R8_M6_0/A44_CAP_CORE128_M6_R1_0/CAP_BOTTOM_010 VDD pfet_03v3 ad=0 pd=0 as=0 ps=0 w=1.56u l=0.28u
X1157 VREFP A44_DCTRL_STRIP_W_R2_0/CTRL_OUT[7] A44_CDAC_CAP_BANK_ASSEMBLY_R8_M6_0/A44_CAP_CORE128_M6_R1_0/CAP_BOTTOM_010 VDD pfet_03v3 ad=0 pd=0 as=0 ps=0 w=1.56u l=0.28u
X1158 VREFP A44_DCTRL_STRIP_W_R2_0/CTRL_OUT[7] A44_CDAC_CAP_BANK_ASSEMBLY_R8_M6_0/A44_CAP_CORE128_M6_R1_0/CAP_BOTTOM_010 VDD pfet_03v3 ad=0 pd=0 as=0 ps=0 w=1.56u l=0.28u
X1159 VREFP A44_DCTRL_STRIP_W_R2_0/CTRL_OUT[7] A44_CDAC_CAP_BANK_ASSEMBLY_R8_M6_0/A44_CAP_CORE128_M6_R1_0/CAP_BOTTOM_010 VDD pfet_03v3 ad=0 pd=0 as=0 ps=0 w=1.56u l=0.28u
X1160 VREFP A44_DCTRL_STRIP_W_R2_0/CTRL_OUT[7] A44_CDAC_CAP_BANK_ASSEMBLY_R8_M6_0/A44_CAP_CORE128_M6_R1_0/CAP_BOTTOM_010 VDD pfet_03v3 ad=0 pd=0 as=0 ps=0 w=1.56u l=0.28u
X1161 VREFP A44_DCTRL_STRIP_W_R2_0/CTRL_OUT[7] A44_CDAC_CAP_BANK_ASSEMBLY_R8_M6_0/A44_CAP_CORE128_M6_R1_0/CAP_BOTTOM_010 VDD pfet_03v3 ad=0 pd=0 as=0 ps=0 w=1.56u l=0.28u
X1162 VREFP A44_DCTRL_STRIP_W_R2_0/CTRL_OUT[7] A44_CDAC_CAP_BANK_ASSEMBLY_R8_M6_0/A44_CAP_CORE128_M6_R1_0/CAP_BOTTOM_010 VDD pfet_03v3 ad=0 pd=0 as=0 ps=0 w=1.56u l=0.28u
X1163 VREFP A44_DCTRL_STRIP_W_R2_0/CTRL_OUT[7] A44_CDAC_CAP_BANK_ASSEMBLY_R8_M6_0/A44_CAP_CORE128_M6_R1_0/CAP_BOTTOM_010 VDD pfet_03v3 ad=0 pd=0 as=0 ps=0 w=1.56u l=0.28u
X1164 VREFP A44_DCTRL_STRIP_W_R2_0/CTRL_OUT[7] A44_CDAC_CAP_BANK_ASSEMBLY_R8_M6_0/A44_CAP_CORE128_M6_R1_0/CAP_BOTTOM_010 VDD pfet_03v3 ad=0 pd=0 as=0 ps=0 w=1.56u l=0.28u
X1165 VREFP A44_DCTRL_STRIP_W_R2_0/CTRL_OUT[7] A44_CDAC_CAP_BANK_ASSEMBLY_R8_M6_0/A44_CAP_CORE128_M6_R1_0/CAP_BOTTOM_010 VDD pfet_03v3 ad=0 pd=0 as=0 ps=0 w=1.56u l=0.28u
X1166 VREFP A44_DCTRL_STRIP_W_R2_0/CTRL_OUT[7] A44_CDAC_CAP_BANK_ASSEMBLY_R8_M6_0/A44_CAP_CORE128_M6_R1_0/CAP_BOTTOM_010 VDD pfet_03v3 ad=0 pd=0 as=0 ps=0 w=1.56u l=0.28u
X1167 VREFP A44_DCTRL_STRIP_W_R2_0/CTRL_OUT[7] A44_CDAC_CAP_BANK_ASSEMBLY_R8_M6_0/A44_CAP_CORE128_M6_R1_0/CAP_BOTTOM_010 VDD pfet_03v3 ad=0 pd=0 as=0 ps=0 w=1.56u l=0.28u
X1168 VREFP A44_DCTRL_STRIP_W_R2_0/CTRL_OUT[7] A44_CDAC_CAP_BANK_ASSEMBLY_R8_M6_0/A44_CAP_CORE128_M6_R1_0/CAP_BOTTOM_010 VDD pfet_03v3 ad=0 pd=0 as=0 ps=0 w=1.56u l=0.28u
X1169 VREFP A44_DCTRL_STRIP_W_R2_0/CTRL_OUT[7] A44_CDAC_CAP_BANK_ASSEMBLY_R8_M6_0/A44_CAP_CORE128_M6_R1_0/CAP_BOTTOM_010 VDD pfet_03v3 ad=0 pd=0 as=0 ps=0 w=1.56u l=0.28u
X1170 VREFP A44_DCTRL_STRIP_W_R2_0/CTRL_OUT[7] A44_CDAC_CAP_BANK_ASSEMBLY_R8_M6_0/A44_CAP_CORE128_M6_R1_0/CAP_BOTTOM_010 VDD pfet_03v3 ad=0 pd=0 as=0 ps=0 w=1.56u l=0.28u
X1171 VREFP A44_DCTRL_STRIP_W_R2_0/CTRL_OUT[7] A44_CDAC_CAP_BANK_ASSEMBLY_R8_M6_0/A44_CAP_CORE128_M6_R1_0/CAP_BOTTOM_010 VDD pfet_03v3 ad=0 pd=0 as=0 ps=0 w=1.56u l=0.28u
X1172 VREFN A44_DCTRL_STRIP_W_R2_0/CTRL_OUT[7] A44_CDAC_CAP_BANK_ASSEMBLY_R8_M6_0/A44_CAP_CORE128_M6_R1_0/CAP_BOTTOM_010 GND nfet_03v3 ad=0 pd=0 as=16.6842p ps=77.76u w=1.56u l=0.28u
X1173 VREFN A44_DCTRL_STRIP_W_R2_0/CTRL_OUT[7] A44_CDAC_CAP_BANK_ASSEMBLY_R8_M6_0/A44_CAP_CORE128_M6_R1_0/CAP_BOTTOM_010 GND nfet_03v3 ad=0 pd=0 as=0 ps=0 w=1.56u l=0.28u
X1174 VREFN A44_DCTRL_STRIP_W_R2_0/CTRL_OUT[7] A44_CDAC_CAP_BANK_ASSEMBLY_R8_M6_0/A44_CAP_CORE128_M6_R1_0/CAP_BOTTOM_010 GND nfet_03v3 ad=0 pd=0 as=0 ps=0 w=1.56u l=0.28u
X1175 VREFN A44_DCTRL_STRIP_W_R2_0/CTRL_OUT[7] A44_CDAC_CAP_BANK_ASSEMBLY_R8_M6_0/A44_CAP_CORE128_M6_R1_0/CAP_BOTTOM_010 GND nfet_03v3 ad=0 pd=0 as=0 ps=0 w=1.56u l=0.28u
X1176 VREFN A44_DCTRL_STRIP_W_R2_0/CTRL_OUT[7] A44_CDAC_CAP_BANK_ASSEMBLY_R8_M6_0/A44_CAP_CORE128_M6_R1_0/CAP_BOTTOM_010 GND nfet_03v3 ad=0 pd=0 as=0 ps=0 w=1.56u l=0.28u
X1177 VREFN A44_DCTRL_STRIP_W_R2_0/CTRL_OUT[7] A44_CDAC_CAP_BANK_ASSEMBLY_R8_M6_0/A44_CAP_CORE128_M6_R1_0/CAP_BOTTOM_010 GND nfet_03v3 ad=0 pd=0 as=0 ps=0 w=1.56u l=0.28u
X1178 VREFN A44_DCTRL_STRIP_W_R2_0/CTRL_OUT[7] A44_CDAC_CAP_BANK_ASSEMBLY_R8_M6_0/A44_CAP_CORE128_M6_R1_0/CAP_BOTTOM_010 GND nfet_03v3 ad=0 pd=0 as=0 ps=0 w=1.56u l=0.28u
X1179 VREFN A44_DCTRL_STRIP_W_R2_0/CTRL_OUT[7] A44_CDAC_CAP_BANK_ASSEMBLY_R8_M6_0/A44_CAP_CORE128_M6_R1_0/CAP_BOTTOM_010 GND nfet_03v3 ad=0 pd=0 as=0 ps=0 w=1.56u l=0.28u
X1180 VREFN A44_DCTRL_STRIP_W_R2_0/CTRL_OUT[7] A44_CDAC_CAP_BANK_ASSEMBLY_R8_M6_0/A44_CAP_CORE128_M6_R1_0/CAP_BOTTOM_010 GND nfet_03v3 ad=0 pd=0 as=0 ps=0 w=1.56u l=0.28u
X1181 VREFN A44_DCTRL_STRIP_W_R2_0/CTRL_OUT[7] A44_CDAC_CAP_BANK_ASSEMBLY_R8_M6_0/A44_CAP_CORE128_M6_R1_0/CAP_BOTTOM_010 GND nfet_03v3 ad=0 pd=0 as=0 ps=0 w=1.56u l=0.28u
X1182 VREFN A44_DCTRL_STRIP_W_R2_0/CTRL_OUT[7] A44_CDAC_CAP_BANK_ASSEMBLY_R8_M6_0/A44_CAP_CORE128_M6_R1_0/CAP_BOTTOM_010 GND nfet_03v3 ad=0 pd=0 as=0 ps=0 w=1.56u l=0.28u
X1183 VREFN A44_DCTRL_STRIP_W_R2_0/CTRL_OUT[7] A44_CDAC_CAP_BANK_ASSEMBLY_R8_M6_0/A44_CAP_CORE128_M6_R1_0/CAP_BOTTOM_010 GND nfet_03v3 ad=0 pd=0 as=0 ps=0 w=1.56u l=0.28u
X1184 VREFN A44_DCTRL_STRIP_W_R2_0/CTRL_OUT[7] A44_CDAC_CAP_BANK_ASSEMBLY_R8_M6_0/A44_CAP_CORE128_M6_R1_0/CAP_BOTTOM_010 GND nfet_03v3 ad=0 pd=0 as=0 ps=0 w=1.56u l=0.28u
X1185 VREFN A44_DCTRL_STRIP_W_R2_0/CTRL_OUT[7] A44_CDAC_CAP_BANK_ASSEMBLY_R8_M6_0/A44_CAP_CORE128_M6_R1_0/CAP_BOTTOM_010 GND nfet_03v3 ad=0 pd=0 as=0 ps=0 w=1.56u l=0.28u
X1186 VREFN A44_DCTRL_STRIP_W_R2_0/CTRL_OUT[7] A44_CDAC_CAP_BANK_ASSEMBLY_R8_M6_0/A44_CAP_CORE128_M6_R1_0/CAP_BOTTOM_010 GND nfet_03v3 ad=0 pd=0 as=0 ps=0 w=1.56u l=0.28u
X1187 VREFN A44_DCTRL_STRIP_W_R2_0/CTRL_OUT[7] A44_CDAC_CAP_BANK_ASSEMBLY_R8_M6_0/A44_CAP_CORE128_M6_R1_0/CAP_BOTTOM_010 GND nfet_03v3 ad=0 pd=0 as=0 ps=0 w=1.56u l=0.28u
X1188 VREFN A44_DCTRL_STRIP_W_R2_0/CTRL_OUT[7] A44_CDAC_CAP_BANK_ASSEMBLY_R8_M6_0/A44_CAP_CORE128_M6_R1_0/CAP_BOTTOM_010 GND nfet_03v3 ad=0 pd=0 as=0 ps=0 w=1.56u l=0.28u
X1189 VREFN A44_DCTRL_STRIP_W_R2_0/CTRL_OUT[7] A44_CDAC_CAP_BANK_ASSEMBLY_R8_M6_0/A44_CAP_CORE128_M6_R1_0/CAP_BOTTOM_010 GND nfet_03v3 ad=0 pd=0 as=0 ps=0 w=1.56u l=0.28u
X1190 VREFP A44_DCTRL_STRIP_W_R2_0/CTRL_OUT[5] A44_CDAC_CAP_BANK_ASSEMBLY_R8_M6_0/A44_CAP_CORE128_M6_R1_0/CAP_BOTTOM_036 VDD pfet_03v3 ad=0 pd=0 as=16.6842p ps=77.76u w=1.56u l=0.28u
X1191 VREFP A44_DCTRL_STRIP_W_R2_0/CTRL_OUT[5] A44_CDAC_CAP_BANK_ASSEMBLY_R8_M6_0/A44_CAP_CORE128_M6_R1_0/CAP_BOTTOM_036 VDD pfet_03v3 ad=0 pd=0 as=0 ps=0 w=1.56u l=0.28u
X1192 VREFP A44_DCTRL_STRIP_W_R2_0/CTRL_OUT[5] A44_CDAC_CAP_BANK_ASSEMBLY_R8_M6_0/A44_CAP_CORE128_M6_R1_0/CAP_BOTTOM_036 VDD pfet_03v3 ad=0 pd=0 as=0 ps=0 w=1.56u l=0.28u
X1193 VREFP A44_DCTRL_STRIP_W_R2_0/CTRL_OUT[5] A44_CDAC_CAP_BANK_ASSEMBLY_R8_M6_0/A44_CAP_CORE128_M6_R1_0/CAP_BOTTOM_036 VDD pfet_03v3 ad=0 pd=0 as=0 ps=0 w=1.56u l=0.28u
X1194 VREFP A44_DCTRL_STRIP_W_R2_0/CTRL_OUT[5] A44_CDAC_CAP_BANK_ASSEMBLY_R8_M6_0/A44_CAP_CORE128_M6_R1_0/CAP_BOTTOM_036 VDD pfet_03v3 ad=0 pd=0 as=0 ps=0 w=1.56u l=0.28u
X1195 VREFP A44_DCTRL_STRIP_W_R2_0/CTRL_OUT[5] A44_CDAC_CAP_BANK_ASSEMBLY_R8_M6_0/A44_CAP_CORE128_M6_R1_0/CAP_BOTTOM_036 VDD pfet_03v3 ad=0 pd=0 as=0 ps=0 w=1.56u l=0.28u
X1196 VREFP A44_DCTRL_STRIP_W_R2_0/CTRL_OUT[5] A44_CDAC_CAP_BANK_ASSEMBLY_R8_M6_0/A44_CAP_CORE128_M6_R1_0/CAP_BOTTOM_036 VDD pfet_03v3 ad=0 pd=0 as=0 ps=0 w=1.56u l=0.28u
X1197 VREFP A44_DCTRL_STRIP_W_R2_0/CTRL_OUT[5] A44_CDAC_CAP_BANK_ASSEMBLY_R8_M6_0/A44_CAP_CORE128_M6_R1_0/CAP_BOTTOM_036 VDD pfet_03v3 ad=0 pd=0 as=0 ps=0 w=1.56u l=0.28u
X1198 VREFP A44_DCTRL_STRIP_W_R2_0/CTRL_OUT[5] A44_CDAC_CAP_BANK_ASSEMBLY_R8_M6_0/A44_CAP_CORE128_M6_R1_0/CAP_BOTTOM_036 VDD pfet_03v3 ad=0 pd=0 as=0 ps=0 w=1.56u l=0.28u
X1199 VREFP A44_DCTRL_STRIP_W_R2_0/CTRL_OUT[5] A44_CDAC_CAP_BANK_ASSEMBLY_R8_M6_0/A44_CAP_CORE128_M6_R1_0/CAP_BOTTOM_036 VDD pfet_03v3 ad=0 pd=0 as=0 ps=0 w=1.56u l=0.28u
X1200 VREFP A44_DCTRL_STRIP_W_R2_0/CTRL_OUT[5] A44_CDAC_CAP_BANK_ASSEMBLY_R8_M6_0/A44_CAP_CORE128_M6_R1_0/CAP_BOTTOM_036 VDD pfet_03v3 ad=0 pd=0 as=0 ps=0 w=1.56u l=0.28u
X1201 VREFP A44_DCTRL_STRIP_W_R2_0/CTRL_OUT[5] A44_CDAC_CAP_BANK_ASSEMBLY_R8_M6_0/A44_CAP_CORE128_M6_R1_0/CAP_BOTTOM_036 VDD pfet_03v3 ad=0 pd=0 as=0 ps=0 w=1.56u l=0.28u
X1202 VREFP A44_DCTRL_STRIP_W_R2_0/CTRL_OUT[5] A44_CDAC_CAP_BANK_ASSEMBLY_R8_M6_0/A44_CAP_CORE128_M6_R1_0/CAP_BOTTOM_036 VDD pfet_03v3 ad=0 pd=0 as=0 ps=0 w=1.56u l=0.28u
X1203 VREFP A44_DCTRL_STRIP_W_R2_0/CTRL_OUT[5] A44_CDAC_CAP_BANK_ASSEMBLY_R8_M6_0/A44_CAP_CORE128_M6_R1_0/CAP_BOTTOM_036 VDD pfet_03v3 ad=0 pd=0 as=0 ps=0 w=1.56u l=0.28u
X1204 VREFP A44_DCTRL_STRIP_W_R2_0/CTRL_OUT[5] A44_CDAC_CAP_BANK_ASSEMBLY_R8_M6_0/A44_CAP_CORE128_M6_R1_0/CAP_BOTTOM_036 VDD pfet_03v3 ad=0 pd=0 as=0 ps=0 w=1.56u l=0.28u
X1205 VREFP A44_DCTRL_STRIP_W_R2_0/CTRL_OUT[5] A44_CDAC_CAP_BANK_ASSEMBLY_R8_M6_0/A44_CAP_CORE128_M6_R1_0/CAP_BOTTOM_036 VDD pfet_03v3 ad=0 pd=0 as=0 ps=0 w=1.56u l=0.28u
X1206 VREFP A44_DCTRL_STRIP_W_R2_0/CTRL_OUT[5] A44_CDAC_CAP_BANK_ASSEMBLY_R8_M6_0/A44_CAP_CORE128_M6_R1_0/CAP_BOTTOM_036 VDD pfet_03v3 ad=0 pd=0 as=0 ps=0 w=1.56u l=0.28u
X1207 VREFP A44_DCTRL_STRIP_W_R2_0/CTRL_OUT[5] A44_CDAC_CAP_BANK_ASSEMBLY_R8_M6_0/A44_CAP_CORE128_M6_R1_0/CAP_BOTTOM_036 VDD pfet_03v3 ad=0 pd=0 as=0 ps=0 w=1.56u l=0.28u
X1208 VREFN A44_DCTRL_STRIP_W_R2_0/CTRL_OUT[5] A44_CDAC_CAP_BANK_ASSEMBLY_R8_M6_0/A44_CAP_CORE128_M6_R1_0/CAP_BOTTOM_036 GND nfet_03v3 ad=0 pd=0 as=16.6842p ps=77.76u w=1.56u l=0.28u
X1209 VREFN A44_DCTRL_STRIP_W_R2_0/CTRL_OUT[5] A44_CDAC_CAP_BANK_ASSEMBLY_R8_M6_0/A44_CAP_CORE128_M6_R1_0/CAP_BOTTOM_036 GND nfet_03v3 ad=0 pd=0 as=0 ps=0 w=1.56u l=0.28u
X1210 VREFN A44_DCTRL_STRIP_W_R2_0/CTRL_OUT[5] A44_CDAC_CAP_BANK_ASSEMBLY_R8_M6_0/A44_CAP_CORE128_M6_R1_0/CAP_BOTTOM_036 GND nfet_03v3 ad=0 pd=0 as=0 ps=0 w=1.56u l=0.28u
X1211 VREFN A44_DCTRL_STRIP_W_R2_0/CTRL_OUT[5] A44_CDAC_CAP_BANK_ASSEMBLY_R8_M6_0/A44_CAP_CORE128_M6_R1_0/CAP_BOTTOM_036 GND nfet_03v3 ad=0 pd=0 as=0 ps=0 w=1.56u l=0.28u
X1212 VREFN A44_DCTRL_STRIP_W_R2_0/CTRL_OUT[5] A44_CDAC_CAP_BANK_ASSEMBLY_R8_M6_0/A44_CAP_CORE128_M6_R1_0/CAP_BOTTOM_036 GND nfet_03v3 ad=0 pd=0 as=0 ps=0 w=1.56u l=0.28u
X1213 VREFN A44_DCTRL_STRIP_W_R2_0/CTRL_OUT[5] A44_CDAC_CAP_BANK_ASSEMBLY_R8_M6_0/A44_CAP_CORE128_M6_R1_0/CAP_BOTTOM_036 GND nfet_03v3 ad=0 pd=0 as=0 ps=0 w=1.56u l=0.28u
X1214 VREFN A44_DCTRL_STRIP_W_R2_0/CTRL_OUT[5] A44_CDAC_CAP_BANK_ASSEMBLY_R8_M6_0/A44_CAP_CORE128_M6_R1_0/CAP_BOTTOM_036 GND nfet_03v3 ad=0 pd=0 as=0 ps=0 w=1.56u l=0.28u
X1215 VREFN A44_DCTRL_STRIP_W_R2_0/CTRL_OUT[5] A44_CDAC_CAP_BANK_ASSEMBLY_R8_M6_0/A44_CAP_CORE128_M6_R1_0/CAP_BOTTOM_036 GND nfet_03v3 ad=0 pd=0 as=0 ps=0 w=1.56u l=0.28u
X1216 VREFN A44_DCTRL_STRIP_W_R2_0/CTRL_OUT[5] A44_CDAC_CAP_BANK_ASSEMBLY_R8_M6_0/A44_CAP_CORE128_M6_R1_0/CAP_BOTTOM_036 GND nfet_03v3 ad=0 pd=0 as=0 ps=0 w=1.56u l=0.28u
X1217 VREFN A44_DCTRL_STRIP_W_R2_0/CTRL_OUT[5] A44_CDAC_CAP_BANK_ASSEMBLY_R8_M6_0/A44_CAP_CORE128_M6_R1_0/CAP_BOTTOM_036 GND nfet_03v3 ad=0 pd=0 as=0 ps=0 w=1.56u l=0.28u
X1218 VREFN A44_DCTRL_STRIP_W_R2_0/CTRL_OUT[5] A44_CDAC_CAP_BANK_ASSEMBLY_R8_M6_0/A44_CAP_CORE128_M6_R1_0/CAP_BOTTOM_036 GND nfet_03v3 ad=0 pd=0 as=0 ps=0 w=1.56u l=0.28u
X1219 VREFN A44_DCTRL_STRIP_W_R2_0/CTRL_OUT[5] A44_CDAC_CAP_BANK_ASSEMBLY_R8_M6_0/A44_CAP_CORE128_M6_R1_0/CAP_BOTTOM_036 GND nfet_03v3 ad=0 pd=0 as=0 ps=0 w=1.56u l=0.28u
X1220 VREFN A44_DCTRL_STRIP_W_R2_0/CTRL_OUT[5] A44_CDAC_CAP_BANK_ASSEMBLY_R8_M6_0/A44_CAP_CORE128_M6_R1_0/CAP_BOTTOM_036 GND nfet_03v3 ad=0 pd=0 as=0 ps=0 w=1.56u l=0.28u
X1221 VREFN A44_DCTRL_STRIP_W_R2_0/CTRL_OUT[5] A44_CDAC_CAP_BANK_ASSEMBLY_R8_M6_0/A44_CAP_CORE128_M6_R1_0/CAP_BOTTOM_036 GND nfet_03v3 ad=0 pd=0 as=0 ps=0 w=1.56u l=0.28u
X1222 VREFN A44_DCTRL_STRIP_W_R2_0/CTRL_OUT[5] A44_CDAC_CAP_BANK_ASSEMBLY_R8_M6_0/A44_CAP_CORE128_M6_R1_0/CAP_BOTTOM_036 GND nfet_03v3 ad=0 pd=0 as=0 ps=0 w=1.56u l=0.28u
X1223 VREFN A44_DCTRL_STRIP_W_R2_0/CTRL_OUT[5] A44_CDAC_CAP_BANK_ASSEMBLY_R8_M6_0/A44_CAP_CORE128_M6_R1_0/CAP_BOTTOM_036 GND nfet_03v3 ad=0 pd=0 as=0 ps=0 w=1.56u l=0.28u
X1224 VREFN A44_DCTRL_STRIP_W_R2_0/CTRL_OUT[5] A44_CDAC_CAP_BANK_ASSEMBLY_R8_M6_0/A44_CAP_CORE128_M6_R1_0/CAP_BOTTOM_036 GND nfet_03v3 ad=0 pd=0 as=0 ps=0 w=1.56u l=0.28u
X1225 VREFN A44_DCTRL_STRIP_W_R2_0/CTRL_OUT[5] A44_CDAC_CAP_BANK_ASSEMBLY_R8_M6_0/A44_CAP_CORE128_M6_R1_0/CAP_BOTTOM_036 GND nfet_03v3 ad=0 pd=0 as=0 ps=0 w=1.56u l=0.28u
X1226 VREFP A44_DCTRL_STRIP_W_R2_0/CTRL_OUT[7] A44_CDAC_CAP_BANK_ASSEMBLY_R8_M6_0/A44_CAP_CORE128_M6_R1_0/CAP_BOTTOM_060 VDD pfet_03v3 ad=0 pd=0 as=16.6842p ps=77.76u w=1.56u l=0.28u
X1227 VREFP A44_DCTRL_STRIP_W_R2_0/CTRL_OUT[7] A44_CDAC_CAP_BANK_ASSEMBLY_R8_M6_0/A44_CAP_CORE128_M6_R1_0/CAP_BOTTOM_060 VDD pfet_03v3 ad=0 pd=0 as=0 ps=0 w=1.56u l=0.28u
X1228 VREFP A44_DCTRL_STRIP_W_R2_0/CTRL_OUT[7] A44_CDAC_CAP_BANK_ASSEMBLY_R8_M6_0/A44_CAP_CORE128_M6_R1_0/CAP_BOTTOM_060 VDD pfet_03v3 ad=0 pd=0 as=0 ps=0 w=1.56u l=0.28u
X1229 VREFP A44_DCTRL_STRIP_W_R2_0/CTRL_OUT[7] A44_CDAC_CAP_BANK_ASSEMBLY_R8_M6_0/A44_CAP_CORE128_M6_R1_0/CAP_BOTTOM_060 VDD pfet_03v3 ad=0 pd=0 as=0 ps=0 w=1.56u l=0.28u
X1230 VREFP A44_DCTRL_STRIP_W_R2_0/CTRL_OUT[7] A44_CDAC_CAP_BANK_ASSEMBLY_R8_M6_0/A44_CAP_CORE128_M6_R1_0/CAP_BOTTOM_060 VDD pfet_03v3 ad=0 pd=0 as=0 ps=0 w=1.56u l=0.28u
X1231 VREFP A44_DCTRL_STRIP_W_R2_0/CTRL_OUT[7] A44_CDAC_CAP_BANK_ASSEMBLY_R8_M6_0/A44_CAP_CORE128_M6_R1_0/CAP_BOTTOM_060 VDD pfet_03v3 ad=0 pd=0 as=0 ps=0 w=1.56u l=0.28u
X1232 VREFP A44_DCTRL_STRIP_W_R2_0/CTRL_OUT[7] A44_CDAC_CAP_BANK_ASSEMBLY_R8_M6_0/A44_CAP_CORE128_M6_R1_0/CAP_BOTTOM_060 VDD pfet_03v3 ad=0 pd=0 as=0 ps=0 w=1.56u l=0.28u
X1233 VREFP A44_DCTRL_STRIP_W_R2_0/CTRL_OUT[7] A44_CDAC_CAP_BANK_ASSEMBLY_R8_M6_0/A44_CAP_CORE128_M6_R1_0/CAP_BOTTOM_060 VDD pfet_03v3 ad=0 pd=0 as=0 ps=0 w=1.56u l=0.28u
X1234 VREFP A44_DCTRL_STRIP_W_R2_0/CTRL_OUT[7] A44_CDAC_CAP_BANK_ASSEMBLY_R8_M6_0/A44_CAP_CORE128_M6_R1_0/CAP_BOTTOM_060 VDD pfet_03v3 ad=0 pd=0 as=0 ps=0 w=1.56u l=0.28u
X1235 VREFP A44_DCTRL_STRIP_W_R2_0/CTRL_OUT[7] A44_CDAC_CAP_BANK_ASSEMBLY_R8_M6_0/A44_CAP_CORE128_M6_R1_0/CAP_BOTTOM_060 VDD pfet_03v3 ad=0 pd=0 as=0 ps=0 w=1.56u l=0.28u
X1236 VREFP A44_DCTRL_STRIP_W_R2_0/CTRL_OUT[7] A44_CDAC_CAP_BANK_ASSEMBLY_R8_M6_0/A44_CAP_CORE128_M6_R1_0/CAP_BOTTOM_060 VDD pfet_03v3 ad=0 pd=0 as=0 ps=0 w=1.56u l=0.28u
X1237 VREFP A44_DCTRL_STRIP_W_R2_0/CTRL_OUT[7] A44_CDAC_CAP_BANK_ASSEMBLY_R8_M6_0/A44_CAP_CORE128_M6_R1_0/CAP_BOTTOM_060 VDD pfet_03v3 ad=0 pd=0 as=0 ps=0 w=1.56u l=0.28u
X1238 VREFP A44_DCTRL_STRIP_W_R2_0/CTRL_OUT[7] A44_CDAC_CAP_BANK_ASSEMBLY_R8_M6_0/A44_CAP_CORE128_M6_R1_0/CAP_BOTTOM_060 VDD pfet_03v3 ad=0 pd=0 as=0 ps=0 w=1.56u l=0.28u
X1239 VREFP A44_DCTRL_STRIP_W_R2_0/CTRL_OUT[7] A44_CDAC_CAP_BANK_ASSEMBLY_R8_M6_0/A44_CAP_CORE128_M6_R1_0/CAP_BOTTOM_060 VDD pfet_03v3 ad=0 pd=0 as=0 ps=0 w=1.56u l=0.28u
X1240 VREFP A44_DCTRL_STRIP_W_R2_0/CTRL_OUT[7] A44_CDAC_CAP_BANK_ASSEMBLY_R8_M6_0/A44_CAP_CORE128_M6_R1_0/CAP_BOTTOM_060 VDD pfet_03v3 ad=0 pd=0 as=0 ps=0 w=1.56u l=0.28u
X1241 VREFP A44_DCTRL_STRIP_W_R2_0/CTRL_OUT[7] A44_CDAC_CAP_BANK_ASSEMBLY_R8_M6_0/A44_CAP_CORE128_M6_R1_0/CAP_BOTTOM_060 VDD pfet_03v3 ad=0 pd=0 as=0 ps=0 w=1.56u l=0.28u
X1242 VREFP A44_DCTRL_STRIP_W_R2_0/CTRL_OUT[7] A44_CDAC_CAP_BANK_ASSEMBLY_R8_M6_0/A44_CAP_CORE128_M6_R1_0/CAP_BOTTOM_060 VDD pfet_03v3 ad=0 pd=0 as=0 ps=0 w=1.56u l=0.28u
X1243 VREFP A44_DCTRL_STRIP_W_R2_0/CTRL_OUT[7] A44_CDAC_CAP_BANK_ASSEMBLY_R8_M6_0/A44_CAP_CORE128_M6_R1_0/CAP_BOTTOM_060 VDD pfet_03v3 ad=0 pd=0 as=0 ps=0 w=1.56u l=0.28u
X1244 VREFN A44_DCTRL_STRIP_W_R2_0/CTRL_OUT[7] A44_CDAC_CAP_BANK_ASSEMBLY_R8_M6_0/A44_CAP_CORE128_M6_R1_0/CAP_BOTTOM_060 GND nfet_03v3 ad=0 pd=0 as=16.6842p ps=77.76u w=1.56u l=0.28u
X1245 VREFN A44_DCTRL_STRIP_W_R2_0/CTRL_OUT[7] A44_CDAC_CAP_BANK_ASSEMBLY_R8_M6_0/A44_CAP_CORE128_M6_R1_0/CAP_BOTTOM_060 GND nfet_03v3 ad=0 pd=0 as=0 ps=0 w=1.56u l=0.28u
X1246 VREFN A44_DCTRL_STRIP_W_R2_0/CTRL_OUT[7] A44_CDAC_CAP_BANK_ASSEMBLY_R8_M6_0/A44_CAP_CORE128_M6_R1_0/CAP_BOTTOM_060 GND nfet_03v3 ad=0 pd=0 as=0 ps=0 w=1.56u l=0.28u
X1247 VREFN A44_DCTRL_STRIP_W_R2_0/CTRL_OUT[7] A44_CDAC_CAP_BANK_ASSEMBLY_R8_M6_0/A44_CAP_CORE128_M6_R1_0/CAP_BOTTOM_060 GND nfet_03v3 ad=0 pd=0 as=0 ps=0 w=1.56u l=0.28u
X1248 VREFN A44_DCTRL_STRIP_W_R2_0/CTRL_OUT[7] A44_CDAC_CAP_BANK_ASSEMBLY_R8_M6_0/A44_CAP_CORE128_M6_R1_0/CAP_BOTTOM_060 GND nfet_03v3 ad=0 pd=0 as=0 ps=0 w=1.56u l=0.28u
X1249 VREFN A44_DCTRL_STRIP_W_R2_0/CTRL_OUT[7] A44_CDAC_CAP_BANK_ASSEMBLY_R8_M6_0/A44_CAP_CORE128_M6_R1_0/CAP_BOTTOM_060 GND nfet_03v3 ad=0 pd=0 as=0 ps=0 w=1.56u l=0.28u
X1250 VREFN A44_DCTRL_STRIP_W_R2_0/CTRL_OUT[7] A44_CDAC_CAP_BANK_ASSEMBLY_R8_M6_0/A44_CAP_CORE128_M6_R1_0/CAP_BOTTOM_060 GND nfet_03v3 ad=0 pd=0 as=0 ps=0 w=1.56u l=0.28u
X1251 VREFN A44_DCTRL_STRIP_W_R2_0/CTRL_OUT[7] A44_CDAC_CAP_BANK_ASSEMBLY_R8_M6_0/A44_CAP_CORE128_M6_R1_0/CAP_BOTTOM_060 GND nfet_03v3 ad=0 pd=0 as=0 ps=0 w=1.56u l=0.28u
X1252 VREFN A44_DCTRL_STRIP_W_R2_0/CTRL_OUT[7] A44_CDAC_CAP_BANK_ASSEMBLY_R8_M6_0/A44_CAP_CORE128_M6_R1_0/CAP_BOTTOM_060 GND nfet_03v3 ad=0 pd=0 as=0 ps=0 w=1.56u l=0.28u
X1253 VREFN A44_DCTRL_STRIP_W_R2_0/CTRL_OUT[7] A44_CDAC_CAP_BANK_ASSEMBLY_R8_M6_0/A44_CAP_CORE128_M6_R1_0/CAP_BOTTOM_060 GND nfet_03v3 ad=0 pd=0 as=0 ps=0 w=1.56u l=0.28u
X1254 VREFN A44_DCTRL_STRIP_W_R2_0/CTRL_OUT[7] A44_CDAC_CAP_BANK_ASSEMBLY_R8_M6_0/A44_CAP_CORE128_M6_R1_0/CAP_BOTTOM_060 GND nfet_03v3 ad=0 pd=0 as=0 ps=0 w=1.56u l=0.28u
X1255 VREFN A44_DCTRL_STRIP_W_R2_0/CTRL_OUT[7] A44_CDAC_CAP_BANK_ASSEMBLY_R8_M6_0/A44_CAP_CORE128_M6_R1_0/CAP_BOTTOM_060 GND nfet_03v3 ad=0 pd=0 as=0 ps=0 w=1.56u l=0.28u
X1256 VREFN A44_DCTRL_STRIP_W_R2_0/CTRL_OUT[7] A44_CDAC_CAP_BANK_ASSEMBLY_R8_M6_0/A44_CAP_CORE128_M6_R1_0/CAP_BOTTOM_060 GND nfet_03v3 ad=0 pd=0 as=0 ps=0 w=1.56u l=0.28u
X1257 VREFN A44_DCTRL_STRIP_W_R2_0/CTRL_OUT[7] A44_CDAC_CAP_BANK_ASSEMBLY_R8_M6_0/A44_CAP_CORE128_M6_R1_0/CAP_BOTTOM_060 GND nfet_03v3 ad=0 pd=0 as=0 ps=0 w=1.56u l=0.28u
X1258 VREFN A44_DCTRL_STRIP_W_R2_0/CTRL_OUT[7] A44_CDAC_CAP_BANK_ASSEMBLY_R8_M6_0/A44_CAP_CORE128_M6_R1_0/CAP_BOTTOM_060 GND nfet_03v3 ad=0 pd=0 as=0 ps=0 w=1.56u l=0.28u
X1259 VREFN A44_DCTRL_STRIP_W_R2_0/CTRL_OUT[7] A44_CDAC_CAP_BANK_ASSEMBLY_R8_M6_0/A44_CAP_CORE128_M6_R1_0/CAP_BOTTOM_060 GND nfet_03v3 ad=0 pd=0 as=0 ps=0 w=1.56u l=0.28u
X1260 VREFN A44_DCTRL_STRIP_W_R2_0/CTRL_OUT[7] A44_CDAC_CAP_BANK_ASSEMBLY_R8_M6_0/A44_CAP_CORE128_M6_R1_0/CAP_BOTTOM_060 GND nfet_03v3 ad=0 pd=0 as=0 ps=0 w=1.56u l=0.28u
X1261 VREFN A44_DCTRL_STRIP_W_R2_0/CTRL_OUT[7] A44_CDAC_CAP_BANK_ASSEMBLY_R8_M6_0/A44_CAP_CORE128_M6_R1_0/CAP_BOTTOM_060 GND nfet_03v3 ad=0 pd=0 as=0 ps=0 w=1.56u l=0.28u
X1262 VREFP A44_DCTRL_STRIP_W_R2_0/CTRL_OUT[7] A44_CDAC_CAP_BANK_ASSEMBLY_R8_M6_0/A44_CAP_CORE128_M6_R1_0/CAP_BOTTOM_023 VDD pfet_03v3 ad=0 pd=0 as=16.6842p ps=77.76u w=1.56u l=0.28u
X1263 VREFP A44_DCTRL_STRIP_W_R2_0/CTRL_OUT[7] A44_CDAC_CAP_BANK_ASSEMBLY_R8_M6_0/A44_CAP_CORE128_M6_R1_0/CAP_BOTTOM_023 VDD pfet_03v3 ad=0 pd=0 as=0 ps=0 w=1.56u l=0.28u
X1264 VREFP A44_DCTRL_STRIP_W_R2_0/CTRL_OUT[7] A44_CDAC_CAP_BANK_ASSEMBLY_R8_M6_0/A44_CAP_CORE128_M6_R1_0/CAP_BOTTOM_023 VDD pfet_03v3 ad=0 pd=0 as=0 ps=0 w=1.56u l=0.28u
X1265 VREFP A44_DCTRL_STRIP_W_R2_0/CTRL_OUT[7] A44_CDAC_CAP_BANK_ASSEMBLY_R8_M6_0/A44_CAP_CORE128_M6_R1_0/CAP_BOTTOM_023 VDD pfet_03v3 ad=0 pd=0 as=0 ps=0 w=1.56u l=0.28u
X1266 VREFP A44_DCTRL_STRIP_W_R2_0/CTRL_OUT[7] A44_CDAC_CAP_BANK_ASSEMBLY_R8_M6_0/A44_CAP_CORE128_M6_R1_0/CAP_BOTTOM_023 VDD pfet_03v3 ad=0 pd=0 as=0 ps=0 w=1.56u l=0.28u
X1267 VREFP A44_DCTRL_STRIP_W_R2_0/CTRL_OUT[7] A44_CDAC_CAP_BANK_ASSEMBLY_R8_M6_0/A44_CAP_CORE128_M6_R1_0/CAP_BOTTOM_023 VDD pfet_03v3 ad=0 pd=0 as=0 ps=0 w=1.56u l=0.28u
X1268 VREFP A44_DCTRL_STRIP_W_R2_0/CTRL_OUT[7] A44_CDAC_CAP_BANK_ASSEMBLY_R8_M6_0/A44_CAP_CORE128_M6_R1_0/CAP_BOTTOM_023 VDD pfet_03v3 ad=0 pd=0 as=0 ps=0 w=1.56u l=0.28u
X1269 VREFP A44_DCTRL_STRIP_W_R2_0/CTRL_OUT[7] A44_CDAC_CAP_BANK_ASSEMBLY_R8_M6_0/A44_CAP_CORE128_M6_R1_0/CAP_BOTTOM_023 VDD pfet_03v3 ad=0 pd=0 as=0 ps=0 w=1.56u l=0.28u
X1270 VREFP A44_DCTRL_STRIP_W_R2_0/CTRL_OUT[7] A44_CDAC_CAP_BANK_ASSEMBLY_R8_M6_0/A44_CAP_CORE128_M6_R1_0/CAP_BOTTOM_023 VDD pfet_03v3 ad=0 pd=0 as=0 ps=0 w=1.56u l=0.28u
X1271 VREFP A44_DCTRL_STRIP_W_R2_0/CTRL_OUT[7] A44_CDAC_CAP_BANK_ASSEMBLY_R8_M6_0/A44_CAP_CORE128_M6_R1_0/CAP_BOTTOM_023 VDD pfet_03v3 ad=0 pd=0 as=0 ps=0 w=1.56u l=0.28u
X1272 VREFP A44_DCTRL_STRIP_W_R2_0/CTRL_OUT[7] A44_CDAC_CAP_BANK_ASSEMBLY_R8_M6_0/A44_CAP_CORE128_M6_R1_0/CAP_BOTTOM_023 VDD pfet_03v3 ad=0 pd=0 as=0 ps=0 w=1.56u l=0.28u
X1273 VREFP A44_DCTRL_STRIP_W_R2_0/CTRL_OUT[7] A44_CDAC_CAP_BANK_ASSEMBLY_R8_M6_0/A44_CAP_CORE128_M6_R1_0/CAP_BOTTOM_023 VDD pfet_03v3 ad=0 pd=0 as=0 ps=0 w=1.56u l=0.28u
X1274 VREFP A44_DCTRL_STRIP_W_R2_0/CTRL_OUT[7] A44_CDAC_CAP_BANK_ASSEMBLY_R8_M6_0/A44_CAP_CORE128_M6_R1_0/CAP_BOTTOM_023 VDD pfet_03v3 ad=0 pd=0 as=0 ps=0 w=1.56u l=0.28u
X1275 VREFP A44_DCTRL_STRIP_W_R2_0/CTRL_OUT[7] A44_CDAC_CAP_BANK_ASSEMBLY_R8_M6_0/A44_CAP_CORE128_M6_R1_0/CAP_BOTTOM_023 VDD pfet_03v3 ad=0 pd=0 as=0 ps=0 w=1.56u l=0.28u
X1276 VREFP A44_DCTRL_STRIP_W_R2_0/CTRL_OUT[7] A44_CDAC_CAP_BANK_ASSEMBLY_R8_M6_0/A44_CAP_CORE128_M6_R1_0/CAP_BOTTOM_023 VDD pfet_03v3 ad=0 pd=0 as=0 ps=0 w=1.56u l=0.28u
X1277 VREFP A44_DCTRL_STRIP_W_R2_0/CTRL_OUT[7] A44_CDAC_CAP_BANK_ASSEMBLY_R8_M6_0/A44_CAP_CORE128_M6_R1_0/CAP_BOTTOM_023 VDD pfet_03v3 ad=0 pd=0 as=0 ps=0 w=1.56u l=0.28u
X1278 VREFP A44_DCTRL_STRIP_W_R2_0/CTRL_OUT[7] A44_CDAC_CAP_BANK_ASSEMBLY_R8_M6_0/A44_CAP_CORE128_M6_R1_0/CAP_BOTTOM_023 VDD pfet_03v3 ad=0 pd=0 as=0 ps=0 w=1.56u l=0.28u
X1279 VREFP A44_DCTRL_STRIP_W_R2_0/CTRL_OUT[7] A44_CDAC_CAP_BANK_ASSEMBLY_R8_M6_0/A44_CAP_CORE128_M6_R1_0/CAP_BOTTOM_023 VDD pfet_03v3 ad=0 pd=0 as=0 ps=0 w=1.56u l=0.28u
X1280 VREFN A44_DCTRL_STRIP_W_R2_0/CTRL_OUT[7] A44_CDAC_CAP_BANK_ASSEMBLY_R8_M6_0/A44_CAP_CORE128_M6_R1_0/CAP_BOTTOM_023 GND nfet_03v3 ad=0 pd=0 as=16.6842p ps=77.76u w=1.56u l=0.28u
X1281 VREFN A44_DCTRL_STRIP_W_R2_0/CTRL_OUT[7] A44_CDAC_CAP_BANK_ASSEMBLY_R8_M6_0/A44_CAP_CORE128_M6_R1_0/CAP_BOTTOM_023 GND nfet_03v3 ad=0 pd=0 as=0 ps=0 w=1.56u l=0.28u
X1282 VREFN A44_DCTRL_STRIP_W_R2_0/CTRL_OUT[7] A44_CDAC_CAP_BANK_ASSEMBLY_R8_M6_0/A44_CAP_CORE128_M6_R1_0/CAP_BOTTOM_023 GND nfet_03v3 ad=0 pd=0 as=0 ps=0 w=1.56u l=0.28u
X1283 VREFN A44_DCTRL_STRIP_W_R2_0/CTRL_OUT[7] A44_CDAC_CAP_BANK_ASSEMBLY_R8_M6_0/A44_CAP_CORE128_M6_R1_0/CAP_BOTTOM_023 GND nfet_03v3 ad=0 pd=0 as=0 ps=0 w=1.56u l=0.28u
X1284 VREFN A44_DCTRL_STRIP_W_R2_0/CTRL_OUT[7] A44_CDAC_CAP_BANK_ASSEMBLY_R8_M6_0/A44_CAP_CORE128_M6_R1_0/CAP_BOTTOM_023 GND nfet_03v3 ad=0 pd=0 as=0 ps=0 w=1.56u l=0.28u
X1285 VREFN A44_DCTRL_STRIP_W_R2_0/CTRL_OUT[7] A44_CDAC_CAP_BANK_ASSEMBLY_R8_M6_0/A44_CAP_CORE128_M6_R1_0/CAP_BOTTOM_023 GND nfet_03v3 ad=0 pd=0 as=0 ps=0 w=1.56u l=0.28u
X1286 VREFN A44_DCTRL_STRIP_W_R2_0/CTRL_OUT[7] A44_CDAC_CAP_BANK_ASSEMBLY_R8_M6_0/A44_CAP_CORE128_M6_R1_0/CAP_BOTTOM_023 GND nfet_03v3 ad=0 pd=0 as=0 ps=0 w=1.56u l=0.28u
X1287 VREFN A44_DCTRL_STRIP_W_R2_0/CTRL_OUT[7] A44_CDAC_CAP_BANK_ASSEMBLY_R8_M6_0/A44_CAP_CORE128_M6_R1_0/CAP_BOTTOM_023 GND nfet_03v3 ad=0 pd=0 as=0 ps=0 w=1.56u l=0.28u
X1288 VREFN A44_DCTRL_STRIP_W_R2_0/CTRL_OUT[7] A44_CDAC_CAP_BANK_ASSEMBLY_R8_M6_0/A44_CAP_CORE128_M6_R1_0/CAP_BOTTOM_023 GND nfet_03v3 ad=0 pd=0 as=0 ps=0 w=1.56u l=0.28u
X1289 VREFN A44_DCTRL_STRIP_W_R2_0/CTRL_OUT[7] A44_CDAC_CAP_BANK_ASSEMBLY_R8_M6_0/A44_CAP_CORE128_M6_R1_0/CAP_BOTTOM_023 GND nfet_03v3 ad=0 pd=0 as=0 ps=0 w=1.56u l=0.28u
X1290 VREFN A44_DCTRL_STRIP_W_R2_0/CTRL_OUT[7] A44_CDAC_CAP_BANK_ASSEMBLY_R8_M6_0/A44_CAP_CORE128_M6_R1_0/CAP_BOTTOM_023 GND nfet_03v3 ad=0 pd=0 as=0 ps=0 w=1.56u l=0.28u
X1291 VREFN A44_DCTRL_STRIP_W_R2_0/CTRL_OUT[7] A44_CDAC_CAP_BANK_ASSEMBLY_R8_M6_0/A44_CAP_CORE128_M6_R1_0/CAP_BOTTOM_023 GND nfet_03v3 ad=0 pd=0 as=0 ps=0 w=1.56u l=0.28u
X1292 VREFN A44_DCTRL_STRIP_W_R2_0/CTRL_OUT[7] A44_CDAC_CAP_BANK_ASSEMBLY_R8_M6_0/A44_CAP_CORE128_M6_R1_0/CAP_BOTTOM_023 GND nfet_03v3 ad=0 pd=0 as=0 ps=0 w=1.56u l=0.28u
X1293 VREFN A44_DCTRL_STRIP_W_R2_0/CTRL_OUT[7] A44_CDAC_CAP_BANK_ASSEMBLY_R8_M6_0/A44_CAP_CORE128_M6_R1_0/CAP_BOTTOM_023 GND nfet_03v3 ad=0 pd=0 as=0 ps=0 w=1.56u l=0.28u
X1294 VREFN A44_DCTRL_STRIP_W_R2_0/CTRL_OUT[7] A44_CDAC_CAP_BANK_ASSEMBLY_R8_M6_0/A44_CAP_CORE128_M6_R1_0/CAP_BOTTOM_023 GND nfet_03v3 ad=0 pd=0 as=0 ps=0 w=1.56u l=0.28u
X1295 VREFN A44_DCTRL_STRIP_W_R2_0/CTRL_OUT[7] A44_CDAC_CAP_BANK_ASSEMBLY_R8_M6_0/A44_CAP_CORE128_M6_R1_0/CAP_BOTTOM_023 GND nfet_03v3 ad=0 pd=0 as=0 ps=0 w=1.56u l=0.28u
X1296 VREFN A44_DCTRL_STRIP_W_R2_0/CTRL_OUT[7] A44_CDAC_CAP_BANK_ASSEMBLY_R8_M6_0/A44_CAP_CORE128_M6_R1_0/CAP_BOTTOM_023 GND nfet_03v3 ad=0 pd=0 as=0 ps=0 w=1.56u l=0.28u
X1297 VREFN A44_DCTRL_STRIP_W_R2_0/CTRL_OUT[7] A44_CDAC_CAP_BANK_ASSEMBLY_R8_M6_0/A44_CAP_CORE128_M6_R1_0/CAP_BOTTOM_023 GND nfet_03v3 ad=0 pd=0 as=0 ps=0 w=1.56u l=0.28u
X1298 VREFP A44_DCTRL_STRIP_W_R2_0/CTRL_OUT[6] A44_CDAC_CAP_BANK_ASSEMBLY_R8_M6_0/A44_CAP_CORE128_M6_R1_0/CAP_BOTTOM_049 VDD pfet_03v3 ad=0 pd=0 as=16.6842p ps=77.76u w=1.56u l=0.28u
X1299 VREFP A44_DCTRL_STRIP_W_R2_0/CTRL_OUT[6] A44_CDAC_CAP_BANK_ASSEMBLY_R8_M6_0/A44_CAP_CORE128_M6_R1_0/CAP_BOTTOM_049 VDD pfet_03v3 ad=0 pd=0 as=0 ps=0 w=1.56u l=0.28u
X1300 VREFP A44_DCTRL_STRIP_W_R2_0/CTRL_OUT[6] A44_CDAC_CAP_BANK_ASSEMBLY_R8_M6_0/A44_CAP_CORE128_M6_R1_0/CAP_BOTTOM_049 VDD pfet_03v3 ad=0 pd=0 as=0 ps=0 w=1.56u l=0.28u
X1301 VREFP A44_DCTRL_STRIP_W_R2_0/CTRL_OUT[6] A44_CDAC_CAP_BANK_ASSEMBLY_R8_M6_0/A44_CAP_CORE128_M6_R1_0/CAP_BOTTOM_049 VDD pfet_03v3 ad=0 pd=0 as=0 ps=0 w=1.56u l=0.28u
X1302 VREFP A44_DCTRL_STRIP_W_R2_0/CTRL_OUT[6] A44_CDAC_CAP_BANK_ASSEMBLY_R8_M6_0/A44_CAP_CORE128_M6_R1_0/CAP_BOTTOM_049 VDD pfet_03v3 ad=0 pd=0 as=0 ps=0 w=1.56u l=0.28u
X1303 VREFP A44_DCTRL_STRIP_W_R2_0/CTRL_OUT[6] A44_CDAC_CAP_BANK_ASSEMBLY_R8_M6_0/A44_CAP_CORE128_M6_R1_0/CAP_BOTTOM_049 VDD pfet_03v3 ad=0 pd=0 as=0 ps=0 w=1.56u l=0.28u
X1304 VREFP A44_DCTRL_STRIP_W_R2_0/CTRL_OUT[6] A44_CDAC_CAP_BANK_ASSEMBLY_R8_M6_0/A44_CAP_CORE128_M6_R1_0/CAP_BOTTOM_049 VDD pfet_03v3 ad=0 pd=0 as=0 ps=0 w=1.56u l=0.28u
X1305 VREFP A44_DCTRL_STRIP_W_R2_0/CTRL_OUT[6] A44_CDAC_CAP_BANK_ASSEMBLY_R8_M6_0/A44_CAP_CORE128_M6_R1_0/CAP_BOTTOM_049 VDD pfet_03v3 ad=0 pd=0 as=0 ps=0 w=1.56u l=0.28u
X1306 VREFP A44_DCTRL_STRIP_W_R2_0/CTRL_OUT[6] A44_CDAC_CAP_BANK_ASSEMBLY_R8_M6_0/A44_CAP_CORE128_M6_R1_0/CAP_BOTTOM_049 VDD pfet_03v3 ad=0 pd=0 as=0 ps=0 w=1.56u l=0.28u
X1307 VREFP A44_DCTRL_STRIP_W_R2_0/CTRL_OUT[6] A44_CDAC_CAP_BANK_ASSEMBLY_R8_M6_0/A44_CAP_CORE128_M6_R1_0/CAP_BOTTOM_049 VDD pfet_03v3 ad=0 pd=0 as=0 ps=0 w=1.56u l=0.28u
X1308 VREFP A44_DCTRL_STRIP_W_R2_0/CTRL_OUT[6] A44_CDAC_CAP_BANK_ASSEMBLY_R8_M6_0/A44_CAP_CORE128_M6_R1_0/CAP_BOTTOM_049 VDD pfet_03v3 ad=0 pd=0 as=0 ps=0 w=1.56u l=0.28u
X1309 VREFP A44_DCTRL_STRIP_W_R2_0/CTRL_OUT[6] A44_CDAC_CAP_BANK_ASSEMBLY_R8_M6_0/A44_CAP_CORE128_M6_R1_0/CAP_BOTTOM_049 VDD pfet_03v3 ad=0 pd=0 as=0 ps=0 w=1.56u l=0.28u
X1310 VREFP A44_DCTRL_STRIP_W_R2_0/CTRL_OUT[6] A44_CDAC_CAP_BANK_ASSEMBLY_R8_M6_0/A44_CAP_CORE128_M6_R1_0/CAP_BOTTOM_049 VDD pfet_03v3 ad=0 pd=0 as=0 ps=0 w=1.56u l=0.28u
X1311 VREFP A44_DCTRL_STRIP_W_R2_0/CTRL_OUT[6] A44_CDAC_CAP_BANK_ASSEMBLY_R8_M6_0/A44_CAP_CORE128_M6_R1_0/CAP_BOTTOM_049 VDD pfet_03v3 ad=0 pd=0 as=0 ps=0 w=1.56u l=0.28u
X1312 VREFP A44_DCTRL_STRIP_W_R2_0/CTRL_OUT[6] A44_CDAC_CAP_BANK_ASSEMBLY_R8_M6_0/A44_CAP_CORE128_M6_R1_0/CAP_BOTTOM_049 VDD pfet_03v3 ad=0 pd=0 as=0 ps=0 w=1.56u l=0.28u
X1313 VREFP A44_DCTRL_STRIP_W_R2_0/CTRL_OUT[6] A44_CDAC_CAP_BANK_ASSEMBLY_R8_M6_0/A44_CAP_CORE128_M6_R1_0/CAP_BOTTOM_049 VDD pfet_03v3 ad=0 pd=0 as=0 ps=0 w=1.56u l=0.28u
X1314 VREFP A44_DCTRL_STRIP_W_R2_0/CTRL_OUT[6] A44_CDAC_CAP_BANK_ASSEMBLY_R8_M6_0/A44_CAP_CORE128_M6_R1_0/CAP_BOTTOM_049 VDD pfet_03v3 ad=0 pd=0 as=0 ps=0 w=1.56u l=0.28u
X1315 VREFP A44_DCTRL_STRIP_W_R2_0/CTRL_OUT[6] A44_CDAC_CAP_BANK_ASSEMBLY_R8_M6_0/A44_CAP_CORE128_M6_R1_0/CAP_BOTTOM_049 VDD pfet_03v3 ad=0 pd=0 as=0 ps=0 w=1.56u l=0.28u
X1316 VREFN A44_DCTRL_STRIP_W_R2_0/CTRL_OUT[6] A44_CDAC_CAP_BANK_ASSEMBLY_R8_M6_0/A44_CAP_CORE128_M6_R1_0/CAP_BOTTOM_049 GND nfet_03v3 ad=0 pd=0 as=16.6842p ps=77.76u w=1.56u l=0.28u
X1317 VREFN A44_DCTRL_STRIP_W_R2_0/CTRL_OUT[6] A44_CDAC_CAP_BANK_ASSEMBLY_R8_M6_0/A44_CAP_CORE128_M6_R1_0/CAP_BOTTOM_049 GND nfet_03v3 ad=0 pd=0 as=0 ps=0 w=1.56u l=0.28u
X1318 VREFN A44_DCTRL_STRIP_W_R2_0/CTRL_OUT[6] A44_CDAC_CAP_BANK_ASSEMBLY_R8_M6_0/A44_CAP_CORE128_M6_R1_0/CAP_BOTTOM_049 GND nfet_03v3 ad=0 pd=0 as=0 ps=0 w=1.56u l=0.28u
X1319 VREFN A44_DCTRL_STRIP_W_R2_0/CTRL_OUT[6] A44_CDAC_CAP_BANK_ASSEMBLY_R8_M6_0/A44_CAP_CORE128_M6_R1_0/CAP_BOTTOM_049 GND nfet_03v3 ad=0 pd=0 as=0 ps=0 w=1.56u l=0.28u
X1320 VREFN A44_DCTRL_STRIP_W_R2_0/CTRL_OUT[6] A44_CDAC_CAP_BANK_ASSEMBLY_R8_M6_0/A44_CAP_CORE128_M6_R1_0/CAP_BOTTOM_049 GND nfet_03v3 ad=0 pd=0 as=0 ps=0 w=1.56u l=0.28u
X1321 VREFN A44_DCTRL_STRIP_W_R2_0/CTRL_OUT[6] A44_CDAC_CAP_BANK_ASSEMBLY_R8_M6_0/A44_CAP_CORE128_M6_R1_0/CAP_BOTTOM_049 GND nfet_03v3 ad=0 pd=0 as=0 ps=0 w=1.56u l=0.28u
X1322 VREFN A44_DCTRL_STRIP_W_R2_0/CTRL_OUT[6] A44_CDAC_CAP_BANK_ASSEMBLY_R8_M6_0/A44_CAP_CORE128_M6_R1_0/CAP_BOTTOM_049 GND nfet_03v3 ad=0 pd=0 as=0 ps=0 w=1.56u l=0.28u
X1323 VREFN A44_DCTRL_STRIP_W_R2_0/CTRL_OUT[6] A44_CDAC_CAP_BANK_ASSEMBLY_R8_M6_0/A44_CAP_CORE128_M6_R1_0/CAP_BOTTOM_049 GND nfet_03v3 ad=0 pd=0 as=0 ps=0 w=1.56u l=0.28u
X1324 VREFN A44_DCTRL_STRIP_W_R2_0/CTRL_OUT[6] A44_CDAC_CAP_BANK_ASSEMBLY_R8_M6_0/A44_CAP_CORE128_M6_R1_0/CAP_BOTTOM_049 GND nfet_03v3 ad=0 pd=0 as=0 ps=0 w=1.56u l=0.28u
X1325 VREFN A44_DCTRL_STRIP_W_R2_0/CTRL_OUT[6] A44_CDAC_CAP_BANK_ASSEMBLY_R8_M6_0/A44_CAP_CORE128_M6_R1_0/CAP_BOTTOM_049 GND nfet_03v3 ad=0 pd=0 as=0 ps=0 w=1.56u l=0.28u
X1326 VREFN A44_DCTRL_STRIP_W_R2_0/CTRL_OUT[6] A44_CDAC_CAP_BANK_ASSEMBLY_R8_M6_0/A44_CAP_CORE128_M6_R1_0/CAP_BOTTOM_049 GND nfet_03v3 ad=0 pd=0 as=0 ps=0 w=1.56u l=0.28u
X1327 VREFN A44_DCTRL_STRIP_W_R2_0/CTRL_OUT[6] A44_CDAC_CAP_BANK_ASSEMBLY_R8_M6_0/A44_CAP_CORE128_M6_R1_0/CAP_BOTTOM_049 GND nfet_03v3 ad=0 pd=0 as=0 ps=0 w=1.56u l=0.28u
X1328 VREFN A44_DCTRL_STRIP_W_R2_0/CTRL_OUT[6] A44_CDAC_CAP_BANK_ASSEMBLY_R8_M6_0/A44_CAP_CORE128_M6_R1_0/CAP_BOTTOM_049 GND nfet_03v3 ad=0 pd=0 as=0 ps=0 w=1.56u l=0.28u
X1329 VREFN A44_DCTRL_STRIP_W_R2_0/CTRL_OUT[6] A44_CDAC_CAP_BANK_ASSEMBLY_R8_M6_0/A44_CAP_CORE128_M6_R1_0/CAP_BOTTOM_049 GND nfet_03v3 ad=0 pd=0 as=0 ps=0 w=1.56u l=0.28u
X1330 VREFN A44_DCTRL_STRIP_W_R2_0/CTRL_OUT[6] A44_CDAC_CAP_BANK_ASSEMBLY_R8_M6_0/A44_CAP_CORE128_M6_R1_0/CAP_BOTTOM_049 GND nfet_03v3 ad=0 pd=0 as=0 ps=0 w=1.56u l=0.28u
X1331 VREFN A44_DCTRL_STRIP_W_R2_0/CTRL_OUT[6] A44_CDAC_CAP_BANK_ASSEMBLY_R8_M6_0/A44_CAP_CORE128_M6_R1_0/CAP_BOTTOM_049 GND nfet_03v3 ad=0 pd=0 as=0 ps=0 w=1.56u l=0.28u
X1332 VREFN A44_DCTRL_STRIP_W_R2_0/CTRL_OUT[6] A44_CDAC_CAP_BANK_ASSEMBLY_R8_M6_0/A44_CAP_CORE128_M6_R1_0/CAP_BOTTOM_049 GND nfet_03v3 ad=0 pd=0 as=0 ps=0 w=1.56u l=0.28u
X1333 VREFN A44_DCTRL_STRIP_W_R2_0/CTRL_OUT[6] A44_CDAC_CAP_BANK_ASSEMBLY_R8_M6_0/A44_CAP_CORE128_M6_R1_0/CAP_BOTTOM_049 GND nfet_03v3 ad=0 pd=0 as=0 ps=0 w=1.56u l=0.28u
X1334 VREFP A44_DCTRL_STRIP_W_R2_0/CTRL_OUT[3] A44_CDAC_CAP_BANK_ASSEMBLY_R8_M6_0/A44_CAP_CORE128_M6_R1_0/CAP_BOTTOM_044 VDD pfet_03v3 ad=0 pd=0 as=16.6842p ps=77.76u w=1.56u l=0.28u
X1335 VREFP A44_DCTRL_STRIP_W_R2_0/CTRL_OUT[3] A44_CDAC_CAP_BANK_ASSEMBLY_R8_M6_0/A44_CAP_CORE128_M6_R1_0/CAP_BOTTOM_044 VDD pfet_03v3 ad=0 pd=0 as=0 ps=0 w=1.56u l=0.28u
X1336 VREFP A44_DCTRL_STRIP_W_R2_0/CTRL_OUT[3] A44_CDAC_CAP_BANK_ASSEMBLY_R8_M6_0/A44_CAP_CORE128_M6_R1_0/CAP_BOTTOM_044 VDD pfet_03v3 ad=0 pd=0 as=0 ps=0 w=1.56u l=0.28u
X1337 VREFP A44_DCTRL_STRIP_W_R2_0/CTRL_OUT[3] A44_CDAC_CAP_BANK_ASSEMBLY_R8_M6_0/A44_CAP_CORE128_M6_R1_0/CAP_BOTTOM_044 VDD pfet_03v3 ad=0 pd=0 as=0 ps=0 w=1.56u l=0.28u
X1338 VREFP A44_DCTRL_STRIP_W_R2_0/CTRL_OUT[3] A44_CDAC_CAP_BANK_ASSEMBLY_R8_M6_0/A44_CAP_CORE128_M6_R1_0/CAP_BOTTOM_044 VDD pfet_03v3 ad=0 pd=0 as=0 ps=0 w=1.56u l=0.28u
X1339 VREFP A44_DCTRL_STRIP_W_R2_0/CTRL_OUT[3] A44_CDAC_CAP_BANK_ASSEMBLY_R8_M6_0/A44_CAP_CORE128_M6_R1_0/CAP_BOTTOM_044 VDD pfet_03v3 ad=0 pd=0 as=0 ps=0 w=1.56u l=0.28u
X1340 VREFP A44_DCTRL_STRIP_W_R2_0/CTRL_OUT[3] A44_CDAC_CAP_BANK_ASSEMBLY_R8_M6_0/A44_CAP_CORE128_M6_R1_0/CAP_BOTTOM_044 VDD pfet_03v3 ad=0 pd=0 as=0 ps=0 w=1.56u l=0.28u
X1341 VREFP A44_DCTRL_STRIP_W_R2_0/CTRL_OUT[3] A44_CDAC_CAP_BANK_ASSEMBLY_R8_M6_0/A44_CAP_CORE128_M6_R1_0/CAP_BOTTOM_044 VDD pfet_03v3 ad=0 pd=0 as=0 ps=0 w=1.56u l=0.28u
X1342 VREFP A44_DCTRL_STRIP_W_R2_0/CTRL_OUT[3] A44_CDAC_CAP_BANK_ASSEMBLY_R8_M6_0/A44_CAP_CORE128_M6_R1_0/CAP_BOTTOM_044 VDD pfet_03v3 ad=0 pd=0 as=0 ps=0 w=1.56u l=0.28u
X1343 VREFP A44_DCTRL_STRIP_W_R2_0/CTRL_OUT[3] A44_CDAC_CAP_BANK_ASSEMBLY_R8_M6_0/A44_CAP_CORE128_M6_R1_0/CAP_BOTTOM_044 VDD pfet_03v3 ad=0 pd=0 as=0 ps=0 w=1.56u l=0.28u
X1344 VREFP A44_DCTRL_STRIP_W_R2_0/CTRL_OUT[3] A44_CDAC_CAP_BANK_ASSEMBLY_R8_M6_0/A44_CAP_CORE128_M6_R1_0/CAP_BOTTOM_044 VDD pfet_03v3 ad=0 pd=0 as=0 ps=0 w=1.56u l=0.28u
X1345 VREFP A44_DCTRL_STRIP_W_R2_0/CTRL_OUT[3] A44_CDAC_CAP_BANK_ASSEMBLY_R8_M6_0/A44_CAP_CORE128_M6_R1_0/CAP_BOTTOM_044 VDD pfet_03v3 ad=0 pd=0 as=0 ps=0 w=1.56u l=0.28u
X1346 VREFP A44_DCTRL_STRIP_W_R2_0/CTRL_OUT[3] A44_CDAC_CAP_BANK_ASSEMBLY_R8_M6_0/A44_CAP_CORE128_M6_R1_0/CAP_BOTTOM_044 VDD pfet_03v3 ad=0 pd=0 as=0 ps=0 w=1.56u l=0.28u
X1347 VREFP A44_DCTRL_STRIP_W_R2_0/CTRL_OUT[3] A44_CDAC_CAP_BANK_ASSEMBLY_R8_M6_0/A44_CAP_CORE128_M6_R1_0/CAP_BOTTOM_044 VDD pfet_03v3 ad=0 pd=0 as=0 ps=0 w=1.56u l=0.28u
X1348 VREFP A44_DCTRL_STRIP_W_R2_0/CTRL_OUT[3] A44_CDAC_CAP_BANK_ASSEMBLY_R8_M6_0/A44_CAP_CORE128_M6_R1_0/CAP_BOTTOM_044 VDD pfet_03v3 ad=0 pd=0 as=0 ps=0 w=1.56u l=0.28u
X1349 VREFP A44_DCTRL_STRIP_W_R2_0/CTRL_OUT[3] A44_CDAC_CAP_BANK_ASSEMBLY_R8_M6_0/A44_CAP_CORE128_M6_R1_0/CAP_BOTTOM_044 VDD pfet_03v3 ad=0 pd=0 as=0 ps=0 w=1.56u l=0.28u
X1350 VREFP A44_DCTRL_STRIP_W_R2_0/CTRL_OUT[3] A44_CDAC_CAP_BANK_ASSEMBLY_R8_M6_0/A44_CAP_CORE128_M6_R1_0/CAP_BOTTOM_044 VDD pfet_03v3 ad=0 pd=0 as=0 ps=0 w=1.56u l=0.28u
X1351 VREFP A44_DCTRL_STRIP_W_R2_0/CTRL_OUT[3] A44_CDAC_CAP_BANK_ASSEMBLY_R8_M6_0/A44_CAP_CORE128_M6_R1_0/CAP_BOTTOM_044 VDD pfet_03v3 ad=0 pd=0 as=0 ps=0 w=1.56u l=0.28u
X1352 VREFN A44_DCTRL_STRIP_W_R2_0/CTRL_OUT[3] A44_CDAC_CAP_BANK_ASSEMBLY_R8_M6_0/A44_CAP_CORE128_M6_R1_0/CAP_BOTTOM_044 GND nfet_03v3 ad=0 pd=0 as=16.6842p ps=77.76u w=1.56u l=0.28u
X1353 VREFN A44_DCTRL_STRIP_W_R2_0/CTRL_OUT[3] A44_CDAC_CAP_BANK_ASSEMBLY_R8_M6_0/A44_CAP_CORE128_M6_R1_0/CAP_BOTTOM_044 GND nfet_03v3 ad=0 pd=0 as=0 ps=0 w=1.56u l=0.28u
X1354 VREFN A44_DCTRL_STRIP_W_R2_0/CTRL_OUT[3] A44_CDAC_CAP_BANK_ASSEMBLY_R8_M6_0/A44_CAP_CORE128_M6_R1_0/CAP_BOTTOM_044 GND nfet_03v3 ad=0 pd=0 as=0 ps=0 w=1.56u l=0.28u
X1355 VREFN A44_DCTRL_STRIP_W_R2_0/CTRL_OUT[3] A44_CDAC_CAP_BANK_ASSEMBLY_R8_M6_0/A44_CAP_CORE128_M6_R1_0/CAP_BOTTOM_044 GND nfet_03v3 ad=0 pd=0 as=0 ps=0 w=1.56u l=0.28u
X1356 VREFN A44_DCTRL_STRIP_W_R2_0/CTRL_OUT[3] A44_CDAC_CAP_BANK_ASSEMBLY_R8_M6_0/A44_CAP_CORE128_M6_R1_0/CAP_BOTTOM_044 GND nfet_03v3 ad=0 pd=0 as=0 ps=0 w=1.56u l=0.28u
X1357 VREFN A44_DCTRL_STRIP_W_R2_0/CTRL_OUT[3] A44_CDAC_CAP_BANK_ASSEMBLY_R8_M6_0/A44_CAP_CORE128_M6_R1_0/CAP_BOTTOM_044 GND nfet_03v3 ad=0 pd=0 as=0 ps=0 w=1.56u l=0.28u
X1358 VREFN A44_DCTRL_STRIP_W_R2_0/CTRL_OUT[3] A44_CDAC_CAP_BANK_ASSEMBLY_R8_M6_0/A44_CAP_CORE128_M6_R1_0/CAP_BOTTOM_044 GND nfet_03v3 ad=0 pd=0 as=0 ps=0 w=1.56u l=0.28u
X1359 VREFN A44_DCTRL_STRIP_W_R2_0/CTRL_OUT[3] A44_CDAC_CAP_BANK_ASSEMBLY_R8_M6_0/A44_CAP_CORE128_M6_R1_0/CAP_BOTTOM_044 GND nfet_03v3 ad=0 pd=0 as=0 ps=0 w=1.56u l=0.28u
X1360 VREFN A44_DCTRL_STRIP_W_R2_0/CTRL_OUT[3] A44_CDAC_CAP_BANK_ASSEMBLY_R8_M6_0/A44_CAP_CORE128_M6_R1_0/CAP_BOTTOM_044 GND nfet_03v3 ad=0 pd=0 as=0 ps=0 w=1.56u l=0.28u
X1361 VREFN A44_DCTRL_STRIP_W_R2_0/CTRL_OUT[3] A44_CDAC_CAP_BANK_ASSEMBLY_R8_M6_0/A44_CAP_CORE128_M6_R1_0/CAP_BOTTOM_044 GND nfet_03v3 ad=0 pd=0 as=0 ps=0 w=1.56u l=0.28u
X1362 VREFN A44_DCTRL_STRIP_W_R2_0/CTRL_OUT[3] A44_CDAC_CAP_BANK_ASSEMBLY_R8_M6_0/A44_CAP_CORE128_M6_R1_0/CAP_BOTTOM_044 GND nfet_03v3 ad=0 pd=0 as=0 ps=0 w=1.56u l=0.28u
X1363 VREFN A44_DCTRL_STRIP_W_R2_0/CTRL_OUT[3] A44_CDAC_CAP_BANK_ASSEMBLY_R8_M6_0/A44_CAP_CORE128_M6_R1_0/CAP_BOTTOM_044 GND nfet_03v3 ad=0 pd=0 as=0 ps=0 w=1.56u l=0.28u
X1364 VREFN A44_DCTRL_STRIP_W_R2_0/CTRL_OUT[3] A44_CDAC_CAP_BANK_ASSEMBLY_R8_M6_0/A44_CAP_CORE128_M6_R1_0/CAP_BOTTOM_044 GND nfet_03v3 ad=0 pd=0 as=0 ps=0 w=1.56u l=0.28u
X1365 VREFN A44_DCTRL_STRIP_W_R2_0/CTRL_OUT[3] A44_CDAC_CAP_BANK_ASSEMBLY_R8_M6_0/A44_CAP_CORE128_M6_R1_0/CAP_BOTTOM_044 GND nfet_03v3 ad=0 pd=0 as=0 ps=0 w=1.56u l=0.28u
X1366 VREFN A44_DCTRL_STRIP_W_R2_0/CTRL_OUT[3] A44_CDAC_CAP_BANK_ASSEMBLY_R8_M6_0/A44_CAP_CORE128_M6_R1_0/CAP_BOTTOM_044 GND nfet_03v3 ad=0 pd=0 as=0 ps=0 w=1.56u l=0.28u
X1367 VREFN A44_DCTRL_STRIP_W_R2_0/CTRL_OUT[3] A44_CDAC_CAP_BANK_ASSEMBLY_R8_M6_0/A44_CAP_CORE128_M6_R1_0/CAP_BOTTOM_044 GND nfet_03v3 ad=0 pd=0 as=0 ps=0 w=1.56u l=0.28u
X1368 VREFN A44_DCTRL_STRIP_W_R2_0/CTRL_OUT[3] A44_CDAC_CAP_BANK_ASSEMBLY_R8_M6_0/A44_CAP_CORE128_M6_R1_0/CAP_BOTTOM_044 GND nfet_03v3 ad=0 pd=0 as=0 ps=0 w=1.56u l=0.28u
X1369 VREFN A44_DCTRL_STRIP_W_R2_0/CTRL_OUT[3] A44_CDAC_CAP_BANK_ASSEMBLY_R8_M6_0/A44_CAP_CORE128_M6_R1_0/CAP_BOTTOM_044 GND nfet_03v3 ad=0 pd=0 as=0 ps=0 w=1.56u l=0.28u
X1370 VREFP A44_DCTRL_STRIP_W_R2_0/CTRL_OUT[7] A44_CDAC_CAP_BANK_ASSEMBLY_R8_M6_0/A44_CAP_CORE128_M6_R1_0/CAP_BOTTOM_041 VDD pfet_03v3 ad=0 pd=0 as=16.6842p ps=77.76u w=1.56u l=0.28u
X1371 VREFP A44_DCTRL_STRIP_W_R2_0/CTRL_OUT[7] A44_CDAC_CAP_BANK_ASSEMBLY_R8_M6_0/A44_CAP_CORE128_M6_R1_0/CAP_BOTTOM_041 VDD pfet_03v3 ad=0 pd=0 as=0 ps=0 w=1.56u l=0.28u
X1372 VREFP A44_DCTRL_STRIP_W_R2_0/CTRL_OUT[7] A44_CDAC_CAP_BANK_ASSEMBLY_R8_M6_0/A44_CAP_CORE128_M6_R1_0/CAP_BOTTOM_041 VDD pfet_03v3 ad=0 pd=0 as=0 ps=0 w=1.56u l=0.28u
X1373 VREFP A44_DCTRL_STRIP_W_R2_0/CTRL_OUT[7] A44_CDAC_CAP_BANK_ASSEMBLY_R8_M6_0/A44_CAP_CORE128_M6_R1_0/CAP_BOTTOM_041 VDD pfet_03v3 ad=0 pd=0 as=0 ps=0 w=1.56u l=0.28u
X1374 VREFP A44_DCTRL_STRIP_W_R2_0/CTRL_OUT[7] A44_CDAC_CAP_BANK_ASSEMBLY_R8_M6_0/A44_CAP_CORE128_M6_R1_0/CAP_BOTTOM_041 VDD pfet_03v3 ad=0 pd=0 as=0 ps=0 w=1.56u l=0.28u
X1375 VREFP A44_DCTRL_STRIP_W_R2_0/CTRL_OUT[7] A44_CDAC_CAP_BANK_ASSEMBLY_R8_M6_0/A44_CAP_CORE128_M6_R1_0/CAP_BOTTOM_041 VDD pfet_03v3 ad=0 pd=0 as=0 ps=0 w=1.56u l=0.28u
X1376 VREFP A44_DCTRL_STRIP_W_R2_0/CTRL_OUT[7] A44_CDAC_CAP_BANK_ASSEMBLY_R8_M6_0/A44_CAP_CORE128_M6_R1_0/CAP_BOTTOM_041 VDD pfet_03v3 ad=0 pd=0 as=0 ps=0 w=1.56u l=0.28u
X1377 VREFP A44_DCTRL_STRIP_W_R2_0/CTRL_OUT[7] A44_CDAC_CAP_BANK_ASSEMBLY_R8_M6_0/A44_CAP_CORE128_M6_R1_0/CAP_BOTTOM_041 VDD pfet_03v3 ad=0 pd=0 as=0 ps=0 w=1.56u l=0.28u
X1378 VREFP A44_DCTRL_STRIP_W_R2_0/CTRL_OUT[7] A44_CDAC_CAP_BANK_ASSEMBLY_R8_M6_0/A44_CAP_CORE128_M6_R1_0/CAP_BOTTOM_041 VDD pfet_03v3 ad=0 pd=0 as=0 ps=0 w=1.56u l=0.28u
X1379 VREFP A44_DCTRL_STRIP_W_R2_0/CTRL_OUT[7] A44_CDAC_CAP_BANK_ASSEMBLY_R8_M6_0/A44_CAP_CORE128_M6_R1_0/CAP_BOTTOM_041 VDD pfet_03v3 ad=0 pd=0 as=0 ps=0 w=1.56u l=0.28u
X1380 VREFP A44_DCTRL_STRIP_W_R2_0/CTRL_OUT[7] A44_CDAC_CAP_BANK_ASSEMBLY_R8_M6_0/A44_CAP_CORE128_M6_R1_0/CAP_BOTTOM_041 VDD pfet_03v3 ad=0 pd=0 as=0 ps=0 w=1.56u l=0.28u
X1381 VREFP A44_DCTRL_STRIP_W_R2_0/CTRL_OUT[7] A44_CDAC_CAP_BANK_ASSEMBLY_R8_M6_0/A44_CAP_CORE128_M6_R1_0/CAP_BOTTOM_041 VDD pfet_03v3 ad=0 pd=0 as=0 ps=0 w=1.56u l=0.28u
X1382 VREFP A44_DCTRL_STRIP_W_R2_0/CTRL_OUT[7] A44_CDAC_CAP_BANK_ASSEMBLY_R8_M6_0/A44_CAP_CORE128_M6_R1_0/CAP_BOTTOM_041 VDD pfet_03v3 ad=0 pd=0 as=0 ps=0 w=1.56u l=0.28u
X1383 VREFP A44_DCTRL_STRIP_W_R2_0/CTRL_OUT[7] A44_CDAC_CAP_BANK_ASSEMBLY_R8_M6_0/A44_CAP_CORE128_M6_R1_0/CAP_BOTTOM_041 VDD pfet_03v3 ad=0 pd=0 as=0 ps=0 w=1.56u l=0.28u
X1384 VREFP A44_DCTRL_STRIP_W_R2_0/CTRL_OUT[7] A44_CDAC_CAP_BANK_ASSEMBLY_R8_M6_0/A44_CAP_CORE128_M6_R1_0/CAP_BOTTOM_041 VDD pfet_03v3 ad=0 pd=0 as=0 ps=0 w=1.56u l=0.28u
X1385 VREFP A44_DCTRL_STRIP_W_R2_0/CTRL_OUT[7] A44_CDAC_CAP_BANK_ASSEMBLY_R8_M6_0/A44_CAP_CORE128_M6_R1_0/CAP_BOTTOM_041 VDD pfet_03v3 ad=0 pd=0 as=0 ps=0 w=1.56u l=0.28u
X1386 VREFP A44_DCTRL_STRIP_W_R2_0/CTRL_OUT[7] A44_CDAC_CAP_BANK_ASSEMBLY_R8_M6_0/A44_CAP_CORE128_M6_R1_0/CAP_BOTTOM_041 VDD pfet_03v3 ad=0 pd=0 as=0 ps=0 w=1.56u l=0.28u
X1387 VREFP A44_DCTRL_STRIP_W_R2_0/CTRL_OUT[7] A44_CDAC_CAP_BANK_ASSEMBLY_R8_M6_0/A44_CAP_CORE128_M6_R1_0/CAP_BOTTOM_041 VDD pfet_03v3 ad=0 pd=0 as=0 ps=0 w=1.56u l=0.28u
X1388 VREFN A44_DCTRL_STRIP_W_R2_0/CTRL_OUT[7] A44_CDAC_CAP_BANK_ASSEMBLY_R8_M6_0/A44_CAP_CORE128_M6_R1_0/CAP_BOTTOM_041 GND nfet_03v3 ad=0 pd=0 as=16.6842p ps=77.76u w=1.56u l=0.28u
X1389 VREFN A44_DCTRL_STRIP_W_R2_0/CTRL_OUT[7] A44_CDAC_CAP_BANK_ASSEMBLY_R8_M6_0/A44_CAP_CORE128_M6_R1_0/CAP_BOTTOM_041 GND nfet_03v3 ad=0 pd=0 as=0 ps=0 w=1.56u l=0.28u
X1390 VREFN A44_DCTRL_STRIP_W_R2_0/CTRL_OUT[7] A44_CDAC_CAP_BANK_ASSEMBLY_R8_M6_0/A44_CAP_CORE128_M6_R1_0/CAP_BOTTOM_041 GND nfet_03v3 ad=0 pd=0 as=0 ps=0 w=1.56u l=0.28u
X1391 VREFN A44_DCTRL_STRIP_W_R2_0/CTRL_OUT[7] A44_CDAC_CAP_BANK_ASSEMBLY_R8_M6_0/A44_CAP_CORE128_M6_R1_0/CAP_BOTTOM_041 GND nfet_03v3 ad=0 pd=0 as=0 ps=0 w=1.56u l=0.28u
X1392 VREFN A44_DCTRL_STRIP_W_R2_0/CTRL_OUT[7] A44_CDAC_CAP_BANK_ASSEMBLY_R8_M6_0/A44_CAP_CORE128_M6_R1_0/CAP_BOTTOM_041 GND nfet_03v3 ad=0 pd=0 as=0 ps=0 w=1.56u l=0.28u
X1393 VREFN A44_DCTRL_STRIP_W_R2_0/CTRL_OUT[7] A44_CDAC_CAP_BANK_ASSEMBLY_R8_M6_0/A44_CAP_CORE128_M6_R1_0/CAP_BOTTOM_041 GND nfet_03v3 ad=0 pd=0 as=0 ps=0 w=1.56u l=0.28u
X1394 VREFN A44_DCTRL_STRIP_W_R2_0/CTRL_OUT[7] A44_CDAC_CAP_BANK_ASSEMBLY_R8_M6_0/A44_CAP_CORE128_M6_R1_0/CAP_BOTTOM_041 GND nfet_03v3 ad=0 pd=0 as=0 ps=0 w=1.56u l=0.28u
X1395 VREFN A44_DCTRL_STRIP_W_R2_0/CTRL_OUT[7] A44_CDAC_CAP_BANK_ASSEMBLY_R8_M6_0/A44_CAP_CORE128_M6_R1_0/CAP_BOTTOM_041 GND nfet_03v3 ad=0 pd=0 as=0 ps=0 w=1.56u l=0.28u
X1396 VREFN A44_DCTRL_STRIP_W_R2_0/CTRL_OUT[7] A44_CDAC_CAP_BANK_ASSEMBLY_R8_M6_0/A44_CAP_CORE128_M6_R1_0/CAP_BOTTOM_041 GND nfet_03v3 ad=0 pd=0 as=0 ps=0 w=1.56u l=0.28u
X1397 VREFN A44_DCTRL_STRIP_W_R2_0/CTRL_OUT[7] A44_CDAC_CAP_BANK_ASSEMBLY_R8_M6_0/A44_CAP_CORE128_M6_R1_0/CAP_BOTTOM_041 GND nfet_03v3 ad=0 pd=0 as=0 ps=0 w=1.56u l=0.28u
X1398 VREFN A44_DCTRL_STRIP_W_R2_0/CTRL_OUT[7] A44_CDAC_CAP_BANK_ASSEMBLY_R8_M6_0/A44_CAP_CORE128_M6_R1_0/CAP_BOTTOM_041 GND nfet_03v3 ad=0 pd=0 as=0 ps=0 w=1.56u l=0.28u
X1399 VREFN A44_DCTRL_STRIP_W_R2_0/CTRL_OUT[7] A44_CDAC_CAP_BANK_ASSEMBLY_R8_M6_0/A44_CAP_CORE128_M6_R1_0/CAP_BOTTOM_041 GND nfet_03v3 ad=0 pd=0 as=0 ps=0 w=1.56u l=0.28u
X1400 VREFN A44_DCTRL_STRIP_W_R2_0/CTRL_OUT[7] A44_CDAC_CAP_BANK_ASSEMBLY_R8_M6_0/A44_CAP_CORE128_M6_R1_0/CAP_BOTTOM_041 GND nfet_03v3 ad=0 pd=0 as=0 ps=0 w=1.56u l=0.28u
X1401 VREFN A44_DCTRL_STRIP_W_R2_0/CTRL_OUT[7] A44_CDAC_CAP_BANK_ASSEMBLY_R8_M6_0/A44_CAP_CORE128_M6_R1_0/CAP_BOTTOM_041 GND nfet_03v3 ad=0 pd=0 as=0 ps=0 w=1.56u l=0.28u
X1402 VREFN A44_DCTRL_STRIP_W_R2_0/CTRL_OUT[7] A44_CDAC_CAP_BANK_ASSEMBLY_R8_M6_0/A44_CAP_CORE128_M6_R1_0/CAP_BOTTOM_041 GND nfet_03v3 ad=0 pd=0 as=0 ps=0 w=1.56u l=0.28u
X1403 VREFN A44_DCTRL_STRIP_W_R2_0/CTRL_OUT[7] A44_CDAC_CAP_BANK_ASSEMBLY_R8_M6_0/A44_CAP_CORE128_M6_R1_0/CAP_BOTTOM_041 GND nfet_03v3 ad=0 pd=0 as=0 ps=0 w=1.56u l=0.28u
X1404 VREFN A44_DCTRL_STRIP_W_R2_0/CTRL_OUT[7] A44_CDAC_CAP_BANK_ASSEMBLY_R8_M6_0/A44_CAP_CORE128_M6_R1_0/CAP_BOTTOM_041 GND nfet_03v3 ad=0 pd=0 as=0 ps=0 w=1.56u l=0.28u
X1405 VREFN A44_DCTRL_STRIP_W_R2_0/CTRL_OUT[7] A44_CDAC_CAP_BANK_ASSEMBLY_R8_M6_0/A44_CAP_CORE128_M6_R1_0/CAP_BOTTOM_041 GND nfet_03v3 ad=0 pd=0 as=0 ps=0 w=1.56u l=0.28u
X1406 VREFP A44_DCTRL_STRIP_W_R2_0/CTRL_OUT[6] A44_CDAC_CAP_BANK_ASSEMBLY_R8_M6_0/A44_CAP_CORE128_M6_R1_0/CAP_BOTTOM_007 VDD pfet_03v3 ad=0 pd=0 as=16.6842p ps=77.76u w=1.56u l=0.28u
X1407 VREFP A44_DCTRL_STRIP_W_R2_0/CTRL_OUT[6] A44_CDAC_CAP_BANK_ASSEMBLY_R8_M6_0/A44_CAP_CORE128_M6_R1_0/CAP_BOTTOM_007 VDD pfet_03v3 ad=0 pd=0 as=0 ps=0 w=1.56u l=0.28u
X1408 VREFP A44_DCTRL_STRIP_W_R2_0/CTRL_OUT[6] A44_CDAC_CAP_BANK_ASSEMBLY_R8_M6_0/A44_CAP_CORE128_M6_R1_0/CAP_BOTTOM_007 VDD pfet_03v3 ad=0 pd=0 as=0 ps=0 w=1.56u l=0.28u
X1409 VREFP A44_DCTRL_STRIP_W_R2_0/CTRL_OUT[6] A44_CDAC_CAP_BANK_ASSEMBLY_R8_M6_0/A44_CAP_CORE128_M6_R1_0/CAP_BOTTOM_007 VDD pfet_03v3 ad=0 pd=0 as=0 ps=0 w=1.56u l=0.28u
X1410 VREFP A44_DCTRL_STRIP_W_R2_0/CTRL_OUT[6] A44_CDAC_CAP_BANK_ASSEMBLY_R8_M6_0/A44_CAP_CORE128_M6_R1_0/CAP_BOTTOM_007 VDD pfet_03v3 ad=0 pd=0 as=0 ps=0 w=1.56u l=0.28u
X1411 VREFP A44_DCTRL_STRIP_W_R2_0/CTRL_OUT[6] A44_CDAC_CAP_BANK_ASSEMBLY_R8_M6_0/A44_CAP_CORE128_M6_R1_0/CAP_BOTTOM_007 VDD pfet_03v3 ad=0 pd=0 as=0 ps=0 w=1.56u l=0.28u
X1412 VREFP A44_DCTRL_STRIP_W_R2_0/CTRL_OUT[6] A44_CDAC_CAP_BANK_ASSEMBLY_R8_M6_0/A44_CAP_CORE128_M6_R1_0/CAP_BOTTOM_007 VDD pfet_03v3 ad=0 pd=0 as=0 ps=0 w=1.56u l=0.28u
X1413 VREFP A44_DCTRL_STRIP_W_R2_0/CTRL_OUT[6] A44_CDAC_CAP_BANK_ASSEMBLY_R8_M6_0/A44_CAP_CORE128_M6_R1_0/CAP_BOTTOM_007 VDD pfet_03v3 ad=0 pd=0 as=0 ps=0 w=1.56u l=0.28u
X1414 VREFP A44_DCTRL_STRIP_W_R2_0/CTRL_OUT[6] A44_CDAC_CAP_BANK_ASSEMBLY_R8_M6_0/A44_CAP_CORE128_M6_R1_0/CAP_BOTTOM_007 VDD pfet_03v3 ad=0 pd=0 as=0 ps=0 w=1.56u l=0.28u
X1415 VREFP A44_DCTRL_STRIP_W_R2_0/CTRL_OUT[6] A44_CDAC_CAP_BANK_ASSEMBLY_R8_M6_0/A44_CAP_CORE128_M6_R1_0/CAP_BOTTOM_007 VDD pfet_03v3 ad=0 pd=0 as=0 ps=0 w=1.56u l=0.28u
X1416 VREFP A44_DCTRL_STRIP_W_R2_0/CTRL_OUT[6] A44_CDAC_CAP_BANK_ASSEMBLY_R8_M6_0/A44_CAP_CORE128_M6_R1_0/CAP_BOTTOM_007 VDD pfet_03v3 ad=0 pd=0 as=0 ps=0 w=1.56u l=0.28u
X1417 VREFP A44_DCTRL_STRIP_W_R2_0/CTRL_OUT[6] A44_CDAC_CAP_BANK_ASSEMBLY_R8_M6_0/A44_CAP_CORE128_M6_R1_0/CAP_BOTTOM_007 VDD pfet_03v3 ad=0 pd=0 as=0 ps=0 w=1.56u l=0.28u
X1418 VREFP A44_DCTRL_STRIP_W_R2_0/CTRL_OUT[6] A44_CDAC_CAP_BANK_ASSEMBLY_R8_M6_0/A44_CAP_CORE128_M6_R1_0/CAP_BOTTOM_007 VDD pfet_03v3 ad=0 pd=0 as=0 ps=0 w=1.56u l=0.28u
X1419 VREFP A44_DCTRL_STRIP_W_R2_0/CTRL_OUT[6] A44_CDAC_CAP_BANK_ASSEMBLY_R8_M6_0/A44_CAP_CORE128_M6_R1_0/CAP_BOTTOM_007 VDD pfet_03v3 ad=0 pd=0 as=0 ps=0 w=1.56u l=0.28u
X1420 VREFP A44_DCTRL_STRIP_W_R2_0/CTRL_OUT[6] A44_CDAC_CAP_BANK_ASSEMBLY_R8_M6_0/A44_CAP_CORE128_M6_R1_0/CAP_BOTTOM_007 VDD pfet_03v3 ad=0 pd=0 as=0 ps=0 w=1.56u l=0.28u
X1421 VREFP A44_DCTRL_STRIP_W_R2_0/CTRL_OUT[6] A44_CDAC_CAP_BANK_ASSEMBLY_R8_M6_0/A44_CAP_CORE128_M6_R1_0/CAP_BOTTOM_007 VDD pfet_03v3 ad=0 pd=0 as=0 ps=0 w=1.56u l=0.28u
X1422 VREFP A44_DCTRL_STRIP_W_R2_0/CTRL_OUT[6] A44_CDAC_CAP_BANK_ASSEMBLY_R8_M6_0/A44_CAP_CORE128_M6_R1_0/CAP_BOTTOM_007 VDD pfet_03v3 ad=0 pd=0 as=0 ps=0 w=1.56u l=0.28u
X1423 VREFP A44_DCTRL_STRIP_W_R2_0/CTRL_OUT[6] A44_CDAC_CAP_BANK_ASSEMBLY_R8_M6_0/A44_CAP_CORE128_M6_R1_0/CAP_BOTTOM_007 VDD pfet_03v3 ad=0 pd=0 as=0 ps=0 w=1.56u l=0.28u
X1424 VREFN A44_DCTRL_STRIP_W_R2_0/CTRL_OUT[6] A44_CDAC_CAP_BANK_ASSEMBLY_R8_M6_0/A44_CAP_CORE128_M6_R1_0/CAP_BOTTOM_007 GND nfet_03v3 ad=0 pd=0 as=16.6842p ps=77.76u w=1.56u l=0.28u
X1425 VREFN A44_DCTRL_STRIP_W_R2_0/CTRL_OUT[6] A44_CDAC_CAP_BANK_ASSEMBLY_R8_M6_0/A44_CAP_CORE128_M6_R1_0/CAP_BOTTOM_007 GND nfet_03v3 ad=0 pd=0 as=0 ps=0 w=1.56u l=0.28u
X1426 VREFN A44_DCTRL_STRIP_W_R2_0/CTRL_OUT[6] A44_CDAC_CAP_BANK_ASSEMBLY_R8_M6_0/A44_CAP_CORE128_M6_R1_0/CAP_BOTTOM_007 GND nfet_03v3 ad=0 pd=0 as=0 ps=0 w=1.56u l=0.28u
X1427 VREFN A44_DCTRL_STRIP_W_R2_0/CTRL_OUT[6] A44_CDAC_CAP_BANK_ASSEMBLY_R8_M6_0/A44_CAP_CORE128_M6_R1_0/CAP_BOTTOM_007 GND nfet_03v3 ad=0 pd=0 as=0 ps=0 w=1.56u l=0.28u
X1428 VREFN A44_DCTRL_STRIP_W_R2_0/CTRL_OUT[6] A44_CDAC_CAP_BANK_ASSEMBLY_R8_M6_0/A44_CAP_CORE128_M6_R1_0/CAP_BOTTOM_007 GND nfet_03v3 ad=0 pd=0 as=0 ps=0 w=1.56u l=0.28u
X1429 VREFN A44_DCTRL_STRIP_W_R2_0/CTRL_OUT[6] A44_CDAC_CAP_BANK_ASSEMBLY_R8_M6_0/A44_CAP_CORE128_M6_R1_0/CAP_BOTTOM_007 GND nfet_03v3 ad=0 pd=0 as=0 ps=0 w=1.56u l=0.28u
X1430 VREFN A44_DCTRL_STRIP_W_R2_0/CTRL_OUT[6] A44_CDAC_CAP_BANK_ASSEMBLY_R8_M6_0/A44_CAP_CORE128_M6_R1_0/CAP_BOTTOM_007 GND nfet_03v3 ad=0 pd=0 as=0 ps=0 w=1.56u l=0.28u
X1431 VREFN A44_DCTRL_STRIP_W_R2_0/CTRL_OUT[6] A44_CDAC_CAP_BANK_ASSEMBLY_R8_M6_0/A44_CAP_CORE128_M6_R1_0/CAP_BOTTOM_007 GND nfet_03v3 ad=0 pd=0 as=0 ps=0 w=1.56u l=0.28u
X1432 VREFN A44_DCTRL_STRIP_W_R2_0/CTRL_OUT[6] A44_CDAC_CAP_BANK_ASSEMBLY_R8_M6_0/A44_CAP_CORE128_M6_R1_0/CAP_BOTTOM_007 GND nfet_03v3 ad=0 pd=0 as=0 ps=0 w=1.56u l=0.28u
X1433 VREFN A44_DCTRL_STRIP_W_R2_0/CTRL_OUT[6] A44_CDAC_CAP_BANK_ASSEMBLY_R8_M6_0/A44_CAP_CORE128_M6_R1_0/CAP_BOTTOM_007 GND nfet_03v3 ad=0 pd=0 as=0 ps=0 w=1.56u l=0.28u
X1434 VREFN A44_DCTRL_STRIP_W_R2_0/CTRL_OUT[6] A44_CDAC_CAP_BANK_ASSEMBLY_R8_M6_0/A44_CAP_CORE128_M6_R1_0/CAP_BOTTOM_007 GND nfet_03v3 ad=0 pd=0 as=0 ps=0 w=1.56u l=0.28u
X1435 VREFN A44_DCTRL_STRIP_W_R2_0/CTRL_OUT[6] A44_CDAC_CAP_BANK_ASSEMBLY_R8_M6_0/A44_CAP_CORE128_M6_R1_0/CAP_BOTTOM_007 GND nfet_03v3 ad=0 pd=0 as=0 ps=0 w=1.56u l=0.28u
X1436 VREFN A44_DCTRL_STRIP_W_R2_0/CTRL_OUT[6] A44_CDAC_CAP_BANK_ASSEMBLY_R8_M6_0/A44_CAP_CORE128_M6_R1_0/CAP_BOTTOM_007 GND nfet_03v3 ad=0 pd=0 as=0 ps=0 w=1.56u l=0.28u
X1437 VREFN A44_DCTRL_STRIP_W_R2_0/CTRL_OUT[6] A44_CDAC_CAP_BANK_ASSEMBLY_R8_M6_0/A44_CAP_CORE128_M6_R1_0/CAP_BOTTOM_007 GND nfet_03v3 ad=0 pd=0 as=0 ps=0 w=1.56u l=0.28u
X1438 VREFN A44_DCTRL_STRIP_W_R2_0/CTRL_OUT[6] A44_CDAC_CAP_BANK_ASSEMBLY_R8_M6_0/A44_CAP_CORE128_M6_R1_0/CAP_BOTTOM_007 GND nfet_03v3 ad=0 pd=0 as=0 ps=0 w=1.56u l=0.28u
X1439 VREFN A44_DCTRL_STRIP_W_R2_0/CTRL_OUT[6] A44_CDAC_CAP_BANK_ASSEMBLY_R8_M6_0/A44_CAP_CORE128_M6_R1_0/CAP_BOTTOM_007 GND nfet_03v3 ad=0 pd=0 as=0 ps=0 w=1.56u l=0.28u
X1440 VREFN A44_DCTRL_STRIP_W_R2_0/CTRL_OUT[6] A44_CDAC_CAP_BANK_ASSEMBLY_R8_M6_0/A44_CAP_CORE128_M6_R1_0/CAP_BOTTOM_007 GND nfet_03v3 ad=0 pd=0 as=0 ps=0 w=1.56u l=0.28u
X1441 VREFN A44_DCTRL_STRIP_W_R2_0/CTRL_OUT[6] A44_CDAC_CAP_BANK_ASSEMBLY_R8_M6_0/A44_CAP_CORE128_M6_R1_0/CAP_BOTTOM_007 GND nfet_03v3 ad=0 pd=0 as=0 ps=0 w=1.56u l=0.28u
X1442 VREFP A44_DCTRL_STRIP_W_R2_0/CTRL_OUT[7] A44_CDAC_CAP_BANK_ASSEMBLY_R8_M6_0/A44_CAP_CORE128_M6_R1_0/CAP_BOTTOM_004 VDD pfet_03v3 ad=0 pd=0 as=16.6842p ps=77.76u w=1.56u l=0.28u
X1443 VREFP A44_DCTRL_STRIP_W_R2_0/CTRL_OUT[7] A44_CDAC_CAP_BANK_ASSEMBLY_R8_M6_0/A44_CAP_CORE128_M6_R1_0/CAP_BOTTOM_004 VDD pfet_03v3 ad=0 pd=0 as=0 ps=0 w=1.56u l=0.28u
X1444 VREFP A44_DCTRL_STRIP_W_R2_0/CTRL_OUT[7] A44_CDAC_CAP_BANK_ASSEMBLY_R8_M6_0/A44_CAP_CORE128_M6_R1_0/CAP_BOTTOM_004 VDD pfet_03v3 ad=0 pd=0 as=0 ps=0 w=1.56u l=0.28u
X1445 VREFP A44_DCTRL_STRIP_W_R2_0/CTRL_OUT[7] A44_CDAC_CAP_BANK_ASSEMBLY_R8_M6_0/A44_CAP_CORE128_M6_R1_0/CAP_BOTTOM_004 VDD pfet_03v3 ad=0 pd=0 as=0 ps=0 w=1.56u l=0.28u
X1446 VREFP A44_DCTRL_STRIP_W_R2_0/CTRL_OUT[7] A44_CDAC_CAP_BANK_ASSEMBLY_R8_M6_0/A44_CAP_CORE128_M6_R1_0/CAP_BOTTOM_004 VDD pfet_03v3 ad=0 pd=0 as=0 ps=0 w=1.56u l=0.28u
X1447 VREFP A44_DCTRL_STRIP_W_R2_0/CTRL_OUT[7] A44_CDAC_CAP_BANK_ASSEMBLY_R8_M6_0/A44_CAP_CORE128_M6_R1_0/CAP_BOTTOM_004 VDD pfet_03v3 ad=0 pd=0 as=0 ps=0 w=1.56u l=0.28u
X1448 VREFP A44_DCTRL_STRIP_W_R2_0/CTRL_OUT[7] A44_CDAC_CAP_BANK_ASSEMBLY_R8_M6_0/A44_CAP_CORE128_M6_R1_0/CAP_BOTTOM_004 VDD pfet_03v3 ad=0 pd=0 as=0 ps=0 w=1.56u l=0.28u
X1449 VREFP A44_DCTRL_STRIP_W_R2_0/CTRL_OUT[7] A44_CDAC_CAP_BANK_ASSEMBLY_R8_M6_0/A44_CAP_CORE128_M6_R1_0/CAP_BOTTOM_004 VDD pfet_03v3 ad=0 pd=0 as=0 ps=0 w=1.56u l=0.28u
X1450 VREFP A44_DCTRL_STRIP_W_R2_0/CTRL_OUT[7] A44_CDAC_CAP_BANK_ASSEMBLY_R8_M6_0/A44_CAP_CORE128_M6_R1_0/CAP_BOTTOM_004 VDD pfet_03v3 ad=0 pd=0 as=0 ps=0 w=1.56u l=0.28u
X1451 VREFP A44_DCTRL_STRIP_W_R2_0/CTRL_OUT[7] A44_CDAC_CAP_BANK_ASSEMBLY_R8_M6_0/A44_CAP_CORE128_M6_R1_0/CAP_BOTTOM_004 VDD pfet_03v3 ad=0 pd=0 as=0 ps=0 w=1.56u l=0.28u
X1452 VREFP A44_DCTRL_STRIP_W_R2_0/CTRL_OUT[7] A44_CDAC_CAP_BANK_ASSEMBLY_R8_M6_0/A44_CAP_CORE128_M6_R1_0/CAP_BOTTOM_004 VDD pfet_03v3 ad=0 pd=0 as=0 ps=0 w=1.56u l=0.28u
X1453 VREFP A44_DCTRL_STRIP_W_R2_0/CTRL_OUT[7] A44_CDAC_CAP_BANK_ASSEMBLY_R8_M6_0/A44_CAP_CORE128_M6_R1_0/CAP_BOTTOM_004 VDD pfet_03v3 ad=0 pd=0 as=0 ps=0 w=1.56u l=0.28u
X1454 VREFP A44_DCTRL_STRIP_W_R2_0/CTRL_OUT[7] A44_CDAC_CAP_BANK_ASSEMBLY_R8_M6_0/A44_CAP_CORE128_M6_R1_0/CAP_BOTTOM_004 VDD pfet_03v3 ad=0 pd=0 as=0 ps=0 w=1.56u l=0.28u
X1455 VREFP A44_DCTRL_STRIP_W_R2_0/CTRL_OUT[7] A44_CDAC_CAP_BANK_ASSEMBLY_R8_M6_0/A44_CAP_CORE128_M6_R1_0/CAP_BOTTOM_004 VDD pfet_03v3 ad=0 pd=0 as=0 ps=0 w=1.56u l=0.28u
X1456 VREFP A44_DCTRL_STRIP_W_R2_0/CTRL_OUT[7] A44_CDAC_CAP_BANK_ASSEMBLY_R8_M6_0/A44_CAP_CORE128_M6_R1_0/CAP_BOTTOM_004 VDD pfet_03v3 ad=0 pd=0 as=0 ps=0 w=1.56u l=0.28u
X1457 VREFP A44_DCTRL_STRIP_W_R2_0/CTRL_OUT[7] A44_CDAC_CAP_BANK_ASSEMBLY_R8_M6_0/A44_CAP_CORE128_M6_R1_0/CAP_BOTTOM_004 VDD pfet_03v3 ad=0 pd=0 as=0 ps=0 w=1.56u l=0.28u
X1458 VREFP A44_DCTRL_STRIP_W_R2_0/CTRL_OUT[7] A44_CDAC_CAP_BANK_ASSEMBLY_R8_M6_0/A44_CAP_CORE128_M6_R1_0/CAP_BOTTOM_004 VDD pfet_03v3 ad=0 pd=0 as=0 ps=0 w=1.56u l=0.28u
X1459 VREFP A44_DCTRL_STRIP_W_R2_0/CTRL_OUT[7] A44_CDAC_CAP_BANK_ASSEMBLY_R8_M6_0/A44_CAP_CORE128_M6_R1_0/CAP_BOTTOM_004 VDD pfet_03v3 ad=0 pd=0 as=0 ps=0 w=1.56u l=0.28u
X1460 VREFN A44_DCTRL_STRIP_W_R2_0/CTRL_OUT[7] A44_CDAC_CAP_BANK_ASSEMBLY_R8_M6_0/A44_CAP_CORE128_M6_R1_0/CAP_BOTTOM_004 GND nfet_03v3 ad=0 pd=0 as=16.6842p ps=77.76u w=1.56u l=0.28u
X1461 VREFN A44_DCTRL_STRIP_W_R2_0/CTRL_OUT[7] A44_CDAC_CAP_BANK_ASSEMBLY_R8_M6_0/A44_CAP_CORE128_M6_R1_0/CAP_BOTTOM_004 GND nfet_03v3 ad=0 pd=0 as=0 ps=0 w=1.56u l=0.28u
X1462 VREFN A44_DCTRL_STRIP_W_R2_0/CTRL_OUT[7] A44_CDAC_CAP_BANK_ASSEMBLY_R8_M6_0/A44_CAP_CORE128_M6_R1_0/CAP_BOTTOM_004 GND nfet_03v3 ad=0 pd=0 as=0 ps=0 w=1.56u l=0.28u
X1463 VREFN A44_DCTRL_STRIP_W_R2_0/CTRL_OUT[7] A44_CDAC_CAP_BANK_ASSEMBLY_R8_M6_0/A44_CAP_CORE128_M6_R1_0/CAP_BOTTOM_004 GND nfet_03v3 ad=0 pd=0 as=0 ps=0 w=1.56u l=0.28u
X1464 VREFN A44_DCTRL_STRIP_W_R2_0/CTRL_OUT[7] A44_CDAC_CAP_BANK_ASSEMBLY_R8_M6_0/A44_CAP_CORE128_M6_R1_0/CAP_BOTTOM_004 GND nfet_03v3 ad=0 pd=0 as=0 ps=0 w=1.56u l=0.28u
X1465 VREFN A44_DCTRL_STRIP_W_R2_0/CTRL_OUT[7] A44_CDAC_CAP_BANK_ASSEMBLY_R8_M6_0/A44_CAP_CORE128_M6_R1_0/CAP_BOTTOM_004 GND nfet_03v3 ad=0 pd=0 as=0 ps=0 w=1.56u l=0.28u
X1466 VREFN A44_DCTRL_STRIP_W_R2_0/CTRL_OUT[7] A44_CDAC_CAP_BANK_ASSEMBLY_R8_M6_0/A44_CAP_CORE128_M6_R1_0/CAP_BOTTOM_004 GND nfet_03v3 ad=0 pd=0 as=0 ps=0 w=1.56u l=0.28u
X1467 VREFN A44_DCTRL_STRIP_W_R2_0/CTRL_OUT[7] A44_CDAC_CAP_BANK_ASSEMBLY_R8_M6_0/A44_CAP_CORE128_M6_R1_0/CAP_BOTTOM_004 GND nfet_03v3 ad=0 pd=0 as=0 ps=0 w=1.56u l=0.28u
X1468 VREFN A44_DCTRL_STRIP_W_R2_0/CTRL_OUT[7] A44_CDAC_CAP_BANK_ASSEMBLY_R8_M6_0/A44_CAP_CORE128_M6_R1_0/CAP_BOTTOM_004 GND nfet_03v3 ad=0 pd=0 as=0 ps=0 w=1.56u l=0.28u
X1469 VREFN A44_DCTRL_STRIP_W_R2_0/CTRL_OUT[7] A44_CDAC_CAP_BANK_ASSEMBLY_R8_M6_0/A44_CAP_CORE128_M6_R1_0/CAP_BOTTOM_004 GND nfet_03v3 ad=0 pd=0 as=0 ps=0 w=1.56u l=0.28u
X1470 VREFN A44_DCTRL_STRIP_W_R2_0/CTRL_OUT[7] A44_CDAC_CAP_BANK_ASSEMBLY_R8_M6_0/A44_CAP_CORE128_M6_R1_0/CAP_BOTTOM_004 GND nfet_03v3 ad=0 pd=0 as=0 ps=0 w=1.56u l=0.28u
X1471 VREFN A44_DCTRL_STRIP_W_R2_0/CTRL_OUT[7] A44_CDAC_CAP_BANK_ASSEMBLY_R8_M6_0/A44_CAP_CORE128_M6_R1_0/CAP_BOTTOM_004 GND nfet_03v3 ad=0 pd=0 as=0 ps=0 w=1.56u l=0.28u
X1472 VREFN A44_DCTRL_STRIP_W_R2_0/CTRL_OUT[7] A44_CDAC_CAP_BANK_ASSEMBLY_R8_M6_0/A44_CAP_CORE128_M6_R1_0/CAP_BOTTOM_004 GND nfet_03v3 ad=0 pd=0 as=0 ps=0 w=1.56u l=0.28u
X1473 VREFN A44_DCTRL_STRIP_W_R2_0/CTRL_OUT[7] A44_CDAC_CAP_BANK_ASSEMBLY_R8_M6_0/A44_CAP_CORE128_M6_R1_0/CAP_BOTTOM_004 GND nfet_03v3 ad=0 pd=0 as=0 ps=0 w=1.56u l=0.28u
X1474 VREFN A44_DCTRL_STRIP_W_R2_0/CTRL_OUT[7] A44_CDAC_CAP_BANK_ASSEMBLY_R8_M6_0/A44_CAP_CORE128_M6_R1_0/CAP_BOTTOM_004 GND nfet_03v3 ad=0 pd=0 as=0 ps=0 w=1.56u l=0.28u
X1475 VREFN A44_DCTRL_STRIP_W_R2_0/CTRL_OUT[7] A44_CDAC_CAP_BANK_ASSEMBLY_R8_M6_0/A44_CAP_CORE128_M6_R1_0/CAP_BOTTOM_004 GND nfet_03v3 ad=0 pd=0 as=0 ps=0 w=1.56u l=0.28u
X1476 VREFN A44_DCTRL_STRIP_W_R2_0/CTRL_OUT[7] A44_CDAC_CAP_BANK_ASSEMBLY_R8_M6_0/A44_CAP_CORE128_M6_R1_0/CAP_BOTTOM_004 GND nfet_03v3 ad=0 pd=0 as=0 ps=0 w=1.56u l=0.28u
X1477 VREFN A44_DCTRL_STRIP_W_R2_0/CTRL_OUT[7] A44_CDAC_CAP_BANK_ASSEMBLY_R8_M6_0/A44_CAP_CORE128_M6_R1_0/CAP_BOTTOM_004 GND nfet_03v3 ad=0 pd=0 as=0 ps=0 w=1.56u l=0.28u
X1478 VREFP A44_DCTRL_STRIP_W_R2_0/CTRL_OUT[7] A44_CDAC_CAP_BANK_ASSEMBLY_R8_M6_0/A44_CAP_CORE128_M6_R1_0/CAP_BOTTOM_033 VDD pfet_03v3 ad=0 pd=0 as=16.6842p ps=77.76u w=1.56u l=0.28u
X1479 VREFP A44_DCTRL_STRIP_W_R2_0/CTRL_OUT[7] A44_CDAC_CAP_BANK_ASSEMBLY_R8_M6_0/A44_CAP_CORE128_M6_R1_0/CAP_BOTTOM_033 VDD pfet_03v3 ad=0 pd=0 as=0 ps=0 w=1.56u l=0.28u
X1480 VREFP A44_DCTRL_STRIP_W_R2_0/CTRL_OUT[7] A44_CDAC_CAP_BANK_ASSEMBLY_R8_M6_0/A44_CAP_CORE128_M6_R1_0/CAP_BOTTOM_033 VDD pfet_03v3 ad=0 pd=0 as=0 ps=0 w=1.56u l=0.28u
X1481 VREFP A44_DCTRL_STRIP_W_R2_0/CTRL_OUT[7] A44_CDAC_CAP_BANK_ASSEMBLY_R8_M6_0/A44_CAP_CORE128_M6_R1_0/CAP_BOTTOM_033 VDD pfet_03v3 ad=0 pd=0 as=0 ps=0 w=1.56u l=0.28u
X1482 VREFP A44_DCTRL_STRIP_W_R2_0/CTRL_OUT[7] A44_CDAC_CAP_BANK_ASSEMBLY_R8_M6_0/A44_CAP_CORE128_M6_R1_0/CAP_BOTTOM_033 VDD pfet_03v3 ad=0 pd=0 as=0 ps=0 w=1.56u l=0.28u
X1483 VREFP A44_DCTRL_STRIP_W_R2_0/CTRL_OUT[7] A44_CDAC_CAP_BANK_ASSEMBLY_R8_M6_0/A44_CAP_CORE128_M6_R1_0/CAP_BOTTOM_033 VDD pfet_03v3 ad=0 pd=0 as=0 ps=0 w=1.56u l=0.28u
X1484 VREFP A44_DCTRL_STRIP_W_R2_0/CTRL_OUT[7] A44_CDAC_CAP_BANK_ASSEMBLY_R8_M6_0/A44_CAP_CORE128_M6_R1_0/CAP_BOTTOM_033 VDD pfet_03v3 ad=0 pd=0 as=0 ps=0 w=1.56u l=0.28u
X1485 VREFP A44_DCTRL_STRIP_W_R2_0/CTRL_OUT[7] A44_CDAC_CAP_BANK_ASSEMBLY_R8_M6_0/A44_CAP_CORE128_M6_R1_0/CAP_BOTTOM_033 VDD pfet_03v3 ad=0 pd=0 as=0 ps=0 w=1.56u l=0.28u
X1486 VREFP A44_DCTRL_STRIP_W_R2_0/CTRL_OUT[7] A44_CDAC_CAP_BANK_ASSEMBLY_R8_M6_0/A44_CAP_CORE128_M6_R1_0/CAP_BOTTOM_033 VDD pfet_03v3 ad=0 pd=0 as=0 ps=0 w=1.56u l=0.28u
X1487 VREFP A44_DCTRL_STRIP_W_R2_0/CTRL_OUT[7] A44_CDAC_CAP_BANK_ASSEMBLY_R8_M6_0/A44_CAP_CORE128_M6_R1_0/CAP_BOTTOM_033 VDD pfet_03v3 ad=0 pd=0 as=0 ps=0 w=1.56u l=0.28u
X1488 VREFP A44_DCTRL_STRIP_W_R2_0/CTRL_OUT[7] A44_CDAC_CAP_BANK_ASSEMBLY_R8_M6_0/A44_CAP_CORE128_M6_R1_0/CAP_BOTTOM_033 VDD pfet_03v3 ad=0 pd=0 as=0 ps=0 w=1.56u l=0.28u
X1489 VREFP A44_DCTRL_STRIP_W_R2_0/CTRL_OUT[7] A44_CDAC_CAP_BANK_ASSEMBLY_R8_M6_0/A44_CAP_CORE128_M6_R1_0/CAP_BOTTOM_033 VDD pfet_03v3 ad=0 pd=0 as=0 ps=0 w=1.56u l=0.28u
X1490 VREFP A44_DCTRL_STRIP_W_R2_0/CTRL_OUT[7] A44_CDAC_CAP_BANK_ASSEMBLY_R8_M6_0/A44_CAP_CORE128_M6_R1_0/CAP_BOTTOM_033 VDD pfet_03v3 ad=0 pd=0 as=0 ps=0 w=1.56u l=0.28u
X1491 VREFP A44_DCTRL_STRIP_W_R2_0/CTRL_OUT[7] A44_CDAC_CAP_BANK_ASSEMBLY_R8_M6_0/A44_CAP_CORE128_M6_R1_0/CAP_BOTTOM_033 VDD pfet_03v3 ad=0 pd=0 as=0 ps=0 w=1.56u l=0.28u
X1492 VREFP A44_DCTRL_STRIP_W_R2_0/CTRL_OUT[7] A44_CDAC_CAP_BANK_ASSEMBLY_R8_M6_0/A44_CAP_CORE128_M6_R1_0/CAP_BOTTOM_033 VDD pfet_03v3 ad=0 pd=0 as=0 ps=0 w=1.56u l=0.28u
X1493 VREFP A44_DCTRL_STRIP_W_R2_0/CTRL_OUT[7] A44_CDAC_CAP_BANK_ASSEMBLY_R8_M6_0/A44_CAP_CORE128_M6_R1_0/CAP_BOTTOM_033 VDD pfet_03v3 ad=0 pd=0 as=0 ps=0 w=1.56u l=0.28u
X1494 VREFP A44_DCTRL_STRIP_W_R2_0/CTRL_OUT[7] A44_CDAC_CAP_BANK_ASSEMBLY_R8_M6_0/A44_CAP_CORE128_M6_R1_0/CAP_BOTTOM_033 VDD pfet_03v3 ad=0 pd=0 as=0 ps=0 w=1.56u l=0.28u
X1495 VREFP A44_DCTRL_STRIP_W_R2_0/CTRL_OUT[7] A44_CDAC_CAP_BANK_ASSEMBLY_R8_M6_0/A44_CAP_CORE128_M6_R1_0/CAP_BOTTOM_033 VDD pfet_03v3 ad=0 pd=0 as=0 ps=0 w=1.56u l=0.28u
X1496 VREFN A44_DCTRL_STRIP_W_R2_0/CTRL_OUT[7] A44_CDAC_CAP_BANK_ASSEMBLY_R8_M6_0/A44_CAP_CORE128_M6_R1_0/CAP_BOTTOM_033 GND nfet_03v3 ad=0 pd=0 as=16.6842p ps=77.76u w=1.56u l=0.28u
X1497 VREFN A44_DCTRL_STRIP_W_R2_0/CTRL_OUT[7] A44_CDAC_CAP_BANK_ASSEMBLY_R8_M6_0/A44_CAP_CORE128_M6_R1_0/CAP_BOTTOM_033 GND nfet_03v3 ad=0 pd=0 as=0 ps=0 w=1.56u l=0.28u
X1498 VREFN A44_DCTRL_STRIP_W_R2_0/CTRL_OUT[7] A44_CDAC_CAP_BANK_ASSEMBLY_R8_M6_0/A44_CAP_CORE128_M6_R1_0/CAP_BOTTOM_033 GND nfet_03v3 ad=0 pd=0 as=0 ps=0 w=1.56u l=0.28u
X1499 VREFN A44_DCTRL_STRIP_W_R2_0/CTRL_OUT[7] A44_CDAC_CAP_BANK_ASSEMBLY_R8_M6_0/A44_CAP_CORE128_M6_R1_0/CAP_BOTTOM_033 GND nfet_03v3 ad=0 pd=0 as=0 ps=0 w=1.56u l=0.28u
X1500 VREFN A44_DCTRL_STRIP_W_R2_0/CTRL_OUT[7] A44_CDAC_CAP_BANK_ASSEMBLY_R8_M6_0/A44_CAP_CORE128_M6_R1_0/CAP_BOTTOM_033 GND nfet_03v3 ad=0 pd=0 as=0 ps=0 w=1.56u l=0.28u
X1501 VREFN A44_DCTRL_STRIP_W_R2_0/CTRL_OUT[7] A44_CDAC_CAP_BANK_ASSEMBLY_R8_M6_0/A44_CAP_CORE128_M6_R1_0/CAP_BOTTOM_033 GND nfet_03v3 ad=0 pd=0 as=0 ps=0 w=1.56u l=0.28u
X1502 VREFN A44_DCTRL_STRIP_W_R2_0/CTRL_OUT[7] A44_CDAC_CAP_BANK_ASSEMBLY_R8_M6_0/A44_CAP_CORE128_M6_R1_0/CAP_BOTTOM_033 GND nfet_03v3 ad=0 pd=0 as=0 ps=0 w=1.56u l=0.28u
X1503 VREFN A44_DCTRL_STRIP_W_R2_0/CTRL_OUT[7] A44_CDAC_CAP_BANK_ASSEMBLY_R8_M6_0/A44_CAP_CORE128_M6_R1_0/CAP_BOTTOM_033 GND nfet_03v3 ad=0 pd=0 as=0 ps=0 w=1.56u l=0.28u
X1504 VREFN A44_DCTRL_STRIP_W_R2_0/CTRL_OUT[7] A44_CDAC_CAP_BANK_ASSEMBLY_R8_M6_0/A44_CAP_CORE128_M6_R1_0/CAP_BOTTOM_033 GND nfet_03v3 ad=0 pd=0 as=0 ps=0 w=1.56u l=0.28u
X1505 VREFN A44_DCTRL_STRIP_W_R2_0/CTRL_OUT[7] A44_CDAC_CAP_BANK_ASSEMBLY_R8_M6_0/A44_CAP_CORE128_M6_R1_0/CAP_BOTTOM_033 GND nfet_03v3 ad=0 pd=0 as=0 ps=0 w=1.56u l=0.28u
X1506 VREFN A44_DCTRL_STRIP_W_R2_0/CTRL_OUT[7] A44_CDAC_CAP_BANK_ASSEMBLY_R8_M6_0/A44_CAP_CORE128_M6_R1_0/CAP_BOTTOM_033 GND nfet_03v3 ad=0 pd=0 as=0 ps=0 w=1.56u l=0.28u
X1507 VREFN A44_DCTRL_STRIP_W_R2_0/CTRL_OUT[7] A44_CDAC_CAP_BANK_ASSEMBLY_R8_M6_0/A44_CAP_CORE128_M6_R1_0/CAP_BOTTOM_033 GND nfet_03v3 ad=0 pd=0 as=0 ps=0 w=1.56u l=0.28u
X1508 VREFN A44_DCTRL_STRIP_W_R2_0/CTRL_OUT[7] A44_CDAC_CAP_BANK_ASSEMBLY_R8_M6_0/A44_CAP_CORE128_M6_R1_0/CAP_BOTTOM_033 GND nfet_03v3 ad=0 pd=0 as=0 ps=0 w=1.56u l=0.28u
X1509 VREFN A44_DCTRL_STRIP_W_R2_0/CTRL_OUT[7] A44_CDAC_CAP_BANK_ASSEMBLY_R8_M6_0/A44_CAP_CORE128_M6_R1_0/CAP_BOTTOM_033 GND nfet_03v3 ad=0 pd=0 as=0 ps=0 w=1.56u l=0.28u
X1510 VREFN A44_DCTRL_STRIP_W_R2_0/CTRL_OUT[7] A44_CDAC_CAP_BANK_ASSEMBLY_R8_M6_0/A44_CAP_CORE128_M6_R1_0/CAP_BOTTOM_033 GND nfet_03v3 ad=0 pd=0 as=0 ps=0 w=1.56u l=0.28u
X1511 VREFN A44_DCTRL_STRIP_W_R2_0/CTRL_OUT[7] A44_CDAC_CAP_BANK_ASSEMBLY_R8_M6_0/A44_CAP_CORE128_M6_R1_0/CAP_BOTTOM_033 GND nfet_03v3 ad=0 pd=0 as=0 ps=0 w=1.56u l=0.28u
X1512 VREFN A44_DCTRL_STRIP_W_R2_0/CTRL_OUT[7] A44_CDAC_CAP_BANK_ASSEMBLY_R8_M6_0/A44_CAP_CORE128_M6_R1_0/CAP_BOTTOM_033 GND nfet_03v3 ad=0 pd=0 as=0 ps=0 w=1.56u l=0.28u
X1513 VREFN A44_DCTRL_STRIP_W_R2_0/CTRL_OUT[7] A44_CDAC_CAP_BANK_ASSEMBLY_R8_M6_0/A44_CAP_CORE128_M6_R1_0/CAP_BOTTOM_033 GND nfet_03v3 ad=0 pd=0 as=0 ps=0 w=1.56u l=0.28u
X1514 VREFP A44_DCTRL_STRIP_W_R2_0/CTRL_OUT[4] A44_CDAC_CAP_BANK_ASSEMBLY_R8_M6_0/A44_CAP_CORE128_M6_R1_0/CAP_BOTTOM_030 VDD pfet_03v3 ad=0 pd=0 as=16.6842p ps=77.76u w=1.56u l=0.28u
X1515 VREFP A44_DCTRL_STRIP_W_R2_0/CTRL_OUT[4] A44_CDAC_CAP_BANK_ASSEMBLY_R8_M6_0/A44_CAP_CORE128_M6_R1_0/CAP_BOTTOM_030 VDD pfet_03v3 ad=0 pd=0 as=0 ps=0 w=1.56u l=0.28u
X1516 VREFP A44_DCTRL_STRIP_W_R2_0/CTRL_OUT[4] A44_CDAC_CAP_BANK_ASSEMBLY_R8_M6_0/A44_CAP_CORE128_M6_R1_0/CAP_BOTTOM_030 VDD pfet_03v3 ad=0 pd=0 as=0 ps=0 w=1.56u l=0.28u
X1517 VREFP A44_DCTRL_STRIP_W_R2_0/CTRL_OUT[4] A44_CDAC_CAP_BANK_ASSEMBLY_R8_M6_0/A44_CAP_CORE128_M6_R1_0/CAP_BOTTOM_030 VDD pfet_03v3 ad=0 pd=0 as=0 ps=0 w=1.56u l=0.28u
X1518 VREFP A44_DCTRL_STRIP_W_R2_0/CTRL_OUT[4] A44_CDAC_CAP_BANK_ASSEMBLY_R8_M6_0/A44_CAP_CORE128_M6_R1_0/CAP_BOTTOM_030 VDD pfet_03v3 ad=0 pd=0 as=0 ps=0 w=1.56u l=0.28u
X1519 VREFP A44_DCTRL_STRIP_W_R2_0/CTRL_OUT[4] A44_CDAC_CAP_BANK_ASSEMBLY_R8_M6_0/A44_CAP_CORE128_M6_R1_0/CAP_BOTTOM_030 VDD pfet_03v3 ad=0 pd=0 as=0 ps=0 w=1.56u l=0.28u
X1520 VREFP A44_DCTRL_STRIP_W_R2_0/CTRL_OUT[4] A44_CDAC_CAP_BANK_ASSEMBLY_R8_M6_0/A44_CAP_CORE128_M6_R1_0/CAP_BOTTOM_030 VDD pfet_03v3 ad=0 pd=0 as=0 ps=0 w=1.56u l=0.28u
X1521 VREFP A44_DCTRL_STRIP_W_R2_0/CTRL_OUT[4] A44_CDAC_CAP_BANK_ASSEMBLY_R8_M6_0/A44_CAP_CORE128_M6_R1_0/CAP_BOTTOM_030 VDD pfet_03v3 ad=0 pd=0 as=0 ps=0 w=1.56u l=0.28u
X1522 VREFP A44_DCTRL_STRIP_W_R2_0/CTRL_OUT[4] A44_CDAC_CAP_BANK_ASSEMBLY_R8_M6_0/A44_CAP_CORE128_M6_R1_0/CAP_BOTTOM_030 VDD pfet_03v3 ad=0 pd=0 as=0 ps=0 w=1.56u l=0.28u
X1523 VREFP A44_DCTRL_STRIP_W_R2_0/CTRL_OUT[4] A44_CDAC_CAP_BANK_ASSEMBLY_R8_M6_0/A44_CAP_CORE128_M6_R1_0/CAP_BOTTOM_030 VDD pfet_03v3 ad=0 pd=0 as=0 ps=0 w=1.56u l=0.28u
X1524 VREFP A44_DCTRL_STRIP_W_R2_0/CTRL_OUT[4] A44_CDAC_CAP_BANK_ASSEMBLY_R8_M6_0/A44_CAP_CORE128_M6_R1_0/CAP_BOTTOM_030 VDD pfet_03v3 ad=0 pd=0 as=0 ps=0 w=1.56u l=0.28u
X1525 VREFP A44_DCTRL_STRIP_W_R2_0/CTRL_OUT[4] A44_CDAC_CAP_BANK_ASSEMBLY_R8_M6_0/A44_CAP_CORE128_M6_R1_0/CAP_BOTTOM_030 VDD pfet_03v3 ad=0 pd=0 as=0 ps=0 w=1.56u l=0.28u
X1526 VREFP A44_DCTRL_STRIP_W_R2_0/CTRL_OUT[4] A44_CDAC_CAP_BANK_ASSEMBLY_R8_M6_0/A44_CAP_CORE128_M6_R1_0/CAP_BOTTOM_030 VDD pfet_03v3 ad=0 pd=0 as=0 ps=0 w=1.56u l=0.28u
X1527 VREFP A44_DCTRL_STRIP_W_R2_0/CTRL_OUT[4] A44_CDAC_CAP_BANK_ASSEMBLY_R8_M6_0/A44_CAP_CORE128_M6_R1_0/CAP_BOTTOM_030 VDD pfet_03v3 ad=0 pd=0 as=0 ps=0 w=1.56u l=0.28u
X1528 VREFP A44_DCTRL_STRIP_W_R2_0/CTRL_OUT[4] A44_CDAC_CAP_BANK_ASSEMBLY_R8_M6_0/A44_CAP_CORE128_M6_R1_0/CAP_BOTTOM_030 VDD pfet_03v3 ad=0 pd=0 as=0 ps=0 w=1.56u l=0.28u
X1529 VREFP A44_DCTRL_STRIP_W_R2_0/CTRL_OUT[4] A44_CDAC_CAP_BANK_ASSEMBLY_R8_M6_0/A44_CAP_CORE128_M6_R1_0/CAP_BOTTOM_030 VDD pfet_03v3 ad=0 pd=0 as=0 ps=0 w=1.56u l=0.28u
X1530 VREFP A44_DCTRL_STRIP_W_R2_0/CTRL_OUT[4] A44_CDAC_CAP_BANK_ASSEMBLY_R8_M6_0/A44_CAP_CORE128_M6_R1_0/CAP_BOTTOM_030 VDD pfet_03v3 ad=0 pd=0 as=0 ps=0 w=1.56u l=0.28u
X1531 VREFP A44_DCTRL_STRIP_W_R2_0/CTRL_OUT[4] A44_CDAC_CAP_BANK_ASSEMBLY_R8_M6_0/A44_CAP_CORE128_M6_R1_0/CAP_BOTTOM_030 VDD pfet_03v3 ad=0 pd=0 as=0 ps=0 w=1.56u l=0.28u
X1532 VREFN A44_DCTRL_STRIP_W_R2_0/CTRL_OUT[4] A44_CDAC_CAP_BANK_ASSEMBLY_R8_M6_0/A44_CAP_CORE128_M6_R1_0/CAP_BOTTOM_030 GND nfet_03v3 ad=0 pd=0 as=16.6842p ps=77.76u w=1.56u l=0.28u
X1533 VREFN A44_DCTRL_STRIP_W_R2_0/CTRL_OUT[4] A44_CDAC_CAP_BANK_ASSEMBLY_R8_M6_0/A44_CAP_CORE128_M6_R1_0/CAP_BOTTOM_030 GND nfet_03v3 ad=0 pd=0 as=0 ps=0 w=1.56u l=0.28u
X1534 VREFN A44_DCTRL_STRIP_W_R2_0/CTRL_OUT[4] A44_CDAC_CAP_BANK_ASSEMBLY_R8_M6_0/A44_CAP_CORE128_M6_R1_0/CAP_BOTTOM_030 GND nfet_03v3 ad=0 pd=0 as=0 ps=0 w=1.56u l=0.28u
X1535 VREFN A44_DCTRL_STRIP_W_R2_0/CTRL_OUT[4] A44_CDAC_CAP_BANK_ASSEMBLY_R8_M6_0/A44_CAP_CORE128_M6_R1_0/CAP_BOTTOM_030 GND nfet_03v3 ad=0 pd=0 as=0 ps=0 w=1.56u l=0.28u
X1536 VREFN A44_DCTRL_STRIP_W_R2_0/CTRL_OUT[4] A44_CDAC_CAP_BANK_ASSEMBLY_R8_M6_0/A44_CAP_CORE128_M6_R1_0/CAP_BOTTOM_030 GND nfet_03v3 ad=0 pd=0 as=0 ps=0 w=1.56u l=0.28u
X1537 VREFN A44_DCTRL_STRIP_W_R2_0/CTRL_OUT[4] A44_CDAC_CAP_BANK_ASSEMBLY_R8_M6_0/A44_CAP_CORE128_M6_R1_0/CAP_BOTTOM_030 GND nfet_03v3 ad=0 pd=0 as=0 ps=0 w=1.56u l=0.28u
X1538 VREFN A44_DCTRL_STRIP_W_R2_0/CTRL_OUT[4] A44_CDAC_CAP_BANK_ASSEMBLY_R8_M6_0/A44_CAP_CORE128_M6_R1_0/CAP_BOTTOM_030 GND nfet_03v3 ad=0 pd=0 as=0 ps=0 w=1.56u l=0.28u
X1539 VREFN A44_DCTRL_STRIP_W_R2_0/CTRL_OUT[4] A44_CDAC_CAP_BANK_ASSEMBLY_R8_M6_0/A44_CAP_CORE128_M6_R1_0/CAP_BOTTOM_030 GND nfet_03v3 ad=0 pd=0 as=0 ps=0 w=1.56u l=0.28u
X1540 VREFN A44_DCTRL_STRIP_W_R2_0/CTRL_OUT[4] A44_CDAC_CAP_BANK_ASSEMBLY_R8_M6_0/A44_CAP_CORE128_M6_R1_0/CAP_BOTTOM_030 GND nfet_03v3 ad=0 pd=0 as=0 ps=0 w=1.56u l=0.28u
X1541 VREFN A44_DCTRL_STRIP_W_R2_0/CTRL_OUT[4] A44_CDAC_CAP_BANK_ASSEMBLY_R8_M6_0/A44_CAP_CORE128_M6_R1_0/CAP_BOTTOM_030 GND nfet_03v3 ad=0 pd=0 as=0 ps=0 w=1.56u l=0.28u
X1542 VREFN A44_DCTRL_STRIP_W_R2_0/CTRL_OUT[4] A44_CDAC_CAP_BANK_ASSEMBLY_R8_M6_0/A44_CAP_CORE128_M6_R1_0/CAP_BOTTOM_030 GND nfet_03v3 ad=0 pd=0 as=0 ps=0 w=1.56u l=0.28u
X1543 VREFN A44_DCTRL_STRIP_W_R2_0/CTRL_OUT[4] A44_CDAC_CAP_BANK_ASSEMBLY_R8_M6_0/A44_CAP_CORE128_M6_R1_0/CAP_BOTTOM_030 GND nfet_03v3 ad=0 pd=0 as=0 ps=0 w=1.56u l=0.28u
X1544 VREFN A44_DCTRL_STRIP_W_R2_0/CTRL_OUT[4] A44_CDAC_CAP_BANK_ASSEMBLY_R8_M6_0/A44_CAP_CORE128_M6_R1_0/CAP_BOTTOM_030 GND nfet_03v3 ad=0 pd=0 as=0 ps=0 w=1.56u l=0.28u
X1545 VREFN A44_DCTRL_STRIP_W_R2_0/CTRL_OUT[4] A44_CDAC_CAP_BANK_ASSEMBLY_R8_M6_0/A44_CAP_CORE128_M6_R1_0/CAP_BOTTOM_030 GND nfet_03v3 ad=0 pd=0 as=0 ps=0 w=1.56u l=0.28u
X1546 VREFN A44_DCTRL_STRIP_W_R2_0/CTRL_OUT[4] A44_CDAC_CAP_BANK_ASSEMBLY_R8_M6_0/A44_CAP_CORE128_M6_R1_0/CAP_BOTTOM_030 GND nfet_03v3 ad=0 pd=0 as=0 ps=0 w=1.56u l=0.28u
X1547 VREFN A44_DCTRL_STRIP_W_R2_0/CTRL_OUT[4] A44_CDAC_CAP_BANK_ASSEMBLY_R8_M6_0/A44_CAP_CORE128_M6_R1_0/CAP_BOTTOM_030 GND nfet_03v3 ad=0 pd=0 as=0 ps=0 w=1.56u l=0.28u
X1548 VREFN A44_DCTRL_STRIP_W_R2_0/CTRL_OUT[4] A44_CDAC_CAP_BANK_ASSEMBLY_R8_M6_0/A44_CAP_CORE128_M6_R1_0/CAP_BOTTOM_030 GND nfet_03v3 ad=0 pd=0 as=0 ps=0 w=1.56u l=0.28u
X1549 VREFN A44_DCTRL_STRIP_W_R2_0/CTRL_OUT[4] A44_CDAC_CAP_BANK_ASSEMBLY_R8_M6_0/A44_CAP_CORE128_M6_R1_0/CAP_BOTTOM_030 GND nfet_03v3 ad=0 pd=0 as=0 ps=0 w=1.56u l=0.28u
X1550 VREFP A44_DCTRL_STRIP_W_R2_0/CTRL_OUT[6] A44_CDAC_CAP_BANK_ASSEMBLY_R8_M6_0/A44_CAP_CORE128_M6_R1_0/CAP_BOTTOM_028 VDD pfet_03v3 ad=0 pd=0 as=16.6842p ps=77.76u w=1.56u l=0.28u
X1551 VREFP A44_DCTRL_STRIP_W_R2_0/CTRL_OUT[6] A44_CDAC_CAP_BANK_ASSEMBLY_R8_M6_0/A44_CAP_CORE128_M6_R1_0/CAP_BOTTOM_028 VDD pfet_03v3 ad=0 pd=0 as=0 ps=0 w=1.56u l=0.28u
X1552 VREFP A44_DCTRL_STRIP_W_R2_0/CTRL_OUT[6] A44_CDAC_CAP_BANK_ASSEMBLY_R8_M6_0/A44_CAP_CORE128_M6_R1_0/CAP_BOTTOM_028 VDD pfet_03v3 ad=0 pd=0 as=0 ps=0 w=1.56u l=0.28u
X1553 VREFP A44_DCTRL_STRIP_W_R2_0/CTRL_OUT[6] A44_CDAC_CAP_BANK_ASSEMBLY_R8_M6_0/A44_CAP_CORE128_M6_R1_0/CAP_BOTTOM_028 VDD pfet_03v3 ad=0 pd=0 as=0 ps=0 w=1.56u l=0.28u
X1554 VREFP A44_DCTRL_STRIP_W_R2_0/CTRL_OUT[6] A44_CDAC_CAP_BANK_ASSEMBLY_R8_M6_0/A44_CAP_CORE128_M6_R1_0/CAP_BOTTOM_028 VDD pfet_03v3 ad=0 pd=0 as=0 ps=0 w=1.56u l=0.28u
X1555 VREFP A44_DCTRL_STRIP_W_R2_0/CTRL_OUT[6] A44_CDAC_CAP_BANK_ASSEMBLY_R8_M6_0/A44_CAP_CORE128_M6_R1_0/CAP_BOTTOM_028 VDD pfet_03v3 ad=0 pd=0 as=0 ps=0 w=1.56u l=0.28u
X1556 VREFP A44_DCTRL_STRIP_W_R2_0/CTRL_OUT[6] A44_CDAC_CAP_BANK_ASSEMBLY_R8_M6_0/A44_CAP_CORE128_M6_R1_0/CAP_BOTTOM_028 VDD pfet_03v3 ad=0 pd=0 as=0 ps=0 w=1.56u l=0.28u
X1557 VREFP A44_DCTRL_STRIP_W_R2_0/CTRL_OUT[6] A44_CDAC_CAP_BANK_ASSEMBLY_R8_M6_0/A44_CAP_CORE128_M6_R1_0/CAP_BOTTOM_028 VDD pfet_03v3 ad=0 pd=0 as=0 ps=0 w=1.56u l=0.28u
X1558 VREFP A44_DCTRL_STRIP_W_R2_0/CTRL_OUT[6] A44_CDAC_CAP_BANK_ASSEMBLY_R8_M6_0/A44_CAP_CORE128_M6_R1_0/CAP_BOTTOM_028 VDD pfet_03v3 ad=0 pd=0 as=0 ps=0 w=1.56u l=0.28u
X1559 VREFP A44_DCTRL_STRIP_W_R2_0/CTRL_OUT[6] A44_CDAC_CAP_BANK_ASSEMBLY_R8_M6_0/A44_CAP_CORE128_M6_R1_0/CAP_BOTTOM_028 VDD pfet_03v3 ad=0 pd=0 as=0 ps=0 w=1.56u l=0.28u
X1560 VREFP A44_DCTRL_STRIP_W_R2_0/CTRL_OUT[6] A44_CDAC_CAP_BANK_ASSEMBLY_R8_M6_0/A44_CAP_CORE128_M6_R1_0/CAP_BOTTOM_028 VDD pfet_03v3 ad=0 pd=0 as=0 ps=0 w=1.56u l=0.28u
X1561 VREFP A44_DCTRL_STRIP_W_R2_0/CTRL_OUT[6] A44_CDAC_CAP_BANK_ASSEMBLY_R8_M6_0/A44_CAP_CORE128_M6_R1_0/CAP_BOTTOM_028 VDD pfet_03v3 ad=0 pd=0 as=0 ps=0 w=1.56u l=0.28u
X1562 VREFP A44_DCTRL_STRIP_W_R2_0/CTRL_OUT[6] A44_CDAC_CAP_BANK_ASSEMBLY_R8_M6_0/A44_CAP_CORE128_M6_R1_0/CAP_BOTTOM_028 VDD pfet_03v3 ad=0 pd=0 as=0 ps=0 w=1.56u l=0.28u
X1563 VREFP A44_DCTRL_STRIP_W_R2_0/CTRL_OUT[6] A44_CDAC_CAP_BANK_ASSEMBLY_R8_M6_0/A44_CAP_CORE128_M6_R1_0/CAP_BOTTOM_028 VDD pfet_03v3 ad=0 pd=0 as=0 ps=0 w=1.56u l=0.28u
X1564 VREFP A44_DCTRL_STRIP_W_R2_0/CTRL_OUT[6] A44_CDAC_CAP_BANK_ASSEMBLY_R8_M6_0/A44_CAP_CORE128_M6_R1_0/CAP_BOTTOM_028 VDD pfet_03v3 ad=0 pd=0 as=0 ps=0 w=1.56u l=0.28u
X1565 VREFP A44_DCTRL_STRIP_W_R2_0/CTRL_OUT[6] A44_CDAC_CAP_BANK_ASSEMBLY_R8_M6_0/A44_CAP_CORE128_M6_R1_0/CAP_BOTTOM_028 VDD pfet_03v3 ad=0 pd=0 as=0 ps=0 w=1.56u l=0.28u
X1566 VREFP A44_DCTRL_STRIP_W_R2_0/CTRL_OUT[6] A44_CDAC_CAP_BANK_ASSEMBLY_R8_M6_0/A44_CAP_CORE128_M6_R1_0/CAP_BOTTOM_028 VDD pfet_03v3 ad=0 pd=0 as=0 ps=0 w=1.56u l=0.28u
X1567 VREFP A44_DCTRL_STRIP_W_R2_0/CTRL_OUT[6] A44_CDAC_CAP_BANK_ASSEMBLY_R8_M6_0/A44_CAP_CORE128_M6_R1_0/CAP_BOTTOM_028 VDD pfet_03v3 ad=0 pd=0 as=0 ps=0 w=1.56u l=0.28u
X1568 VREFN A44_DCTRL_STRIP_W_R2_0/CTRL_OUT[6] A44_CDAC_CAP_BANK_ASSEMBLY_R8_M6_0/A44_CAP_CORE128_M6_R1_0/CAP_BOTTOM_028 GND nfet_03v3 ad=0 pd=0 as=16.6842p ps=77.76u w=1.56u l=0.28u
X1569 VREFN A44_DCTRL_STRIP_W_R2_0/CTRL_OUT[6] A44_CDAC_CAP_BANK_ASSEMBLY_R8_M6_0/A44_CAP_CORE128_M6_R1_0/CAP_BOTTOM_028 GND nfet_03v3 ad=0 pd=0 as=0 ps=0 w=1.56u l=0.28u
X1570 VREFN A44_DCTRL_STRIP_W_R2_0/CTRL_OUT[6] A44_CDAC_CAP_BANK_ASSEMBLY_R8_M6_0/A44_CAP_CORE128_M6_R1_0/CAP_BOTTOM_028 GND nfet_03v3 ad=0 pd=0 as=0 ps=0 w=1.56u l=0.28u
X1571 VREFN A44_DCTRL_STRIP_W_R2_0/CTRL_OUT[6] A44_CDAC_CAP_BANK_ASSEMBLY_R8_M6_0/A44_CAP_CORE128_M6_R1_0/CAP_BOTTOM_028 GND nfet_03v3 ad=0 pd=0 as=0 ps=0 w=1.56u l=0.28u
X1572 VREFN A44_DCTRL_STRIP_W_R2_0/CTRL_OUT[6] A44_CDAC_CAP_BANK_ASSEMBLY_R8_M6_0/A44_CAP_CORE128_M6_R1_0/CAP_BOTTOM_028 GND nfet_03v3 ad=0 pd=0 as=0 ps=0 w=1.56u l=0.28u
X1573 VREFN A44_DCTRL_STRIP_W_R2_0/CTRL_OUT[6] A44_CDAC_CAP_BANK_ASSEMBLY_R8_M6_0/A44_CAP_CORE128_M6_R1_0/CAP_BOTTOM_028 GND nfet_03v3 ad=0 pd=0 as=0 ps=0 w=1.56u l=0.28u
X1574 VREFN A44_DCTRL_STRIP_W_R2_0/CTRL_OUT[6] A44_CDAC_CAP_BANK_ASSEMBLY_R8_M6_0/A44_CAP_CORE128_M6_R1_0/CAP_BOTTOM_028 GND nfet_03v3 ad=0 pd=0 as=0 ps=0 w=1.56u l=0.28u
X1575 VREFN A44_DCTRL_STRIP_W_R2_0/CTRL_OUT[6] A44_CDAC_CAP_BANK_ASSEMBLY_R8_M6_0/A44_CAP_CORE128_M6_R1_0/CAP_BOTTOM_028 GND nfet_03v3 ad=0 pd=0 as=0 ps=0 w=1.56u l=0.28u
X1576 VREFN A44_DCTRL_STRIP_W_R2_0/CTRL_OUT[6] A44_CDAC_CAP_BANK_ASSEMBLY_R8_M6_0/A44_CAP_CORE128_M6_R1_0/CAP_BOTTOM_028 GND nfet_03v3 ad=0 pd=0 as=0 ps=0 w=1.56u l=0.28u
X1577 VREFN A44_DCTRL_STRIP_W_R2_0/CTRL_OUT[6] A44_CDAC_CAP_BANK_ASSEMBLY_R8_M6_0/A44_CAP_CORE128_M6_R1_0/CAP_BOTTOM_028 GND nfet_03v3 ad=0 pd=0 as=0 ps=0 w=1.56u l=0.28u
X1578 VREFN A44_DCTRL_STRIP_W_R2_0/CTRL_OUT[6] A44_CDAC_CAP_BANK_ASSEMBLY_R8_M6_0/A44_CAP_CORE128_M6_R1_0/CAP_BOTTOM_028 GND nfet_03v3 ad=0 pd=0 as=0 ps=0 w=1.56u l=0.28u
X1579 VREFN A44_DCTRL_STRIP_W_R2_0/CTRL_OUT[6] A44_CDAC_CAP_BANK_ASSEMBLY_R8_M6_0/A44_CAP_CORE128_M6_R1_0/CAP_BOTTOM_028 GND nfet_03v3 ad=0 pd=0 as=0 ps=0 w=1.56u l=0.28u
X1580 VREFN A44_DCTRL_STRIP_W_R2_0/CTRL_OUT[6] A44_CDAC_CAP_BANK_ASSEMBLY_R8_M6_0/A44_CAP_CORE128_M6_R1_0/CAP_BOTTOM_028 GND nfet_03v3 ad=0 pd=0 as=0 ps=0 w=1.56u l=0.28u
X1581 VREFN A44_DCTRL_STRIP_W_R2_0/CTRL_OUT[6] A44_CDAC_CAP_BANK_ASSEMBLY_R8_M6_0/A44_CAP_CORE128_M6_R1_0/CAP_BOTTOM_028 GND nfet_03v3 ad=0 pd=0 as=0 ps=0 w=1.56u l=0.28u
X1582 VREFN A44_DCTRL_STRIP_W_R2_0/CTRL_OUT[6] A44_CDAC_CAP_BANK_ASSEMBLY_R8_M6_0/A44_CAP_CORE128_M6_R1_0/CAP_BOTTOM_028 GND nfet_03v3 ad=0 pd=0 as=0 ps=0 w=1.56u l=0.28u
X1583 VREFN A44_DCTRL_STRIP_W_R2_0/CTRL_OUT[6] A44_CDAC_CAP_BANK_ASSEMBLY_R8_M6_0/A44_CAP_CORE128_M6_R1_0/CAP_BOTTOM_028 GND nfet_03v3 ad=0 pd=0 as=0 ps=0 w=1.56u l=0.28u
X1584 VREFN A44_DCTRL_STRIP_W_R2_0/CTRL_OUT[6] A44_CDAC_CAP_BANK_ASSEMBLY_R8_M6_0/A44_CAP_CORE128_M6_R1_0/CAP_BOTTOM_028 GND nfet_03v3 ad=0 pd=0 as=0 ps=0 w=1.56u l=0.28u
X1585 VREFN A44_DCTRL_STRIP_W_R2_0/CTRL_OUT[6] A44_CDAC_CAP_BANK_ASSEMBLY_R8_M6_0/A44_CAP_CORE128_M6_R1_0/CAP_BOTTOM_028 GND nfet_03v3 ad=0 pd=0 as=0 ps=0 w=1.56u l=0.28u
X1586 VREFP A44_DCTRL_STRIP_W_R2_0/CTRL_OUT[6] A44_CDAC_CAP_BANK_ASSEMBLY_R8_M6_0/A44_CAP_CORE128_M6_R1_0/CAP_BOTTOM_057 VDD pfet_03v3 ad=0 pd=0 as=16.6842p ps=77.76u w=1.56u l=0.28u
X1587 VREFP A44_DCTRL_STRIP_W_R2_0/CTRL_OUT[6] A44_CDAC_CAP_BANK_ASSEMBLY_R8_M6_0/A44_CAP_CORE128_M6_R1_0/CAP_BOTTOM_057 VDD pfet_03v3 ad=0 pd=0 as=0 ps=0 w=1.56u l=0.28u
X1588 VREFP A44_DCTRL_STRIP_W_R2_0/CTRL_OUT[6] A44_CDAC_CAP_BANK_ASSEMBLY_R8_M6_0/A44_CAP_CORE128_M6_R1_0/CAP_BOTTOM_057 VDD pfet_03v3 ad=0 pd=0 as=0 ps=0 w=1.56u l=0.28u
X1589 VREFP A44_DCTRL_STRIP_W_R2_0/CTRL_OUT[6] A44_CDAC_CAP_BANK_ASSEMBLY_R8_M6_0/A44_CAP_CORE128_M6_R1_0/CAP_BOTTOM_057 VDD pfet_03v3 ad=0 pd=0 as=0 ps=0 w=1.56u l=0.28u
X1590 VREFP A44_DCTRL_STRIP_W_R2_0/CTRL_OUT[6] A44_CDAC_CAP_BANK_ASSEMBLY_R8_M6_0/A44_CAP_CORE128_M6_R1_0/CAP_BOTTOM_057 VDD pfet_03v3 ad=0 pd=0 as=0 ps=0 w=1.56u l=0.28u
X1591 VREFP A44_DCTRL_STRIP_W_R2_0/CTRL_OUT[6] A44_CDAC_CAP_BANK_ASSEMBLY_R8_M6_0/A44_CAP_CORE128_M6_R1_0/CAP_BOTTOM_057 VDD pfet_03v3 ad=0 pd=0 as=0 ps=0 w=1.56u l=0.28u
X1592 VREFP A44_DCTRL_STRIP_W_R2_0/CTRL_OUT[6] A44_CDAC_CAP_BANK_ASSEMBLY_R8_M6_0/A44_CAP_CORE128_M6_R1_0/CAP_BOTTOM_057 VDD pfet_03v3 ad=0 pd=0 as=0 ps=0 w=1.56u l=0.28u
X1593 VREFP A44_DCTRL_STRIP_W_R2_0/CTRL_OUT[6] A44_CDAC_CAP_BANK_ASSEMBLY_R8_M6_0/A44_CAP_CORE128_M6_R1_0/CAP_BOTTOM_057 VDD pfet_03v3 ad=0 pd=0 as=0 ps=0 w=1.56u l=0.28u
X1594 VREFP A44_DCTRL_STRIP_W_R2_0/CTRL_OUT[6] A44_CDAC_CAP_BANK_ASSEMBLY_R8_M6_0/A44_CAP_CORE128_M6_R1_0/CAP_BOTTOM_057 VDD pfet_03v3 ad=0 pd=0 as=0 ps=0 w=1.56u l=0.28u
X1595 VREFP A44_DCTRL_STRIP_W_R2_0/CTRL_OUT[6] A44_CDAC_CAP_BANK_ASSEMBLY_R8_M6_0/A44_CAP_CORE128_M6_R1_0/CAP_BOTTOM_057 VDD pfet_03v3 ad=0 pd=0 as=0 ps=0 w=1.56u l=0.28u
X1596 VREFP A44_DCTRL_STRIP_W_R2_0/CTRL_OUT[6] A44_CDAC_CAP_BANK_ASSEMBLY_R8_M6_0/A44_CAP_CORE128_M6_R1_0/CAP_BOTTOM_057 VDD pfet_03v3 ad=0 pd=0 as=0 ps=0 w=1.56u l=0.28u
X1597 VREFP A44_DCTRL_STRIP_W_R2_0/CTRL_OUT[6] A44_CDAC_CAP_BANK_ASSEMBLY_R8_M6_0/A44_CAP_CORE128_M6_R1_0/CAP_BOTTOM_057 VDD pfet_03v3 ad=0 pd=0 as=0 ps=0 w=1.56u l=0.28u
X1598 VREFP A44_DCTRL_STRIP_W_R2_0/CTRL_OUT[6] A44_CDAC_CAP_BANK_ASSEMBLY_R8_M6_0/A44_CAP_CORE128_M6_R1_0/CAP_BOTTOM_057 VDD pfet_03v3 ad=0 pd=0 as=0 ps=0 w=1.56u l=0.28u
X1599 VREFP A44_DCTRL_STRIP_W_R2_0/CTRL_OUT[6] A44_CDAC_CAP_BANK_ASSEMBLY_R8_M6_0/A44_CAP_CORE128_M6_R1_0/CAP_BOTTOM_057 VDD pfet_03v3 ad=0 pd=0 as=0 ps=0 w=1.56u l=0.28u
X1600 VREFP A44_DCTRL_STRIP_W_R2_0/CTRL_OUT[6] A44_CDAC_CAP_BANK_ASSEMBLY_R8_M6_0/A44_CAP_CORE128_M6_R1_0/CAP_BOTTOM_057 VDD pfet_03v3 ad=0 pd=0 as=0 ps=0 w=1.56u l=0.28u
X1601 VREFP A44_DCTRL_STRIP_W_R2_0/CTRL_OUT[6] A44_CDAC_CAP_BANK_ASSEMBLY_R8_M6_0/A44_CAP_CORE128_M6_R1_0/CAP_BOTTOM_057 VDD pfet_03v3 ad=0 pd=0 as=0 ps=0 w=1.56u l=0.28u
X1602 VREFP A44_DCTRL_STRIP_W_R2_0/CTRL_OUT[6] A44_CDAC_CAP_BANK_ASSEMBLY_R8_M6_0/A44_CAP_CORE128_M6_R1_0/CAP_BOTTOM_057 VDD pfet_03v3 ad=0 pd=0 as=0 ps=0 w=1.56u l=0.28u
X1603 VREFP A44_DCTRL_STRIP_W_R2_0/CTRL_OUT[6] A44_CDAC_CAP_BANK_ASSEMBLY_R8_M6_0/A44_CAP_CORE128_M6_R1_0/CAP_BOTTOM_057 VDD pfet_03v3 ad=0 pd=0 as=0 ps=0 w=1.56u l=0.28u
X1604 VREFN A44_DCTRL_STRIP_W_R2_0/CTRL_OUT[6] A44_CDAC_CAP_BANK_ASSEMBLY_R8_M6_0/A44_CAP_CORE128_M6_R1_0/CAP_BOTTOM_057 GND nfet_03v3 ad=0 pd=0 as=16.6842p ps=77.76u w=1.56u l=0.28u
X1605 VREFN A44_DCTRL_STRIP_W_R2_0/CTRL_OUT[6] A44_CDAC_CAP_BANK_ASSEMBLY_R8_M6_0/A44_CAP_CORE128_M6_R1_0/CAP_BOTTOM_057 GND nfet_03v3 ad=0 pd=0 as=0 ps=0 w=1.56u l=0.28u
X1606 VREFN A44_DCTRL_STRIP_W_R2_0/CTRL_OUT[6] A44_CDAC_CAP_BANK_ASSEMBLY_R8_M6_0/A44_CAP_CORE128_M6_R1_0/CAP_BOTTOM_057 GND nfet_03v3 ad=0 pd=0 as=0 ps=0 w=1.56u l=0.28u
X1607 VREFN A44_DCTRL_STRIP_W_R2_0/CTRL_OUT[6] A44_CDAC_CAP_BANK_ASSEMBLY_R8_M6_0/A44_CAP_CORE128_M6_R1_0/CAP_BOTTOM_057 GND nfet_03v3 ad=0 pd=0 as=0 ps=0 w=1.56u l=0.28u
X1608 VREFN A44_DCTRL_STRIP_W_R2_0/CTRL_OUT[6] A44_CDAC_CAP_BANK_ASSEMBLY_R8_M6_0/A44_CAP_CORE128_M6_R1_0/CAP_BOTTOM_057 GND nfet_03v3 ad=0 pd=0 as=0 ps=0 w=1.56u l=0.28u
X1609 VREFN A44_DCTRL_STRIP_W_R2_0/CTRL_OUT[6] A44_CDAC_CAP_BANK_ASSEMBLY_R8_M6_0/A44_CAP_CORE128_M6_R1_0/CAP_BOTTOM_057 GND nfet_03v3 ad=0 pd=0 as=0 ps=0 w=1.56u l=0.28u
X1610 VREFN A44_DCTRL_STRIP_W_R2_0/CTRL_OUT[6] A44_CDAC_CAP_BANK_ASSEMBLY_R8_M6_0/A44_CAP_CORE128_M6_R1_0/CAP_BOTTOM_057 GND nfet_03v3 ad=0 pd=0 as=0 ps=0 w=1.56u l=0.28u
X1611 VREFN A44_DCTRL_STRIP_W_R2_0/CTRL_OUT[6] A44_CDAC_CAP_BANK_ASSEMBLY_R8_M6_0/A44_CAP_CORE128_M6_R1_0/CAP_BOTTOM_057 GND nfet_03v3 ad=0 pd=0 as=0 ps=0 w=1.56u l=0.28u
X1612 VREFN A44_DCTRL_STRIP_W_R2_0/CTRL_OUT[6] A44_CDAC_CAP_BANK_ASSEMBLY_R8_M6_0/A44_CAP_CORE128_M6_R1_0/CAP_BOTTOM_057 GND nfet_03v3 ad=0 pd=0 as=0 ps=0 w=1.56u l=0.28u
X1613 VREFN A44_DCTRL_STRIP_W_R2_0/CTRL_OUT[6] A44_CDAC_CAP_BANK_ASSEMBLY_R8_M6_0/A44_CAP_CORE128_M6_R1_0/CAP_BOTTOM_057 GND nfet_03v3 ad=0 pd=0 as=0 ps=0 w=1.56u l=0.28u
X1614 VREFN A44_DCTRL_STRIP_W_R2_0/CTRL_OUT[6] A44_CDAC_CAP_BANK_ASSEMBLY_R8_M6_0/A44_CAP_CORE128_M6_R1_0/CAP_BOTTOM_057 GND nfet_03v3 ad=0 pd=0 as=0 ps=0 w=1.56u l=0.28u
X1615 VREFN A44_DCTRL_STRIP_W_R2_0/CTRL_OUT[6] A44_CDAC_CAP_BANK_ASSEMBLY_R8_M6_0/A44_CAP_CORE128_M6_R1_0/CAP_BOTTOM_057 GND nfet_03v3 ad=0 pd=0 as=0 ps=0 w=1.56u l=0.28u
X1616 VREFN A44_DCTRL_STRIP_W_R2_0/CTRL_OUT[6] A44_CDAC_CAP_BANK_ASSEMBLY_R8_M6_0/A44_CAP_CORE128_M6_R1_0/CAP_BOTTOM_057 GND nfet_03v3 ad=0 pd=0 as=0 ps=0 w=1.56u l=0.28u
X1617 VREFN A44_DCTRL_STRIP_W_R2_0/CTRL_OUT[6] A44_CDAC_CAP_BANK_ASSEMBLY_R8_M6_0/A44_CAP_CORE128_M6_R1_0/CAP_BOTTOM_057 GND nfet_03v3 ad=0 pd=0 as=0 ps=0 w=1.56u l=0.28u
X1618 VREFN A44_DCTRL_STRIP_W_R2_0/CTRL_OUT[6] A44_CDAC_CAP_BANK_ASSEMBLY_R8_M6_0/A44_CAP_CORE128_M6_R1_0/CAP_BOTTOM_057 GND nfet_03v3 ad=0 pd=0 as=0 ps=0 w=1.56u l=0.28u
X1619 VREFN A44_DCTRL_STRIP_W_R2_0/CTRL_OUT[6] A44_CDAC_CAP_BANK_ASSEMBLY_R8_M6_0/A44_CAP_CORE128_M6_R1_0/CAP_BOTTOM_057 GND nfet_03v3 ad=0 pd=0 as=0 ps=0 w=1.56u l=0.28u
X1620 VREFN A44_DCTRL_STRIP_W_R2_0/CTRL_OUT[6] A44_CDAC_CAP_BANK_ASSEMBLY_R8_M6_0/A44_CAP_CORE128_M6_R1_0/CAP_BOTTOM_057 GND nfet_03v3 ad=0 pd=0 as=0 ps=0 w=1.56u l=0.28u
X1621 VREFN A44_DCTRL_STRIP_W_R2_0/CTRL_OUT[6] A44_CDAC_CAP_BANK_ASSEMBLY_R8_M6_0/A44_CAP_CORE128_M6_R1_0/CAP_BOTTOM_057 GND nfet_03v3 ad=0 pd=0 as=0 ps=0 w=1.56u l=0.28u
X1622 VREFP A44_DCTRL_STRIP_W_R2_0/CTRL_OUT[7] A44_CDAC_CAP_BANK_ASSEMBLY_R8_M6_0/A44_CAP_CORE128_M6_R1_0/CAP_BOTTOM_054 VDD pfet_03v3 ad=0 pd=0 as=16.6842p ps=77.76u w=1.56u l=0.28u
X1623 VREFP A44_DCTRL_STRIP_W_R2_0/CTRL_OUT[7] A44_CDAC_CAP_BANK_ASSEMBLY_R8_M6_0/A44_CAP_CORE128_M6_R1_0/CAP_BOTTOM_054 VDD pfet_03v3 ad=0 pd=0 as=0 ps=0 w=1.56u l=0.28u
X1624 VREFP A44_DCTRL_STRIP_W_R2_0/CTRL_OUT[7] A44_CDAC_CAP_BANK_ASSEMBLY_R8_M6_0/A44_CAP_CORE128_M6_R1_0/CAP_BOTTOM_054 VDD pfet_03v3 ad=0 pd=0 as=0 ps=0 w=1.56u l=0.28u
X1625 VREFP A44_DCTRL_STRIP_W_R2_0/CTRL_OUT[7] A44_CDAC_CAP_BANK_ASSEMBLY_R8_M6_0/A44_CAP_CORE128_M6_R1_0/CAP_BOTTOM_054 VDD pfet_03v3 ad=0 pd=0 as=0 ps=0 w=1.56u l=0.28u
X1626 VREFP A44_DCTRL_STRIP_W_R2_0/CTRL_OUT[7] A44_CDAC_CAP_BANK_ASSEMBLY_R8_M6_0/A44_CAP_CORE128_M6_R1_0/CAP_BOTTOM_054 VDD pfet_03v3 ad=0 pd=0 as=0 ps=0 w=1.56u l=0.28u
X1627 VREFP A44_DCTRL_STRIP_W_R2_0/CTRL_OUT[7] A44_CDAC_CAP_BANK_ASSEMBLY_R8_M6_0/A44_CAP_CORE128_M6_R1_0/CAP_BOTTOM_054 VDD pfet_03v3 ad=0 pd=0 as=0 ps=0 w=1.56u l=0.28u
X1628 VREFP A44_DCTRL_STRIP_W_R2_0/CTRL_OUT[7] A44_CDAC_CAP_BANK_ASSEMBLY_R8_M6_0/A44_CAP_CORE128_M6_R1_0/CAP_BOTTOM_054 VDD pfet_03v3 ad=0 pd=0 as=0 ps=0 w=1.56u l=0.28u
X1629 VREFP A44_DCTRL_STRIP_W_R2_0/CTRL_OUT[7] A44_CDAC_CAP_BANK_ASSEMBLY_R8_M6_0/A44_CAP_CORE128_M6_R1_0/CAP_BOTTOM_054 VDD pfet_03v3 ad=0 pd=0 as=0 ps=0 w=1.56u l=0.28u
X1630 VREFP A44_DCTRL_STRIP_W_R2_0/CTRL_OUT[7] A44_CDAC_CAP_BANK_ASSEMBLY_R8_M6_0/A44_CAP_CORE128_M6_R1_0/CAP_BOTTOM_054 VDD pfet_03v3 ad=0 pd=0 as=0 ps=0 w=1.56u l=0.28u
X1631 VREFP A44_DCTRL_STRIP_W_R2_0/CTRL_OUT[7] A44_CDAC_CAP_BANK_ASSEMBLY_R8_M6_0/A44_CAP_CORE128_M6_R1_0/CAP_BOTTOM_054 VDD pfet_03v3 ad=0 pd=0 as=0 ps=0 w=1.56u l=0.28u
X1632 VREFP A44_DCTRL_STRIP_W_R2_0/CTRL_OUT[7] A44_CDAC_CAP_BANK_ASSEMBLY_R8_M6_0/A44_CAP_CORE128_M6_R1_0/CAP_BOTTOM_054 VDD pfet_03v3 ad=0 pd=0 as=0 ps=0 w=1.56u l=0.28u
X1633 VREFP A44_DCTRL_STRIP_W_R2_0/CTRL_OUT[7] A44_CDAC_CAP_BANK_ASSEMBLY_R8_M6_0/A44_CAP_CORE128_M6_R1_0/CAP_BOTTOM_054 VDD pfet_03v3 ad=0 pd=0 as=0 ps=0 w=1.56u l=0.28u
X1634 VREFP A44_DCTRL_STRIP_W_R2_0/CTRL_OUT[7] A44_CDAC_CAP_BANK_ASSEMBLY_R8_M6_0/A44_CAP_CORE128_M6_R1_0/CAP_BOTTOM_054 VDD pfet_03v3 ad=0 pd=0 as=0 ps=0 w=1.56u l=0.28u
X1635 VREFP A44_DCTRL_STRIP_W_R2_0/CTRL_OUT[7] A44_CDAC_CAP_BANK_ASSEMBLY_R8_M6_0/A44_CAP_CORE128_M6_R1_0/CAP_BOTTOM_054 VDD pfet_03v3 ad=0 pd=0 as=0 ps=0 w=1.56u l=0.28u
X1636 VREFP A44_DCTRL_STRIP_W_R2_0/CTRL_OUT[7] A44_CDAC_CAP_BANK_ASSEMBLY_R8_M6_0/A44_CAP_CORE128_M6_R1_0/CAP_BOTTOM_054 VDD pfet_03v3 ad=0 pd=0 as=0 ps=0 w=1.56u l=0.28u
X1637 VREFP A44_DCTRL_STRIP_W_R2_0/CTRL_OUT[7] A44_CDAC_CAP_BANK_ASSEMBLY_R8_M6_0/A44_CAP_CORE128_M6_R1_0/CAP_BOTTOM_054 VDD pfet_03v3 ad=0 pd=0 as=0 ps=0 w=1.56u l=0.28u
X1638 VREFP A44_DCTRL_STRIP_W_R2_0/CTRL_OUT[7] A44_CDAC_CAP_BANK_ASSEMBLY_R8_M6_0/A44_CAP_CORE128_M6_R1_0/CAP_BOTTOM_054 VDD pfet_03v3 ad=0 pd=0 as=0 ps=0 w=1.56u l=0.28u
X1639 VREFP A44_DCTRL_STRIP_W_R2_0/CTRL_OUT[7] A44_CDAC_CAP_BANK_ASSEMBLY_R8_M6_0/A44_CAP_CORE128_M6_R1_0/CAP_BOTTOM_054 VDD pfet_03v3 ad=0 pd=0 as=0 ps=0 w=1.56u l=0.28u
X1640 VREFN A44_DCTRL_STRIP_W_R2_0/CTRL_OUT[7] A44_CDAC_CAP_BANK_ASSEMBLY_R8_M6_0/A44_CAP_CORE128_M6_R1_0/CAP_BOTTOM_054 GND nfet_03v3 ad=0 pd=0 as=16.6842p ps=77.76u w=1.56u l=0.28u
X1641 VREFN A44_DCTRL_STRIP_W_R2_0/CTRL_OUT[7] A44_CDAC_CAP_BANK_ASSEMBLY_R8_M6_0/A44_CAP_CORE128_M6_R1_0/CAP_BOTTOM_054 GND nfet_03v3 ad=0 pd=0 as=0 ps=0 w=1.56u l=0.28u
X1642 VREFN A44_DCTRL_STRIP_W_R2_0/CTRL_OUT[7] A44_CDAC_CAP_BANK_ASSEMBLY_R8_M6_0/A44_CAP_CORE128_M6_R1_0/CAP_BOTTOM_054 GND nfet_03v3 ad=0 pd=0 as=0 ps=0 w=1.56u l=0.28u
X1643 VREFN A44_DCTRL_STRIP_W_R2_0/CTRL_OUT[7] A44_CDAC_CAP_BANK_ASSEMBLY_R8_M6_0/A44_CAP_CORE128_M6_R1_0/CAP_BOTTOM_054 GND nfet_03v3 ad=0 pd=0 as=0 ps=0 w=1.56u l=0.28u
X1644 VREFN A44_DCTRL_STRIP_W_R2_0/CTRL_OUT[7] A44_CDAC_CAP_BANK_ASSEMBLY_R8_M6_0/A44_CAP_CORE128_M6_R1_0/CAP_BOTTOM_054 GND nfet_03v3 ad=0 pd=0 as=0 ps=0 w=1.56u l=0.28u
X1645 VREFN A44_DCTRL_STRIP_W_R2_0/CTRL_OUT[7] A44_CDAC_CAP_BANK_ASSEMBLY_R8_M6_0/A44_CAP_CORE128_M6_R1_0/CAP_BOTTOM_054 GND nfet_03v3 ad=0 pd=0 as=0 ps=0 w=1.56u l=0.28u
X1646 VREFN A44_DCTRL_STRIP_W_R2_0/CTRL_OUT[7] A44_CDAC_CAP_BANK_ASSEMBLY_R8_M6_0/A44_CAP_CORE128_M6_R1_0/CAP_BOTTOM_054 GND nfet_03v3 ad=0 pd=0 as=0 ps=0 w=1.56u l=0.28u
X1647 VREFN A44_DCTRL_STRIP_W_R2_0/CTRL_OUT[7] A44_CDAC_CAP_BANK_ASSEMBLY_R8_M6_0/A44_CAP_CORE128_M6_R1_0/CAP_BOTTOM_054 GND nfet_03v3 ad=0 pd=0 as=0 ps=0 w=1.56u l=0.28u
X1648 VREFN A44_DCTRL_STRIP_W_R2_0/CTRL_OUT[7] A44_CDAC_CAP_BANK_ASSEMBLY_R8_M6_0/A44_CAP_CORE128_M6_R1_0/CAP_BOTTOM_054 GND nfet_03v3 ad=0 pd=0 as=0 ps=0 w=1.56u l=0.28u
X1649 VREFN A44_DCTRL_STRIP_W_R2_0/CTRL_OUT[7] A44_CDAC_CAP_BANK_ASSEMBLY_R8_M6_0/A44_CAP_CORE128_M6_R1_0/CAP_BOTTOM_054 GND nfet_03v3 ad=0 pd=0 as=0 ps=0 w=1.56u l=0.28u
X1650 VREFN A44_DCTRL_STRIP_W_R2_0/CTRL_OUT[7] A44_CDAC_CAP_BANK_ASSEMBLY_R8_M6_0/A44_CAP_CORE128_M6_R1_0/CAP_BOTTOM_054 GND nfet_03v3 ad=0 pd=0 as=0 ps=0 w=1.56u l=0.28u
X1651 VREFN A44_DCTRL_STRIP_W_R2_0/CTRL_OUT[7] A44_CDAC_CAP_BANK_ASSEMBLY_R8_M6_0/A44_CAP_CORE128_M6_R1_0/CAP_BOTTOM_054 GND nfet_03v3 ad=0 pd=0 as=0 ps=0 w=1.56u l=0.28u
X1652 VREFN A44_DCTRL_STRIP_W_R2_0/CTRL_OUT[7] A44_CDAC_CAP_BANK_ASSEMBLY_R8_M6_0/A44_CAP_CORE128_M6_R1_0/CAP_BOTTOM_054 GND nfet_03v3 ad=0 pd=0 as=0 ps=0 w=1.56u l=0.28u
X1653 VREFN A44_DCTRL_STRIP_W_R2_0/CTRL_OUT[7] A44_CDAC_CAP_BANK_ASSEMBLY_R8_M6_0/A44_CAP_CORE128_M6_R1_0/CAP_BOTTOM_054 GND nfet_03v3 ad=0 pd=0 as=0 ps=0 w=1.56u l=0.28u
X1654 VREFN A44_DCTRL_STRIP_W_R2_0/CTRL_OUT[7] A44_CDAC_CAP_BANK_ASSEMBLY_R8_M6_0/A44_CAP_CORE128_M6_R1_0/CAP_BOTTOM_054 GND nfet_03v3 ad=0 pd=0 as=0 ps=0 w=1.56u l=0.28u
X1655 VREFN A44_DCTRL_STRIP_W_R2_0/CTRL_OUT[7] A44_CDAC_CAP_BANK_ASSEMBLY_R8_M6_0/A44_CAP_CORE128_M6_R1_0/CAP_BOTTOM_054 GND nfet_03v3 ad=0 pd=0 as=0 ps=0 w=1.56u l=0.28u
X1656 VREFN A44_DCTRL_STRIP_W_R2_0/CTRL_OUT[7] A44_CDAC_CAP_BANK_ASSEMBLY_R8_M6_0/A44_CAP_CORE128_M6_R1_0/CAP_BOTTOM_054 GND nfet_03v3 ad=0 pd=0 as=0 ps=0 w=1.56u l=0.28u
X1657 VREFN A44_DCTRL_STRIP_W_R2_0/CTRL_OUT[7] A44_CDAC_CAP_BANK_ASSEMBLY_R8_M6_0/A44_CAP_CORE128_M6_R1_0/CAP_BOTTOM_054 GND nfet_03v3 ad=0 pd=0 as=0 ps=0 w=1.56u l=0.28u
X1658 VREFP A44_DCTRL_STRIP_W_R2_0/CTRL_OUT[6] A44_CDAC_CAP_BANK_ASSEMBLY_R8_M6_0/A44_CAP_CORE128_M6_R1_0/CAP_BOTTOM_020 VDD pfet_03v3 ad=0 pd=0 as=16.6842p ps=77.76u w=1.56u l=0.28u
X1659 VREFP A44_DCTRL_STRIP_W_R2_0/CTRL_OUT[6] A44_CDAC_CAP_BANK_ASSEMBLY_R8_M6_0/A44_CAP_CORE128_M6_R1_0/CAP_BOTTOM_020 VDD pfet_03v3 ad=0 pd=0 as=0 ps=0 w=1.56u l=0.28u
X1660 VREFP A44_DCTRL_STRIP_W_R2_0/CTRL_OUT[6] A44_CDAC_CAP_BANK_ASSEMBLY_R8_M6_0/A44_CAP_CORE128_M6_R1_0/CAP_BOTTOM_020 VDD pfet_03v3 ad=0 pd=0 as=0 ps=0 w=1.56u l=0.28u
X1661 VREFP A44_DCTRL_STRIP_W_R2_0/CTRL_OUT[6] A44_CDAC_CAP_BANK_ASSEMBLY_R8_M6_0/A44_CAP_CORE128_M6_R1_0/CAP_BOTTOM_020 VDD pfet_03v3 ad=0 pd=0 as=0 ps=0 w=1.56u l=0.28u
X1662 VREFP A44_DCTRL_STRIP_W_R2_0/CTRL_OUT[6] A44_CDAC_CAP_BANK_ASSEMBLY_R8_M6_0/A44_CAP_CORE128_M6_R1_0/CAP_BOTTOM_020 VDD pfet_03v3 ad=0 pd=0 as=0 ps=0 w=1.56u l=0.28u
X1663 VREFP A44_DCTRL_STRIP_W_R2_0/CTRL_OUT[6] A44_CDAC_CAP_BANK_ASSEMBLY_R8_M6_0/A44_CAP_CORE128_M6_R1_0/CAP_BOTTOM_020 VDD pfet_03v3 ad=0 pd=0 as=0 ps=0 w=1.56u l=0.28u
X1664 VREFP A44_DCTRL_STRIP_W_R2_0/CTRL_OUT[6] A44_CDAC_CAP_BANK_ASSEMBLY_R8_M6_0/A44_CAP_CORE128_M6_R1_0/CAP_BOTTOM_020 VDD pfet_03v3 ad=0 pd=0 as=0 ps=0 w=1.56u l=0.28u
X1665 VREFP A44_DCTRL_STRIP_W_R2_0/CTRL_OUT[6] A44_CDAC_CAP_BANK_ASSEMBLY_R8_M6_0/A44_CAP_CORE128_M6_R1_0/CAP_BOTTOM_020 VDD pfet_03v3 ad=0 pd=0 as=0 ps=0 w=1.56u l=0.28u
X1666 VREFP A44_DCTRL_STRIP_W_R2_0/CTRL_OUT[6] A44_CDAC_CAP_BANK_ASSEMBLY_R8_M6_0/A44_CAP_CORE128_M6_R1_0/CAP_BOTTOM_020 VDD pfet_03v3 ad=0 pd=0 as=0 ps=0 w=1.56u l=0.28u
X1667 VREFP A44_DCTRL_STRIP_W_R2_0/CTRL_OUT[6] A44_CDAC_CAP_BANK_ASSEMBLY_R8_M6_0/A44_CAP_CORE128_M6_R1_0/CAP_BOTTOM_020 VDD pfet_03v3 ad=0 pd=0 as=0 ps=0 w=1.56u l=0.28u
X1668 VREFP A44_DCTRL_STRIP_W_R2_0/CTRL_OUT[6] A44_CDAC_CAP_BANK_ASSEMBLY_R8_M6_0/A44_CAP_CORE128_M6_R1_0/CAP_BOTTOM_020 VDD pfet_03v3 ad=0 pd=0 as=0 ps=0 w=1.56u l=0.28u
X1669 VREFP A44_DCTRL_STRIP_W_R2_0/CTRL_OUT[6] A44_CDAC_CAP_BANK_ASSEMBLY_R8_M6_0/A44_CAP_CORE128_M6_R1_0/CAP_BOTTOM_020 VDD pfet_03v3 ad=0 pd=0 as=0 ps=0 w=1.56u l=0.28u
X1670 VREFP A44_DCTRL_STRIP_W_R2_0/CTRL_OUT[6] A44_CDAC_CAP_BANK_ASSEMBLY_R8_M6_0/A44_CAP_CORE128_M6_R1_0/CAP_BOTTOM_020 VDD pfet_03v3 ad=0 pd=0 as=0 ps=0 w=1.56u l=0.28u
X1671 VREFP A44_DCTRL_STRIP_W_R2_0/CTRL_OUT[6] A44_CDAC_CAP_BANK_ASSEMBLY_R8_M6_0/A44_CAP_CORE128_M6_R1_0/CAP_BOTTOM_020 VDD pfet_03v3 ad=0 pd=0 as=0 ps=0 w=1.56u l=0.28u
X1672 VREFP A44_DCTRL_STRIP_W_R2_0/CTRL_OUT[6] A44_CDAC_CAP_BANK_ASSEMBLY_R8_M6_0/A44_CAP_CORE128_M6_R1_0/CAP_BOTTOM_020 VDD pfet_03v3 ad=0 pd=0 as=0 ps=0 w=1.56u l=0.28u
X1673 VREFP A44_DCTRL_STRIP_W_R2_0/CTRL_OUT[6] A44_CDAC_CAP_BANK_ASSEMBLY_R8_M6_0/A44_CAP_CORE128_M6_R1_0/CAP_BOTTOM_020 VDD pfet_03v3 ad=0 pd=0 as=0 ps=0 w=1.56u l=0.28u
X1674 VREFP A44_DCTRL_STRIP_W_R2_0/CTRL_OUT[6] A44_CDAC_CAP_BANK_ASSEMBLY_R8_M6_0/A44_CAP_CORE128_M6_R1_0/CAP_BOTTOM_020 VDD pfet_03v3 ad=0 pd=0 as=0 ps=0 w=1.56u l=0.28u
X1675 VREFP A44_DCTRL_STRIP_W_R2_0/CTRL_OUT[6] A44_CDAC_CAP_BANK_ASSEMBLY_R8_M6_0/A44_CAP_CORE128_M6_R1_0/CAP_BOTTOM_020 VDD pfet_03v3 ad=0 pd=0 as=0 ps=0 w=1.56u l=0.28u
X1676 VREFN A44_DCTRL_STRIP_W_R2_0/CTRL_OUT[6] A44_CDAC_CAP_BANK_ASSEMBLY_R8_M6_0/A44_CAP_CORE128_M6_R1_0/CAP_BOTTOM_020 GND nfet_03v3 ad=0 pd=0 as=16.6842p ps=77.76u w=1.56u l=0.28u
X1677 VREFN A44_DCTRL_STRIP_W_R2_0/CTRL_OUT[6] A44_CDAC_CAP_BANK_ASSEMBLY_R8_M6_0/A44_CAP_CORE128_M6_R1_0/CAP_BOTTOM_020 GND nfet_03v3 ad=0 pd=0 as=0 ps=0 w=1.56u l=0.28u
X1678 VREFN A44_DCTRL_STRIP_W_R2_0/CTRL_OUT[6] A44_CDAC_CAP_BANK_ASSEMBLY_R8_M6_0/A44_CAP_CORE128_M6_R1_0/CAP_BOTTOM_020 GND nfet_03v3 ad=0 pd=0 as=0 ps=0 w=1.56u l=0.28u
X1679 VREFN A44_DCTRL_STRIP_W_R2_0/CTRL_OUT[6] A44_CDAC_CAP_BANK_ASSEMBLY_R8_M6_0/A44_CAP_CORE128_M6_R1_0/CAP_BOTTOM_020 GND nfet_03v3 ad=0 pd=0 as=0 ps=0 w=1.56u l=0.28u
X1680 VREFN A44_DCTRL_STRIP_W_R2_0/CTRL_OUT[6] A44_CDAC_CAP_BANK_ASSEMBLY_R8_M6_0/A44_CAP_CORE128_M6_R1_0/CAP_BOTTOM_020 GND nfet_03v3 ad=0 pd=0 as=0 ps=0 w=1.56u l=0.28u
X1681 VREFN A44_DCTRL_STRIP_W_R2_0/CTRL_OUT[6] A44_CDAC_CAP_BANK_ASSEMBLY_R8_M6_0/A44_CAP_CORE128_M6_R1_0/CAP_BOTTOM_020 GND nfet_03v3 ad=0 pd=0 as=0 ps=0 w=1.56u l=0.28u
X1682 VREFN A44_DCTRL_STRIP_W_R2_0/CTRL_OUT[6] A44_CDAC_CAP_BANK_ASSEMBLY_R8_M6_0/A44_CAP_CORE128_M6_R1_0/CAP_BOTTOM_020 GND nfet_03v3 ad=0 pd=0 as=0 ps=0 w=1.56u l=0.28u
X1683 VREFN A44_DCTRL_STRIP_W_R2_0/CTRL_OUT[6] A44_CDAC_CAP_BANK_ASSEMBLY_R8_M6_0/A44_CAP_CORE128_M6_R1_0/CAP_BOTTOM_020 GND nfet_03v3 ad=0 pd=0 as=0 ps=0 w=1.56u l=0.28u
X1684 VREFN A44_DCTRL_STRIP_W_R2_0/CTRL_OUT[6] A44_CDAC_CAP_BANK_ASSEMBLY_R8_M6_0/A44_CAP_CORE128_M6_R1_0/CAP_BOTTOM_020 GND nfet_03v3 ad=0 pd=0 as=0 ps=0 w=1.56u l=0.28u
X1685 VREFN A44_DCTRL_STRIP_W_R2_0/CTRL_OUT[6] A44_CDAC_CAP_BANK_ASSEMBLY_R8_M6_0/A44_CAP_CORE128_M6_R1_0/CAP_BOTTOM_020 GND nfet_03v3 ad=0 pd=0 as=0 ps=0 w=1.56u l=0.28u
X1686 VREFN A44_DCTRL_STRIP_W_R2_0/CTRL_OUT[6] A44_CDAC_CAP_BANK_ASSEMBLY_R8_M6_0/A44_CAP_CORE128_M6_R1_0/CAP_BOTTOM_020 GND nfet_03v3 ad=0 pd=0 as=0 ps=0 w=1.56u l=0.28u
X1687 VREFN A44_DCTRL_STRIP_W_R2_0/CTRL_OUT[6] A44_CDAC_CAP_BANK_ASSEMBLY_R8_M6_0/A44_CAP_CORE128_M6_R1_0/CAP_BOTTOM_020 GND nfet_03v3 ad=0 pd=0 as=0 ps=0 w=1.56u l=0.28u
X1688 VREFN A44_DCTRL_STRIP_W_R2_0/CTRL_OUT[6] A44_CDAC_CAP_BANK_ASSEMBLY_R8_M6_0/A44_CAP_CORE128_M6_R1_0/CAP_BOTTOM_020 GND nfet_03v3 ad=0 pd=0 as=0 ps=0 w=1.56u l=0.28u
X1689 VREFN A44_DCTRL_STRIP_W_R2_0/CTRL_OUT[6] A44_CDAC_CAP_BANK_ASSEMBLY_R8_M6_0/A44_CAP_CORE128_M6_R1_0/CAP_BOTTOM_020 GND nfet_03v3 ad=0 pd=0 as=0 ps=0 w=1.56u l=0.28u
X1690 VREFN A44_DCTRL_STRIP_W_R2_0/CTRL_OUT[6] A44_CDAC_CAP_BANK_ASSEMBLY_R8_M6_0/A44_CAP_CORE128_M6_R1_0/CAP_BOTTOM_020 GND nfet_03v3 ad=0 pd=0 as=0 ps=0 w=1.56u l=0.28u
X1691 VREFN A44_DCTRL_STRIP_W_R2_0/CTRL_OUT[6] A44_CDAC_CAP_BANK_ASSEMBLY_R8_M6_0/A44_CAP_CORE128_M6_R1_0/CAP_BOTTOM_020 GND nfet_03v3 ad=0 pd=0 as=0 ps=0 w=1.56u l=0.28u
X1692 VREFN A44_DCTRL_STRIP_W_R2_0/CTRL_OUT[6] A44_CDAC_CAP_BANK_ASSEMBLY_R8_M6_0/A44_CAP_CORE128_M6_R1_0/CAP_BOTTOM_020 GND nfet_03v3 ad=0 pd=0 as=0 ps=0 w=1.56u l=0.28u
X1693 VREFN A44_DCTRL_STRIP_W_R2_0/CTRL_OUT[6] A44_CDAC_CAP_BANK_ASSEMBLY_R8_M6_0/A44_CAP_CORE128_M6_R1_0/CAP_BOTTOM_020 GND nfet_03v3 ad=0 pd=0 as=0 ps=0 w=1.56u l=0.28u
X1694 VREFP A44_DCTRL_STRIP_W_R2_0/CTRL_OUT[7] A44_CDAC_CAP_BANK_ASSEMBLY_R8_M6_0/A44_CAP_CORE128_M6_R1_0/CAP_BOTTOM_017 VDD pfet_03v3 ad=0 pd=0 as=16.6842p ps=77.76u w=1.56u l=0.28u
X1695 VREFP A44_DCTRL_STRIP_W_R2_0/CTRL_OUT[7] A44_CDAC_CAP_BANK_ASSEMBLY_R8_M6_0/A44_CAP_CORE128_M6_R1_0/CAP_BOTTOM_017 VDD pfet_03v3 ad=0 pd=0 as=0 ps=0 w=1.56u l=0.28u
X1696 VREFP A44_DCTRL_STRIP_W_R2_0/CTRL_OUT[7] A44_CDAC_CAP_BANK_ASSEMBLY_R8_M6_0/A44_CAP_CORE128_M6_R1_0/CAP_BOTTOM_017 VDD pfet_03v3 ad=0 pd=0 as=0 ps=0 w=1.56u l=0.28u
X1697 VREFP A44_DCTRL_STRIP_W_R2_0/CTRL_OUT[7] A44_CDAC_CAP_BANK_ASSEMBLY_R8_M6_0/A44_CAP_CORE128_M6_R1_0/CAP_BOTTOM_017 VDD pfet_03v3 ad=0 pd=0 as=0 ps=0 w=1.56u l=0.28u
X1698 VREFP A44_DCTRL_STRIP_W_R2_0/CTRL_OUT[7] A44_CDAC_CAP_BANK_ASSEMBLY_R8_M6_0/A44_CAP_CORE128_M6_R1_0/CAP_BOTTOM_017 VDD pfet_03v3 ad=0 pd=0 as=0 ps=0 w=1.56u l=0.28u
X1699 VREFP A44_DCTRL_STRIP_W_R2_0/CTRL_OUT[7] A44_CDAC_CAP_BANK_ASSEMBLY_R8_M6_0/A44_CAP_CORE128_M6_R1_0/CAP_BOTTOM_017 VDD pfet_03v3 ad=0 pd=0 as=0 ps=0 w=1.56u l=0.28u
X1700 VREFP A44_DCTRL_STRIP_W_R2_0/CTRL_OUT[7] A44_CDAC_CAP_BANK_ASSEMBLY_R8_M6_0/A44_CAP_CORE128_M6_R1_0/CAP_BOTTOM_017 VDD pfet_03v3 ad=0 pd=0 as=0 ps=0 w=1.56u l=0.28u
X1701 VREFP A44_DCTRL_STRIP_W_R2_0/CTRL_OUT[7] A44_CDAC_CAP_BANK_ASSEMBLY_R8_M6_0/A44_CAP_CORE128_M6_R1_0/CAP_BOTTOM_017 VDD pfet_03v3 ad=0 pd=0 as=0 ps=0 w=1.56u l=0.28u
X1702 VREFP A44_DCTRL_STRIP_W_R2_0/CTRL_OUT[7] A44_CDAC_CAP_BANK_ASSEMBLY_R8_M6_0/A44_CAP_CORE128_M6_R1_0/CAP_BOTTOM_017 VDD pfet_03v3 ad=0 pd=0 as=0 ps=0 w=1.56u l=0.28u
X1703 VREFP A44_DCTRL_STRIP_W_R2_0/CTRL_OUT[7] A44_CDAC_CAP_BANK_ASSEMBLY_R8_M6_0/A44_CAP_CORE128_M6_R1_0/CAP_BOTTOM_017 VDD pfet_03v3 ad=0 pd=0 as=0 ps=0 w=1.56u l=0.28u
X1704 VREFP A44_DCTRL_STRIP_W_R2_0/CTRL_OUT[7] A44_CDAC_CAP_BANK_ASSEMBLY_R8_M6_0/A44_CAP_CORE128_M6_R1_0/CAP_BOTTOM_017 VDD pfet_03v3 ad=0 pd=0 as=0 ps=0 w=1.56u l=0.28u
X1705 VREFP A44_DCTRL_STRIP_W_R2_0/CTRL_OUT[7] A44_CDAC_CAP_BANK_ASSEMBLY_R8_M6_0/A44_CAP_CORE128_M6_R1_0/CAP_BOTTOM_017 VDD pfet_03v3 ad=0 pd=0 as=0 ps=0 w=1.56u l=0.28u
X1706 VREFP A44_DCTRL_STRIP_W_R2_0/CTRL_OUT[7] A44_CDAC_CAP_BANK_ASSEMBLY_R8_M6_0/A44_CAP_CORE128_M6_R1_0/CAP_BOTTOM_017 VDD pfet_03v3 ad=0 pd=0 as=0 ps=0 w=1.56u l=0.28u
X1707 VREFP A44_DCTRL_STRIP_W_R2_0/CTRL_OUT[7] A44_CDAC_CAP_BANK_ASSEMBLY_R8_M6_0/A44_CAP_CORE128_M6_R1_0/CAP_BOTTOM_017 VDD pfet_03v3 ad=0 pd=0 as=0 ps=0 w=1.56u l=0.28u
X1708 VREFP A44_DCTRL_STRIP_W_R2_0/CTRL_OUT[7] A44_CDAC_CAP_BANK_ASSEMBLY_R8_M6_0/A44_CAP_CORE128_M6_R1_0/CAP_BOTTOM_017 VDD pfet_03v3 ad=0 pd=0 as=0 ps=0 w=1.56u l=0.28u
X1709 VREFP A44_DCTRL_STRIP_W_R2_0/CTRL_OUT[7] A44_CDAC_CAP_BANK_ASSEMBLY_R8_M6_0/A44_CAP_CORE128_M6_R1_0/CAP_BOTTOM_017 VDD pfet_03v3 ad=0 pd=0 as=0 ps=0 w=1.56u l=0.28u
X1710 VREFP A44_DCTRL_STRIP_W_R2_0/CTRL_OUT[7] A44_CDAC_CAP_BANK_ASSEMBLY_R8_M6_0/A44_CAP_CORE128_M6_R1_0/CAP_BOTTOM_017 VDD pfet_03v3 ad=0 pd=0 as=0 ps=0 w=1.56u l=0.28u
X1711 VREFP A44_DCTRL_STRIP_W_R2_0/CTRL_OUT[7] A44_CDAC_CAP_BANK_ASSEMBLY_R8_M6_0/A44_CAP_CORE128_M6_R1_0/CAP_BOTTOM_017 VDD pfet_03v3 ad=0 pd=0 as=0 ps=0 w=1.56u l=0.28u
X1712 VREFN A44_DCTRL_STRIP_W_R2_0/CTRL_OUT[7] A44_CDAC_CAP_BANK_ASSEMBLY_R8_M6_0/A44_CAP_CORE128_M6_R1_0/CAP_BOTTOM_017 GND nfet_03v3 ad=0 pd=0 as=16.6842p ps=77.76u w=1.56u l=0.28u
X1713 VREFN A44_DCTRL_STRIP_W_R2_0/CTRL_OUT[7] A44_CDAC_CAP_BANK_ASSEMBLY_R8_M6_0/A44_CAP_CORE128_M6_R1_0/CAP_BOTTOM_017 GND nfet_03v3 ad=0 pd=0 as=0 ps=0 w=1.56u l=0.28u
X1714 VREFN A44_DCTRL_STRIP_W_R2_0/CTRL_OUT[7] A44_CDAC_CAP_BANK_ASSEMBLY_R8_M6_0/A44_CAP_CORE128_M6_R1_0/CAP_BOTTOM_017 GND nfet_03v3 ad=0 pd=0 as=0 ps=0 w=1.56u l=0.28u
X1715 VREFN A44_DCTRL_STRIP_W_R2_0/CTRL_OUT[7] A44_CDAC_CAP_BANK_ASSEMBLY_R8_M6_0/A44_CAP_CORE128_M6_R1_0/CAP_BOTTOM_017 GND nfet_03v3 ad=0 pd=0 as=0 ps=0 w=1.56u l=0.28u
X1716 VREFN A44_DCTRL_STRIP_W_R2_0/CTRL_OUT[7] A44_CDAC_CAP_BANK_ASSEMBLY_R8_M6_0/A44_CAP_CORE128_M6_R1_0/CAP_BOTTOM_017 GND nfet_03v3 ad=0 pd=0 as=0 ps=0 w=1.56u l=0.28u
X1717 VREFN A44_DCTRL_STRIP_W_R2_0/CTRL_OUT[7] A44_CDAC_CAP_BANK_ASSEMBLY_R8_M6_0/A44_CAP_CORE128_M6_R1_0/CAP_BOTTOM_017 GND nfet_03v3 ad=0 pd=0 as=0 ps=0 w=1.56u l=0.28u
X1718 VREFN A44_DCTRL_STRIP_W_R2_0/CTRL_OUT[7] A44_CDAC_CAP_BANK_ASSEMBLY_R8_M6_0/A44_CAP_CORE128_M6_R1_0/CAP_BOTTOM_017 GND nfet_03v3 ad=0 pd=0 as=0 ps=0 w=1.56u l=0.28u
X1719 VREFN A44_DCTRL_STRIP_W_R2_0/CTRL_OUT[7] A44_CDAC_CAP_BANK_ASSEMBLY_R8_M6_0/A44_CAP_CORE128_M6_R1_0/CAP_BOTTOM_017 GND nfet_03v3 ad=0 pd=0 as=0 ps=0 w=1.56u l=0.28u
X1720 VREFN A44_DCTRL_STRIP_W_R2_0/CTRL_OUT[7] A44_CDAC_CAP_BANK_ASSEMBLY_R8_M6_0/A44_CAP_CORE128_M6_R1_0/CAP_BOTTOM_017 GND nfet_03v3 ad=0 pd=0 as=0 ps=0 w=1.56u l=0.28u
X1721 VREFN A44_DCTRL_STRIP_W_R2_0/CTRL_OUT[7] A44_CDAC_CAP_BANK_ASSEMBLY_R8_M6_0/A44_CAP_CORE128_M6_R1_0/CAP_BOTTOM_017 GND nfet_03v3 ad=0 pd=0 as=0 ps=0 w=1.56u l=0.28u
X1722 VREFN A44_DCTRL_STRIP_W_R2_0/CTRL_OUT[7] A44_CDAC_CAP_BANK_ASSEMBLY_R8_M6_0/A44_CAP_CORE128_M6_R1_0/CAP_BOTTOM_017 GND nfet_03v3 ad=0 pd=0 as=0 ps=0 w=1.56u l=0.28u
X1723 VREFN A44_DCTRL_STRIP_W_R2_0/CTRL_OUT[7] A44_CDAC_CAP_BANK_ASSEMBLY_R8_M6_0/A44_CAP_CORE128_M6_R1_0/CAP_BOTTOM_017 GND nfet_03v3 ad=0 pd=0 as=0 ps=0 w=1.56u l=0.28u
X1724 VREFN A44_DCTRL_STRIP_W_R2_0/CTRL_OUT[7] A44_CDAC_CAP_BANK_ASSEMBLY_R8_M6_0/A44_CAP_CORE128_M6_R1_0/CAP_BOTTOM_017 GND nfet_03v3 ad=0 pd=0 as=0 ps=0 w=1.56u l=0.28u
X1725 VREFN A44_DCTRL_STRIP_W_R2_0/CTRL_OUT[7] A44_CDAC_CAP_BANK_ASSEMBLY_R8_M6_0/A44_CAP_CORE128_M6_R1_0/CAP_BOTTOM_017 GND nfet_03v3 ad=0 pd=0 as=0 ps=0 w=1.56u l=0.28u
X1726 VREFN A44_DCTRL_STRIP_W_R2_0/CTRL_OUT[7] A44_CDAC_CAP_BANK_ASSEMBLY_R8_M6_0/A44_CAP_CORE128_M6_R1_0/CAP_BOTTOM_017 GND nfet_03v3 ad=0 pd=0 as=0 ps=0 w=1.56u l=0.28u
X1727 VREFN A44_DCTRL_STRIP_W_R2_0/CTRL_OUT[7] A44_CDAC_CAP_BANK_ASSEMBLY_R8_M6_0/A44_CAP_CORE128_M6_R1_0/CAP_BOTTOM_017 GND nfet_03v3 ad=0 pd=0 as=0 ps=0 w=1.56u l=0.28u
X1728 VREFN A44_DCTRL_STRIP_W_R2_0/CTRL_OUT[7] A44_CDAC_CAP_BANK_ASSEMBLY_R8_M6_0/A44_CAP_CORE128_M6_R1_0/CAP_BOTTOM_017 GND nfet_03v3 ad=0 pd=0 as=0 ps=0 w=1.56u l=0.28u
X1729 VREFN A44_DCTRL_STRIP_W_R2_0/CTRL_OUT[7] A44_CDAC_CAP_BANK_ASSEMBLY_R8_M6_0/A44_CAP_CORE128_M6_R1_0/CAP_BOTTOM_017 GND nfet_03v3 ad=0 pd=0 as=0 ps=0 w=1.56u l=0.28u
X1730 VREFP A44_DCTRL_STRIP_W_R2_0/CTRL_OUT[7] A44_CDAC_CAP_BANK_ASSEMBLY_R8_M6_0/A44_CAP_CORE128_M6_R1_0/CAP_BOTTOM_014 VDD pfet_03v3 ad=0 pd=0 as=16.6842p ps=77.76u w=1.56u l=0.28u
X1731 VREFP A44_DCTRL_STRIP_W_R2_0/CTRL_OUT[7] A44_CDAC_CAP_BANK_ASSEMBLY_R8_M6_0/A44_CAP_CORE128_M6_R1_0/CAP_BOTTOM_014 VDD pfet_03v3 ad=0 pd=0 as=0 ps=0 w=1.56u l=0.28u
X1732 VREFP A44_DCTRL_STRIP_W_R2_0/CTRL_OUT[7] A44_CDAC_CAP_BANK_ASSEMBLY_R8_M6_0/A44_CAP_CORE128_M6_R1_0/CAP_BOTTOM_014 VDD pfet_03v3 ad=0 pd=0 as=0 ps=0 w=1.56u l=0.28u
X1733 VREFP A44_DCTRL_STRIP_W_R2_0/CTRL_OUT[7] A44_CDAC_CAP_BANK_ASSEMBLY_R8_M6_0/A44_CAP_CORE128_M6_R1_0/CAP_BOTTOM_014 VDD pfet_03v3 ad=0 pd=0 as=0 ps=0 w=1.56u l=0.28u
X1734 VREFP A44_DCTRL_STRIP_W_R2_0/CTRL_OUT[7] A44_CDAC_CAP_BANK_ASSEMBLY_R8_M6_0/A44_CAP_CORE128_M6_R1_0/CAP_BOTTOM_014 VDD pfet_03v3 ad=0 pd=0 as=0 ps=0 w=1.56u l=0.28u
X1735 VREFP A44_DCTRL_STRIP_W_R2_0/CTRL_OUT[7] A44_CDAC_CAP_BANK_ASSEMBLY_R8_M6_0/A44_CAP_CORE128_M6_R1_0/CAP_BOTTOM_014 VDD pfet_03v3 ad=0 pd=0 as=0 ps=0 w=1.56u l=0.28u
X1736 VREFP A44_DCTRL_STRIP_W_R2_0/CTRL_OUT[7] A44_CDAC_CAP_BANK_ASSEMBLY_R8_M6_0/A44_CAP_CORE128_M6_R1_0/CAP_BOTTOM_014 VDD pfet_03v3 ad=0 pd=0 as=0 ps=0 w=1.56u l=0.28u
X1737 VREFP A44_DCTRL_STRIP_W_R2_0/CTRL_OUT[7] A44_CDAC_CAP_BANK_ASSEMBLY_R8_M6_0/A44_CAP_CORE128_M6_R1_0/CAP_BOTTOM_014 VDD pfet_03v3 ad=0 pd=0 as=0 ps=0 w=1.56u l=0.28u
X1738 VREFP A44_DCTRL_STRIP_W_R2_0/CTRL_OUT[7] A44_CDAC_CAP_BANK_ASSEMBLY_R8_M6_0/A44_CAP_CORE128_M6_R1_0/CAP_BOTTOM_014 VDD pfet_03v3 ad=0 pd=0 as=0 ps=0 w=1.56u l=0.28u
X1739 VREFP A44_DCTRL_STRIP_W_R2_0/CTRL_OUT[7] A44_CDAC_CAP_BANK_ASSEMBLY_R8_M6_0/A44_CAP_CORE128_M6_R1_0/CAP_BOTTOM_014 VDD pfet_03v3 ad=0 pd=0 as=0 ps=0 w=1.56u l=0.28u
X1740 VREFP A44_DCTRL_STRIP_W_R2_0/CTRL_OUT[7] A44_CDAC_CAP_BANK_ASSEMBLY_R8_M6_0/A44_CAP_CORE128_M6_R1_0/CAP_BOTTOM_014 VDD pfet_03v3 ad=0 pd=0 as=0 ps=0 w=1.56u l=0.28u
X1741 VREFP A44_DCTRL_STRIP_W_R2_0/CTRL_OUT[7] A44_CDAC_CAP_BANK_ASSEMBLY_R8_M6_0/A44_CAP_CORE128_M6_R1_0/CAP_BOTTOM_014 VDD pfet_03v3 ad=0 pd=0 as=0 ps=0 w=1.56u l=0.28u
X1742 VREFP A44_DCTRL_STRIP_W_R2_0/CTRL_OUT[7] A44_CDAC_CAP_BANK_ASSEMBLY_R8_M6_0/A44_CAP_CORE128_M6_R1_0/CAP_BOTTOM_014 VDD pfet_03v3 ad=0 pd=0 as=0 ps=0 w=1.56u l=0.28u
X1743 VREFP A44_DCTRL_STRIP_W_R2_0/CTRL_OUT[7] A44_CDAC_CAP_BANK_ASSEMBLY_R8_M6_0/A44_CAP_CORE128_M6_R1_0/CAP_BOTTOM_014 VDD pfet_03v3 ad=0 pd=0 as=0 ps=0 w=1.56u l=0.28u
X1744 VREFP A44_DCTRL_STRIP_W_R2_0/CTRL_OUT[7] A44_CDAC_CAP_BANK_ASSEMBLY_R8_M6_0/A44_CAP_CORE128_M6_R1_0/CAP_BOTTOM_014 VDD pfet_03v3 ad=0 pd=0 as=0 ps=0 w=1.56u l=0.28u
X1745 VREFP A44_DCTRL_STRIP_W_R2_0/CTRL_OUT[7] A44_CDAC_CAP_BANK_ASSEMBLY_R8_M6_0/A44_CAP_CORE128_M6_R1_0/CAP_BOTTOM_014 VDD pfet_03v3 ad=0 pd=0 as=0 ps=0 w=1.56u l=0.28u
X1746 VREFP A44_DCTRL_STRIP_W_R2_0/CTRL_OUT[7] A44_CDAC_CAP_BANK_ASSEMBLY_R8_M6_0/A44_CAP_CORE128_M6_R1_0/CAP_BOTTOM_014 VDD pfet_03v3 ad=0 pd=0 as=0 ps=0 w=1.56u l=0.28u
X1747 VREFP A44_DCTRL_STRIP_W_R2_0/CTRL_OUT[7] A44_CDAC_CAP_BANK_ASSEMBLY_R8_M6_0/A44_CAP_CORE128_M6_R1_0/CAP_BOTTOM_014 VDD pfet_03v3 ad=0 pd=0 as=0 ps=0 w=1.56u l=0.28u
X1748 VREFN A44_DCTRL_STRIP_W_R2_0/CTRL_OUT[7] A44_CDAC_CAP_BANK_ASSEMBLY_R8_M6_0/A44_CAP_CORE128_M6_R1_0/CAP_BOTTOM_014 GND nfet_03v3 ad=0 pd=0 as=16.6842p ps=77.76u w=1.56u l=0.28u
X1749 VREFN A44_DCTRL_STRIP_W_R2_0/CTRL_OUT[7] A44_CDAC_CAP_BANK_ASSEMBLY_R8_M6_0/A44_CAP_CORE128_M6_R1_0/CAP_BOTTOM_014 GND nfet_03v3 ad=0 pd=0 as=0 ps=0 w=1.56u l=0.28u
X1750 VREFN A44_DCTRL_STRIP_W_R2_0/CTRL_OUT[7] A44_CDAC_CAP_BANK_ASSEMBLY_R8_M6_0/A44_CAP_CORE128_M6_R1_0/CAP_BOTTOM_014 GND nfet_03v3 ad=0 pd=0 as=0 ps=0 w=1.56u l=0.28u
X1751 VREFN A44_DCTRL_STRIP_W_R2_0/CTRL_OUT[7] A44_CDAC_CAP_BANK_ASSEMBLY_R8_M6_0/A44_CAP_CORE128_M6_R1_0/CAP_BOTTOM_014 GND nfet_03v3 ad=0 pd=0 as=0 ps=0 w=1.56u l=0.28u
X1752 VREFN A44_DCTRL_STRIP_W_R2_0/CTRL_OUT[7] A44_CDAC_CAP_BANK_ASSEMBLY_R8_M6_0/A44_CAP_CORE128_M6_R1_0/CAP_BOTTOM_014 GND nfet_03v3 ad=0 pd=0 as=0 ps=0 w=1.56u l=0.28u
X1753 VREFN A44_DCTRL_STRIP_W_R2_0/CTRL_OUT[7] A44_CDAC_CAP_BANK_ASSEMBLY_R8_M6_0/A44_CAP_CORE128_M6_R1_0/CAP_BOTTOM_014 GND nfet_03v3 ad=0 pd=0 as=0 ps=0 w=1.56u l=0.28u
X1754 VREFN A44_DCTRL_STRIP_W_R2_0/CTRL_OUT[7] A44_CDAC_CAP_BANK_ASSEMBLY_R8_M6_0/A44_CAP_CORE128_M6_R1_0/CAP_BOTTOM_014 GND nfet_03v3 ad=0 pd=0 as=0 ps=0 w=1.56u l=0.28u
X1755 VREFN A44_DCTRL_STRIP_W_R2_0/CTRL_OUT[7] A44_CDAC_CAP_BANK_ASSEMBLY_R8_M6_0/A44_CAP_CORE128_M6_R1_0/CAP_BOTTOM_014 GND nfet_03v3 ad=0 pd=0 as=0 ps=0 w=1.56u l=0.28u
X1756 VREFN A44_DCTRL_STRIP_W_R2_0/CTRL_OUT[7] A44_CDAC_CAP_BANK_ASSEMBLY_R8_M6_0/A44_CAP_CORE128_M6_R1_0/CAP_BOTTOM_014 GND nfet_03v3 ad=0 pd=0 as=0 ps=0 w=1.56u l=0.28u
X1757 VREFN A44_DCTRL_STRIP_W_R2_0/CTRL_OUT[7] A44_CDAC_CAP_BANK_ASSEMBLY_R8_M6_0/A44_CAP_CORE128_M6_R1_0/CAP_BOTTOM_014 GND nfet_03v3 ad=0 pd=0 as=0 ps=0 w=1.56u l=0.28u
X1758 VREFN A44_DCTRL_STRIP_W_R2_0/CTRL_OUT[7] A44_CDAC_CAP_BANK_ASSEMBLY_R8_M6_0/A44_CAP_CORE128_M6_R1_0/CAP_BOTTOM_014 GND nfet_03v3 ad=0 pd=0 as=0 ps=0 w=1.56u l=0.28u
X1759 VREFN A44_DCTRL_STRIP_W_R2_0/CTRL_OUT[7] A44_CDAC_CAP_BANK_ASSEMBLY_R8_M6_0/A44_CAP_CORE128_M6_R1_0/CAP_BOTTOM_014 GND nfet_03v3 ad=0 pd=0 as=0 ps=0 w=1.56u l=0.28u
X1760 VREFN A44_DCTRL_STRIP_W_R2_0/CTRL_OUT[7] A44_CDAC_CAP_BANK_ASSEMBLY_R8_M6_0/A44_CAP_CORE128_M6_R1_0/CAP_BOTTOM_014 GND nfet_03v3 ad=0 pd=0 as=0 ps=0 w=1.56u l=0.28u
X1761 VREFN A44_DCTRL_STRIP_W_R2_0/CTRL_OUT[7] A44_CDAC_CAP_BANK_ASSEMBLY_R8_M6_0/A44_CAP_CORE128_M6_R1_0/CAP_BOTTOM_014 GND nfet_03v3 ad=0 pd=0 as=0 ps=0 w=1.56u l=0.28u
X1762 VREFN A44_DCTRL_STRIP_W_R2_0/CTRL_OUT[7] A44_CDAC_CAP_BANK_ASSEMBLY_R8_M6_0/A44_CAP_CORE128_M6_R1_0/CAP_BOTTOM_014 GND nfet_03v3 ad=0 pd=0 as=0 ps=0 w=1.56u l=0.28u
X1763 VREFN A44_DCTRL_STRIP_W_R2_0/CTRL_OUT[7] A44_CDAC_CAP_BANK_ASSEMBLY_R8_M6_0/A44_CAP_CORE128_M6_R1_0/CAP_BOTTOM_014 GND nfet_03v3 ad=0 pd=0 as=0 ps=0 w=1.56u l=0.28u
X1764 VREFN A44_DCTRL_STRIP_W_R2_0/CTRL_OUT[7] A44_CDAC_CAP_BANK_ASSEMBLY_R8_M6_0/A44_CAP_CORE128_M6_R1_0/CAP_BOTTOM_014 GND nfet_03v3 ad=0 pd=0 as=0 ps=0 w=1.56u l=0.28u
X1765 VREFN A44_DCTRL_STRIP_W_R2_0/CTRL_OUT[7] A44_CDAC_CAP_BANK_ASSEMBLY_R8_M6_0/A44_CAP_CORE128_M6_R1_0/CAP_BOTTOM_014 GND nfet_03v3 ad=0 pd=0 as=0 ps=0 w=1.56u l=0.28u
X1766 VREFP A44_DCTRL_STRIP_W_R2_0/CTRL_OUT[7] A44_CDAC_CAP_BANK_ASSEMBLY_R8_M6_0/A44_CAP_CORE128_M6_R1_0/CAP_BOTTOM_012 VDD pfet_03v3 ad=0 pd=0 as=16.6842p ps=77.76u w=1.56u l=0.28u
X1767 VREFP A44_DCTRL_STRIP_W_R2_0/CTRL_OUT[7] A44_CDAC_CAP_BANK_ASSEMBLY_R8_M6_0/A44_CAP_CORE128_M6_R1_0/CAP_BOTTOM_012 VDD pfet_03v3 ad=0 pd=0 as=0 ps=0 w=1.56u l=0.28u
X1768 VREFP A44_DCTRL_STRIP_W_R2_0/CTRL_OUT[7] A44_CDAC_CAP_BANK_ASSEMBLY_R8_M6_0/A44_CAP_CORE128_M6_R1_0/CAP_BOTTOM_012 VDD pfet_03v3 ad=0 pd=0 as=0 ps=0 w=1.56u l=0.28u
X1769 VREFP A44_DCTRL_STRIP_W_R2_0/CTRL_OUT[7] A44_CDAC_CAP_BANK_ASSEMBLY_R8_M6_0/A44_CAP_CORE128_M6_R1_0/CAP_BOTTOM_012 VDD pfet_03v3 ad=0 pd=0 as=0 ps=0 w=1.56u l=0.28u
X1770 VREFP A44_DCTRL_STRIP_W_R2_0/CTRL_OUT[7] A44_CDAC_CAP_BANK_ASSEMBLY_R8_M6_0/A44_CAP_CORE128_M6_R1_0/CAP_BOTTOM_012 VDD pfet_03v3 ad=0 pd=0 as=0 ps=0 w=1.56u l=0.28u
X1771 VREFP A44_DCTRL_STRIP_W_R2_0/CTRL_OUT[7] A44_CDAC_CAP_BANK_ASSEMBLY_R8_M6_0/A44_CAP_CORE128_M6_R1_0/CAP_BOTTOM_012 VDD pfet_03v3 ad=0 pd=0 as=0 ps=0 w=1.56u l=0.28u
X1772 VREFP A44_DCTRL_STRIP_W_R2_0/CTRL_OUT[7] A44_CDAC_CAP_BANK_ASSEMBLY_R8_M6_0/A44_CAP_CORE128_M6_R1_0/CAP_BOTTOM_012 VDD pfet_03v3 ad=0 pd=0 as=0 ps=0 w=1.56u l=0.28u
X1773 VREFP A44_DCTRL_STRIP_W_R2_0/CTRL_OUT[7] A44_CDAC_CAP_BANK_ASSEMBLY_R8_M6_0/A44_CAP_CORE128_M6_R1_0/CAP_BOTTOM_012 VDD pfet_03v3 ad=0 pd=0 as=0 ps=0 w=1.56u l=0.28u
X1774 VREFP A44_DCTRL_STRIP_W_R2_0/CTRL_OUT[7] A44_CDAC_CAP_BANK_ASSEMBLY_R8_M6_0/A44_CAP_CORE128_M6_R1_0/CAP_BOTTOM_012 VDD pfet_03v3 ad=0 pd=0 as=0 ps=0 w=1.56u l=0.28u
X1775 VREFP A44_DCTRL_STRIP_W_R2_0/CTRL_OUT[7] A44_CDAC_CAP_BANK_ASSEMBLY_R8_M6_0/A44_CAP_CORE128_M6_R1_0/CAP_BOTTOM_012 VDD pfet_03v3 ad=0 pd=0 as=0 ps=0 w=1.56u l=0.28u
X1776 VREFP A44_DCTRL_STRIP_W_R2_0/CTRL_OUT[7] A44_CDAC_CAP_BANK_ASSEMBLY_R8_M6_0/A44_CAP_CORE128_M6_R1_0/CAP_BOTTOM_012 VDD pfet_03v3 ad=0 pd=0 as=0 ps=0 w=1.56u l=0.28u
X1777 VREFP A44_DCTRL_STRIP_W_R2_0/CTRL_OUT[7] A44_CDAC_CAP_BANK_ASSEMBLY_R8_M6_0/A44_CAP_CORE128_M6_R1_0/CAP_BOTTOM_012 VDD pfet_03v3 ad=0 pd=0 as=0 ps=0 w=1.56u l=0.28u
X1778 VREFP A44_DCTRL_STRIP_W_R2_0/CTRL_OUT[7] A44_CDAC_CAP_BANK_ASSEMBLY_R8_M6_0/A44_CAP_CORE128_M6_R1_0/CAP_BOTTOM_012 VDD pfet_03v3 ad=0 pd=0 as=0 ps=0 w=1.56u l=0.28u
X1779 VREFP A44_DCTRL_STRIP_W_R2_0/CTRL_OUT[7] A44_CDAC_CAP_BANK_ASSEMBLY_R8_M6_0/A44_CAP_CORE128_M6_R1_0/CAP_BOTTOM_012 VDD pfet_03v3 ad=0 pd=0 as=0 ps=0 w=1.56u l=0.28u
X1780 VREFP A44_DCTRL_STRIP_W_R2_0/CTRL_OUT[7] A44_CDAC_CAP_BANK_ASSEMBLY_R8_M6_0/A44_CAP_CORE128_M6_R1_0/CAP_BOTTOM_012 VDD pfet_03v3 ad=0 pd=0 as=0 ps=0 w=1.56u l=0.28u
X1781 VREFP A44_DCTRL_STRIP_W_R2_0/CTRL_OUT[7] A44_CDAC_CAP_BANK_ASSEMBLY_R8_M6_0/A44_CAP_CORE128_M6_R1_0/CAP_BOTTOM_012 VDD pfet_03v3 ad=0 pd=0 as=0 ps=0 w=1.56u l=0.28u
X1782 VREFP A44_DCTRL_STRIP_W_R2_0/CTRL_OUT[7] A44_CDAC_CAP_BANK_ASSEMBLY_R8_M6_0/A44_CAP_CORE128_M6_R1_0/CAP_BOTTOM_012 VDD pfet_03v3 ad=0 pd=0 as=0 ps=0 w=1.56u l=0.28u
X1783 VREFP A44_DCTRL_STRIP_W_R2_0/CTRL_OUT[7] A44_CDAC_CAP_BANK_ASSEMBLY_R8_M6_0/A44_CAP_CORE128_M6_R1_0/CAP_BOTTOM_012 VDD pfet_03v3 ad=0 pd=0 as=0 ps=0 w=1.56u l=0.28u
X1784 VREFN A44_DCTRL_STRIP_W_R2_0/CTRL_OUT[7] A44_CDAC_CAP_BANK_ASSEMBLY_R8_M6_0/A44_CAP_CORE128_M6_R1_0/CAP_BOTTOM_012 GND nfet_03v3 ad=0 pd=0 as=16.6842p ps=77.76u w=1.56u l=0.28u
X1785 VREFN A44_DCTRL_STRIP_W_R2_0/CTRL_OUT[7] A44_CDAC_CAP_BANK_ASSEMBLY_R8_M6_0/A44_CAP_CORE128_M6_R1_0/CAP_BOTTOM_012 GND nfet_03v3 ad=0 pd=0 as=0 ps=0 w=1.56u l=0.28u
X1786 VREFN A44_DCTRL_STRIP_W_R2_0/CTRL_OUT[7] A44_CDAC_CAP_BANK_ASSEMBLY_R8_M6_0/A44_CAP_CORE128_M6_R1_0/CAP_BOTTOM_012 GND nfet_03v3 ad=0 pd=0 as=0 ps=0 w=1.56u l=0.28u
X1787 VREFN A44_DCTRL_STRIP_W_R2_0/CTRL_OUT[7] A44_CDAC_CAP_BANK_ASSEMBLY_R8_M6_0/A44_CAP_CORE128_M6_R1_0/CAP_BOTTOM_012 GND nfet_03v3 ad=0 pd=0 as=0 ps=0 w=1.56u l=0.28u
X1788 VREFN A44_DCTRL_STRIP_W_R2_0/CTRL_OUT[7] A44_CDAC_CAP_BANK_ASSEMBLY_R8_M6_0/A44_CAP_CORE128_M6_R1_0/CAP_BOTTOM_012 GND nfet_03v3 ad=0 pd=0 as=0 ps=0 w=1.56u l=0.28u
X1789 VREFN A44_DCTRL_STRIP_W_R2_0/CTRL_OUT[7] A44_CDAC_CAP_BANK_ASSEMBLY_R8_M6_0/A44_CAP_CORE128_M6_R1_0/CAP_BOTTOM_012 GND nfet_03v3 ad=0 pd=0 as=0 ps=0 w=1.56u l=0.28u
X1790 VREFN A44_DCTRL_STRIP_W_R2_0/CTRL_OUT[7] A44_CDAC_CAP_BANK_ASSEMBLY_R8_M6_0/A44_CAP_CORE128_M6_R1_0/CAP_BOTTOM_012 GND nfet_03v3 ad=0 pd=0 as=0 ps=0 w=1.56u l=0.28u
X1791 VREFN A44_DCTRL_STRIP_W_R2_0/CTRL_OUT[7] A44_CDAC_CAP_BANK_ASSEMBLY_R8_M6_0/A44_CAP_CORE128_M6_R1_0/CAP_BOTTOM_012 GND nfet_03v3 ad=0 pd=0 as=0 ps=0 w=1.56u l=0.28u
X1792 VREFN A44_DCTRL_STRIP_W_R2_0/CTRL_OUT[7] A44_CDAC_CAP_BANK_ASSEMBLY_R8_M6_0/A44_CAP_CORE128_M6_R1_0/CAP_BOTTOM_012 GND nfet_03v3 ad=0 pd=0 as=0 ps=0 w=1.56u l=0.28u
X1793 VREFN A44_DCTRL_STRIP_W_R2_0/CTRL_OUT[7] A44_CDAC_CAP_BANK_ASSEMBLY_R8_M6_0/A44_CAP_CORE128_M6_R1_0/CAP_BOTTOM_012 GND nfet_03v3 ad=0 pd=0 as=0 ps=0 w=1.56u l=0.28u
X1794 VREFN A44_DCTRL_STRIP_W_R2_0/CTRL_OUT[7] A44_CDAC_CAP_BANK_ASSEMBLY_R8_M6_0/A44_CAP_CORE128_M6_R1_0/CAP_BOTTOM_012 GND nfet_03v3 ad=0 pd=0 as=0 ps=0 w=1.56u l=0.28u
X1795 VREFN A44_DCTRL_STRIP_W_R2_0/CTRL_OUT[7] A44_CDAC_CAP_BANK_ASSEMBLY_R8_M6_0/A44_CAP_CORE128_M6_R1_0/CAP_BOTTOM_012 GND nfet_03v3 ad=0 pd=0 as=0 ps=0 w=1.56u l=0.28u
X1796 VREFN A44_DCTRL_STRIP_W_R2_0/CTRL_OUT[7] A44_CDAC_CAP_BANK_ASSEMBLY_R8_M6_0/A44_CAP_CORE128_M6_R1_0/CAP_BOTTOM_012 GND nfet_03v3 ad=0 pd=0 as=0 ps=0 w=1.56u l=0.28u
X1797 VREFN A44_DCTRL_STRIP_W_R2_0/CTRL_OUT[7] A44_CDAC_CAP_BANK_ASSEMBLY_R8_M6_0/A44_CAP_CORE128_M6_R1_0/CAP_BOTTOM_012 GND nfet_03v3 ad=0 pd=0 as=0 ps=0 w=1.56u l=0.28u
X1798 VREFN A44_DCTRL_STRIP_W_R2_0/CTRL_OUT[7] A44_CDAC_CAP_BANK_ASSEMBLY_R8_M6_0/A44_CAP_CORE128_M6_R1_0/CAP_BOTTOM_012 GND nfet_03v3 ad=0 pd=0 as=0 ps=0 w=1.56u l=0.28u
X1799 VREFN A44_DCTRL_STRIP_W_R2_0/CTRL_OUT[7] A44_CDAC_CAP_BANK_ASSEMBLY_R8_M6_0/A44_CAP_CORE128_M6_R1_0/CAP_BOTTOM_012 GND nfet_03v3 ad=0 pd=0 as=0 ps=0 w=1.56u l=0.28u
X1800 VREFN A44_DCTRL_STRIP_W_R2_0/CTRL_OUT[7] A44_CDAC_CAP_BANK_ASSEMBLY_R8_M6_0/A44_CAP_CORE128_M6_R1_0/CAP_BOTTOM_012 GND nfet_03v3 ad=0 pd=0 as=0 ps=0 w=1.56u l=0.28u
X1801 VREFN A44_DCTRL_STRIP_W_R2_0/CTRL_OUT[7] A44_CDAC_CAP_BANK_ASSEMBLY_R8_M6_0/A44_CAP_CORE128_M6_R1_0/CAP_BOTTOM_012 GND nfet_03v3 ad=0 pd=0 as=0 ps=0 w=1.56u l=0.28u
X1802 VREFP A44_DCTRL_STRIP_W_R2_0/CTRL_OUT[6] A44_CDAC_CAP_BANK_ASSEMBLY_R8_M6_0/A44_CAP_CORE128_M6_R1_0/CAP_BOTTOM_038 VDD pfet_03v3 ad=0 pd=0 as=16.6842p ps=77.76u w=1.56u l=0.28u
X1803 VREFP A44_DCTRL_STRIP_W_R2_0/CTRL_OUT[6] A44_CDAC_CAP_BANK_ASSEMBLY_R8_M6_0/A44_CAP_CORE128_M6_R1_0/CAP_BOTTOM_038 VDD pfet_03v3 ad=0 pd=0 as=0 ps=0 w=1.56u l=0.28u
X1804 VREFP A44_DCTRL_STRIP_W_R2_0/CTRL_OUT[6] A44_CDAC_CAP_BANK_ASSEMBLY_R8_M6_0/A44_CAP_CORE128_M6_R1_0/CAP_BOTTOM_038 VDD pfet_03v3 ad=0 pd=0 as=0 ps=0 w=1.56u l=0.28u
X1805 VREFP A44_DCTRL_STRIP_W_R2_0/CTRL_OUT[6] A44_CDAC_CAP_BANK_ASSEMBLY_R8_M6_0/A44_CAP_CORE128_M6_R1_0/CAP_BOTTOM_038 VDD pfet_03v3 ad=0 pd=0 as=0 ps=0 w=1.56u l=0.28u
X1806 VREFP A44_DCTRL_STRIP_W_R2_0/CTRL_OUT[6] A44_CDAC_CAP_BANK_ASSEMBLY_R8_M6_0/A44_CAP_CORE128_M6_R1_0/CAP_BOTTOM_038 VDD pfet_03v3 ad=0 pd=0 as=0 ps=0 w=1.56u l=0.28u
X1807 VREFP A44_DCTRL_STRIP_W_R2_0/CTRL_OUT[6] A44_CDAC_CAP_BANK_ASSEMBLY_R8_M6_0/A44_CAP_CORE128_M6_R1_0/CAP_BOTTOM_038 VDD pfet_03v3 ad=0 pd=0 as=0 ps=0 w=1.56u l=0.28u
X1808 VREFP A44_DCTRL_STRIP_W_R2_0/CTRL_OUT[6] A44_CDAC_CAP_BANK_ASSEMBLY_R8_M6_0/A44_CAP_CORE128_M6_R1_0/CAP_BOTTOM_038 VDD pfet_03v3 ad=0 pd=0 as=0 ps=0 w=1.56u l=0.28u
X1809 VREFP A44_DCTRL_STRIP_W_R2_0/CTRL_OUT[6] A44_CDAC_CAP_BANK_ASSEMBLY_R8_M6_0/A44_CAP_CORE128_M6_R1_0/CAP_BOTTOM_038 VDD pfet_03v3 ad=0 pd=0 as=0 ps=0 w=1.56u l=0.28u
X1810 VREFP A44_DCTRL_STRIP_W_R2_0/CTRL_OUT[6] A44_CDAC_CAP_BANK_ASSEMBLY_R8_M6_0/A44_CAP_CORE128_M6_R1_0/CAP_BOTTOM_038 VDD pfet_03v3 ad=0 pd=0 as=0 ps=0 w=1.56u l=0.28u
X1811 VREFP A44_DCTRL_STRIP_W_R2_0/CTRL_OUT[6] A44_CDAC_CAP_BANK_ASSEMBLY_R8_M6_0/A44_CAP_CORE128_M6_R1_0/CAP_BOTTOM_038 VDD pfet_03v3 ad=0 pd=0 as=0 ps=0 w=1.56u l=0.28u
X1812 VREFP A44_DCTRL_STRIP_W_R2_0/CTRL_OUT[6] A44_CDAC_CAP_BANK_ASSEMBLY_R8_M6_0/A44_CAP_CORE128_M6_R1_0/CAP_BOTTOM_038 VDD pfet_03v3 ad=0 pd=0 as=0 ps=0 w=1.56u l=0.28u
X1813 VREFP A44_DCTRL_STRIP_W_R2_0/CTRL_OUT[6] A44_CDAC_CAP_BANK_ASSEMBLY_R8_M6_0/A44_CAP_CORE128_M6_R1_0/CAP_BOTTOM_038 VDD pfet_03v3 ad=0 pd=0 as=0 ps=0 w=1.56u l=0.28u
X1814 VREFP A44_DCTRL_STRIP_W_R2_0/CTRL_OUT[6] A44_CDAC_CAP_BANK_ASSEMBLY_R8_M6_0/A44_CAP_CORE128_M6_R1_0/CAP_BOTTOM_038 VDD pfet_03v3 ad=0 pd=0 as=0 ps=0 w=1.56u l=0.28u
X1815 VREFP A44_DCTRL_STRIP_W_R2_0/CTRL_OUT[6] A44_CDAC_CAP_BANK_ASSEMBLY_R8_M6_0/A44_CAP_CORE128_M6_R1_0/CAP_BOTTOM_038 VDD pfet_03v3 ad=0 pd=0 as=0 ps=0 w=1.56u l=0.28u
X1816 VREFP A44_DCTRL_STRIP_W_R2_0/CTRL_OUT[6] A44_CDAC_CAP_BANK_ASSEMBLY_R8_M6_0/A44_CAP_CORE128_M6_R1_0/CAP_BOTTOM_038 VDD pfet_03v3 ad=0 pd=0 as=0 ps=0 w=1.56u l=0.28u
X1817 VREFP A44_DCTRL_STRIP_W_R2_0/CTRL_OUT[6] A44_CDAC_CAP_BANK_ASSEMBLY_R8_M6_0/A44_CAP_CORE128_M6_R1_0/CAP_BOTTOM_038 VDD pfet_03v3 ad=0 pd=0 as=0 ps=0 w=1.56u l=0.28u
X1818 VREFP A44_DCTRL_STRIP_W_R2_0/CTRL_OUT[6] A44_CDAC_CAP_BANK_ASSEMBLY_R8_M6_0/A44_CAP_CORE128_M6_R1_0/CAP_BOTTOM_038 VDD pfet_03v3 ad=0 pd=0 as=0 ps=0 w=1.56u l=0.28u
X1819 VREFP A44_DCTRL_STRIP_W_R2_0/CTRL_OUT[6] A44_CDAC_CAP_BANK_ASSEMBLY_R8_M6_0/A44_CAP_CORE128_M6_R1_0/CAP_BOTTOM_038 VDD pfet_03v3 ad=0 pd=0 as=0 ps=0 w=1.56u l=0.28u
X1820 VREFN A44_DCTRL_STRIP_W_R2_0/CTRL_OUT[6] A44_CDAC_CAP_BANK_ASSEMBLY_R8_M6_0/A44_CAP_CORE128_M6_R1_0/CAP_BOTTOM_038 GND nfet_03v3 ad=0 pd=0 as=16.6842p ps=77.76u w=1.56u l=0.28u
X1821 VREFN A44_DCTRL_STRIP_W_R2_0/CTRL_OUT[6] A44_CDAC_CAP_BANK_ASSEMBLY_R8_M6_0/A44_CAP_CORE128_M6_R1_0/CAP_BOTTOM_038 GND nfet_03v3 ad=0 pd=0 as=0 ps=0 w=1.56u l=0.28u
X1822 VREFN A44_DCTRL_STRIP_W_R2_0/CTRL_OUT[6] A44_CDAC_CAP_BANK_ASSEMBLY_R8_M6_0/A44_CAP_CORE128_M6_R1_0/CAP_BOTTOM_038 GND nfet_03v3 ad=0 pd=0 as=0 ps=0 w=1.56u l=0.28u
X1823 VREFN A44_DCTRL_STRIP_W_R2_0/CTRL_OUT[6] A44_CDAC_CAP_BANK_ASSEMBLY_R8_M6_0/A44_CAP_CORE128_M6_R1_0/CAP_BOTTOM_038 GND nfet_03v3 ad=0 pd=0 as=0 ps=0 w=1.56u l=0.28u
X1824 VREFN A44_DCTRL_STRIP_W_R2_0/CTRL_OUT[6] A44_CDAC_CAP_BANK_ASSEMBLY_R8_M6_0/A44_CAP_CORE128_M6_R1_0/CAP_BOTTOM_038 GND nfet_03v3 ad=0 pd=0 as=0 ps=0 w=1.56u l=0.28u
X1825 VREFN A44_DCTRL_STRIP_W_R2_0/CTRL_OUT[6] A44_CDAC_CAP_BANK_ASSEMBLY_R8_M6_0/A44_CAP_CORE128_M6_R1_0/CAP_BOTTOM_038 GND nfet_03v3 ad=0 pd=0 as=0 ps=0 w=1.56u l=0.28u
X1826 VREFN A44_DCTRL_STRIP_W_R2_0/CTRL_OUT[6] A44_CDAC_CAP_BANK_ASSEMBLY_R8_M6_0/A44_CAP_CORE128_M6_R1_0/CAP_BOTTOM_038 GND nfet_03v3 ad=0 pd=0 as=0 ps=0 w=1.56u l=0.28u
X1827 VREFN A44_DCTRL_STRIP_W_R2_0/CTRL_OUT[6] A44_CDAC_CAP_BANK_ASSEMBLY_R8_M6_0/A44_CAP_CORE128_M6_R1_0/CAP_BOTTOM_038 GND nfet_03v3 ad=0 pd=0 as=0 ps=0 w=1.56u l=0.28u
X1828 VREFN A44_DCTRL_STRIP_W_R2_0/CTRL_OUT[6] A44_CDAC_CAP_BANK_ASSEMBLY_R8_M6_0/A44_CAP_CORE128_M6_R1_0/CAP_BOTTOM_038 GND nfet_03v3 ad=0 pd=0 as=0 ps=0 w=1.56u l=0.28u
X1829 VREFN A44_DCTRL_STRIP_W_R2_0/CTRL_OUT[6] A44_CDAC_CAP_BANK_ASSEMBLY_R8_M6_0/A44_CAP_CORE128_M6_R1_0/CAP_BOTTOM_038 GND nfet_03v3 ad=0 pd=0 as=0 ps=0 w=1.56u l=0.28u
X1830 VREFN A44_DCTRL_STRIP_W_R2_0/CTRL_OUT[6] A44_CDAC_CAP_BANK_ASSEMBLY_R8_M6_0/A44_CAP_CORE128_M6_R1_0/CAP_BOTTOM_038 GND nfet_03v3 ad=0 pd=0 as=0 ps=0 w=1.56u l=0.28u
X1831 VREFN A44_DCTRL_STRIP_W_R2_0/CTRL_OUT[6] A44_CDAC_CAP_BANK_ASSEMBLY_R8_M6_0/A44_CAP_CORE128_M6_R1_0/CAP_BOTTOM_038 GND nfet_03v3 ad=0 pd=0 as=0 ps=0 w=1.56u l=0.28u
X1832 VREFN A44_DCTRL_STRIP_W_R2_0/CTRL_OUT[6] A44_CDAC_CAP_BANK_ASSEMBLY_R8_M6_0/A44_CAP_CORE128_M6_R1_0/CAP_BOTTOM_038 GND nfet_03v3 ad=0 pd=0 as=0 ps=0 w=1.56u l=0.28u
X1833 VREFN A44_DCTRL_STRIP_W_R2_0/CTRL_OUT[6] A44_CDAC_CAP_BANK_ASSEMBLY_R8_M6_0/A44_CAP_CORE128_M6_R1_0/CAP_BOTTOM_038 GND nfet_03v3 ad=0 pd=0 as=0 ps=0 w=1.56u l=0.28u
X1834 VREFN A44_DCTRL_STRIP_W_R2_0/CTRL_OUT[6] A44_CDAC_CAP_BANK_ASSEMBLY_R8_M6_0/A44_CAP_CORE128_M6_R1_0/CAP_BOTTOM_038 GND nfet_03v3 ad=0 pd=0 as=0 ps=0 w=1.56u l=0.28u
X1835 VREFN A44_DCTRL_STRIP_W_R2_0/CTRL_OUT[6] A44_CDAC_CAP_BANK_ASSEMBLY_R8_M6_0/A44_CAP_CORE128_M6_R1_0/CAP_BOTTOM_038 GND nfet_03v3 ad=0 pd=0 as=0 ps=0 w=1.56u l=0.28u
X1836 VREFN A44_DCTRL_STRIP_W_R2_0/CTRL_OUT[6] A44_CDAC_CAP_BANK_ASSEMBLY_R8_M6_0/A44_CAP_CORE128_M6_R1_0/CAP_BOTTOM_038 GND nfet_03v3 ad=0 pd=0 as=0 ps=0 w=1.56u l=0.28u
X1837 VREFN A44_DCTRL_STRIP_W_R2_0/CTRL_OUT[6] A44_CDAC_CAP_BANK_ASSEMBLY_R8_M6_0/A44_CAP_CORE128_M6_R1_0/CAP_BOTTOM_038 GND nfet_03v3 ad=0 pd=0 as=0 ps=0 w=1.56u l=0.28u
X1838 VREFP A44_DCTRL_STRIP_W_R2_0/CTRL_OUT[3] A44_CDAC_CAP_BANK_ASSEMBLY_R8_M6_0/A44_CAP_CORE128_M6_R1_0/CAP_BOTTOM_001 VDD pfet_03v3 ad=0 pd=0 as=16.6842p ps=77.76u w=1.56u l=0.28u
X1839 VREFP A44_DCTRL_STRIP_W_R2_0/CTRL_OUT[3] A44_CDAC_CAP_BANK_ASSEMBLY_R8_M6_0/A44_CAP_CORE128_M6_R1_0/CAP_BOTTOM_001 VDD pfet_03v3 ad=0 pd=0 as=0 ps=0 w=1.56u l=0.28u
X1840 VREFP A44_DCTRL_STRIP_W_R2_0/CTRL_OUT[3] A44_CDAC_CAP_BANK_ASSEMBLY_R8_M6_0/A44_CAP_CORE128_M6_R1_0/CAP_BOTTOM_001 VDD pfet_03v3 ad=0 pd=0 as=0 ps=0 w=1.56u l=0.28u
X1841 VREFP A44_DCTRL_STRIP_W_R2_0/CTRL_OUT[3] A44_CDAC_CAP_BANK_ASSEMBLY_R8_M6_0/A44_CAP_CORE128_M6_R1_0/CAP_BOTTOM_001 VDD pfet_03v3 ad=0 pd=0 as=0 ps=0 w=1.56u l=0.28u
X1842 VREFP A44_DCTRL_STRIP_W_R2_0/CTRL_OUT[3] A44_CDAC_CAP_BANK_ASSEMBLY_R8_M6_0/A44_CAP_CORE128_M6_R1_0/CAP_BOTTOM_001 VDD pfet_03v3 ad=0 pd=0 as=0 ps=0 w=1.56u l=0.28u
X1843 VREFP A44_DCTRL_STRIP_W_R2_0/CTRL_OUT[3] A44_CDAC_CAP_BANK_ASSEMBLY_R8_M6_0/A44_CAP_CORE128_M6_R1_0/CAP_BOTTOM_001 VDD pfet_03v3 ad=0 pd=0 as=0 ps=0 w=1.56u l=0.28u
X1844 VREFP A44_DCTRL_STRIP_W_R2_0/CTRL_OUT[3] A44_CDAC_CAP_BANK_ASSEMBLY_R8_M6_0/A44_CAP_CORE128_M6_R1_0/CAP_BOTTOM_001 VDD pfet_03v3 ad=0 pd=0 as=0 ps=0 w=1.56u l=0.28u
X1845 VREFP A44_DCTRL_STRIP_W_R2_0/CTRL_OUT[3] A44_CDAC_CAP_BANK_ASSEMBLY_R8_M6_0/A44_CAP_CORE128_M6_R1_0/CAP_BOTTOM_001 VDD pfet_03v3 ad=0 pd=0 as=0 ps=0 w=1.56u l=0.28u
X1846 VREFP A44_DCTRL_STRIP_W_R2_0/CTRL_OUT[3] A44_CDAC_CAP_BANK_ASSEMBLY_R8_M6_0/A44_CAP_CORE128_M6_R1_0/CAP_BOTTOM_001 VDD pfet_03v3 ad=0 pd=0 as=0 ps=0 w=1.56u l=0.28u
X1847 VREFP A44_DCTRL_STRIP_W_R2_0/CTRL_OUT[3] A44_CDAC_CAP_BANK_ASSEMBLY_R8_M6_0/A44_CAP_CORE128_M6_R1_0/CAP_BOTTOM_001 VDD pfet_03v3 ad=0 pd=0 as=0 ps=0 w=1.56u l=0.28u
X1848 VREFP A44_DCTRL_STRIP_W_R2_0/CTRL_OUT[3] A44_CDAC_CAP_BANK_ASSEMBLY_R8_M6_0/A44_CAP_CORE128_M6_R1_0/CAP_BOTTOM_001 VDD pfet_03v3 ad=0 pd=0 as=0 ps=0 w=1.56u l=0.28u
X1849 VREFP A44_DCTRL_STRIP_W_R2_0/CTRL_OUT[3] A44_CDAC_CAP_BANK_ASSEMBLY_R8_M6_0/A44_CAP_CORE128_M6_R1_0/CAP_BOTTOM_001 VDD pfet_03v3 ad=0 pd=0 as=0 ps=0 w=1.56u l=0.28u
X1850 VREFP A44_DCTRL_STRIP_W_R2_0/CTRL_OUT[3] A44_CDAC_CAP_BANK_ASSEMBLY_R8_M6_0/A44_CAP_CORE128_M6_R1_0/CAP_BOTTOM_001 VDD pfet_03v3 ad=0 pd=0 as=0 ps=0 w=1.56u l=0.28u
X1851 VREFP A44_DCTRL_STRIP_W_R2_0/CTRL_OUT[3] A44_CDAC_CAP_BANK_ASSEMBLY_R8_M6_0/A44_CAP_CORE128_M6_R1_0/CAP_BOTTOM_001 VDD pfet_03v3 ad=0 pd=0 as=0 ps=0 w=1.56u l=0.28u
X1852 VREFP A44_DCTRL_STRIP_W_R2_0/CTRL_OUT[3] A44_CDAC_CAP_BANK_ASSEMBLY_R8_M6_0/A44_CAP_CORE128_M6_R1_0/CAP_BOTTOM_001 VDD pfet_03v3 ad=0 pd=0 as=0 ps=0 w=1.56u l=0.28u
X1853 VREFP A44_DCTRL_STRIP_W_R2_0/CTRL_OUT[3] A44_CDAC_CAP_BANK_ASSEMBLY_R8_M6_0/A44_CAP_CORE128_M6_R1_0/CAP_BOTTOM_001 VDD pfet_03v3 ad=0 pd=0 as=0 ps=0 w=1.56u l=0.28u
X1854 VREFP A44_DCTRL_STRIP_W_R2_0/CTRL_OUT[3] A44_CDAC_CAP_BANK_ASSEMBLY_R8_M6_0/A44_CAP_CORE128_M6_R1_0/CAP_BOTTOM_001 VDD pfet_03v3 ad=0 pd=0 as=0 ps=0 w=1.56u l=0.28u
X1855 VREFP A44_DCTRL_STRIP_W_R2_0/CTRL_OUT[3] A44_CDAC_CAP_BANK_ASSEMBLY_R8_M6_0/A44_CAP_CORE128_M6_R1_0/CAP_BOTTOM_001 VDD pfet_03v3 ad=0 pd=0 as=0 ps=0 w=1.56u l=0.28u
X1856 VREFN A44_DCTRL_STRIP_W_R2_0/CTRL_OUT[3] A44_CDAC_CAP_BANK_ASSEMBLY_R8_M6_0/A44_CAP_CORE128_M6_R1_0/CAP_BOTTOM_001 GND nfet_03v3 ad=0 pd=0 as=16.6842p ps=77.76u w=1.56u l=0.28u
X1857 VREFN A44_DCTRL_STRIP_W_R2_0/CTRL_OUT[3] A44_CDAC_CAP_BANK_ASSEMBLY_R8_M6_0/A44_CAP_CORE128_M6_R1_0/CAP_BOTTOM_001 GND nfet_03v3 ad=0 pd=0 as=0 ps=0 w=1.56u l=0.28u
X1858 VREFN A44_DCTRL_STRIP_W_R2_0/CTRL_OUT[3] A44_CDAC_CAP_BANK_ASSEMBLY_R8_M6_0/A44_CAP_CORE128_M6_R1_0/CAP_BOTTOM_001 GND nfet_03v3 ad=0 pd=0 as=0 ps=0 w=1.56u l=0.28u
X1859 VREFN A44_DCTRL_STRIP_W_R2_0/CTRL_OUT[3] A44_CDAC_CAP_BANK_ASSEMBLY_R8_M6_0/A44_CAP_CORE128_M6_R1_0/CAP_BOTTOM_001 GND nfet_03v3 ad=0 pd=0 as=0 ps=0 w=1.56u l=0.28u
X1860 VREFN A44_DCTRL_STRIP_W_R2_0/CTRL_OUT[3] A44_CDAC_CAP_BANK_ASSEMBLY_R8_M6_0/A44_CAP_CORE128_M6_R1_0/CAP_BOTTOM_001 GND nfet_03v3 ad=0 pd=0 as=0 ps=0 w=1.56u l=0.28u
X1861 VREFN A44_DCTRL_STRIP_W_R2_0/CTRL_OUT[3] A44_CDAC_CAP_BANK_ASSEMBLY_R8_M6_0/A44_CAP_CORE128_M6_R1_0/CAP_BOTTOM_001 GND nfet_03v3 ad=0 pd=0 as=0 ps=0 w=1.56u l=0.28u
X1862 VREFN A44_DCTRL_STRIP_W_R2_0/CTRL_OUT[3] A44_CDAC_CAP_BANK_ASSEMBLY_R8_M6_0/A44_CAP_CORE128_M6_R1_0/CAP_BOTTOM_001 GND nfet_03v3 ad=0 pd=0 as=0 ps=0 w=1.56u l=0.28u
X1863 VREFN A44_DCTRL_STRIP_W_R2_0/CTRL_OUT[3] A44_CDAC_CAP_BANK_ASSEMBLY_R8_M6_0/A44_CAP_CORE128_M6_R1_0/CAP_BOTTOM_001 GND nfet_03v3 ad=0 pd=0 as=0 ps=0 w=1.56u l=0.28u
X1864 VREFN A44_DCTRL_STRIP_W_R2_0/CTRL_OUT[3] A44_CDAC_CAP_BANK_ASSEMBLY_R8_M6_0/A44_CAP_CORE128_M6_R1_0/CAP_BOTTOM_001 GND nfet_03v3 ad=0 pd=0 as=0 ps=0 w=1.56u l=0.28u
X1865 VREFN A44_DCTRL_STRIP_W_R2_0/CTRL_OUT[3] A44_CDAC_CAP_BANK_ASSEMBLY_R8_M6_0/A44_CAP_CORE128_M6_R1_0/CAP_BOTTOM_001 GND nfet_03v3 ad=0 pd=0 as=0 ps=0 w=1.56u l=0.28u
X1866 VREFN A44_DCTRL_STRIP_W_R2_0/CTRL_OUT[3] A44_CDAC_CAP_BANK_ASSEMBLY_R8_M6_0/A44_CAP_CORE128_M6_R1_0/CAP_BOTTOM_001 GND nfet_03v3 ad=0 pd=0 as=0 ps=0 w=1.56u l=0.28u
X1867 VREFN A44_DCTRL_STRIP_W_R2_0/CTRL_OUT[3] A44_CDAC_CAP_BANK_ASSEMBLY_R8_M6_0/A44_CAP_CORE128_M6_R1_0/CAP_BOTTOM_001 GND nfet_03v3 ad=0 pd=0 as=0 ps=0 w=1.56u l=0.28u
X1868 VREFN A44_DCTRL_STRIP_W_R2_0/CTRL_OUT[3] A44_CDAC_CAP_BANK_ASSEMBLY_R8_M6_0/A44_CAP_CORE128_M6_R1_0/CAP_BOTTOM_001 GND nfet_03v3 ad=0 pd=0 as=0 ps=0 w=1.56u l=0.28u
X1869 VREFN A44_DCTRL_STRIP_W_R2_0/CTRL_OUT[3] A44_CDAC_CAP_BANK_ASSEMBLY_R8_M6_0/A44_CAP_CORE128_M6_R1_0/CAP_BOTTOM_001 GND nfet_03v3 ad=0 pd=0 as=0 ps=0 w=1.56u l=0.28u
X1870 VREFN A44_DCTRL_STRIP_W_R2_0/CTRL_OUT[3] A44_CDAC_CAP_BANK_ASSEMBLY_R8_M6_0/A44_CAP_CORE128_M6_R1_0/CAP_BOTTOM_001 GND nfet_03v3 ad=0 pd=0 as=0 ps=0 w=1.56u l=0.28u
X1871 VREFN A44_DCTRL_STRIP_W_R2_0/CTRL_OUT[3] A44_CDAC_CAP_BANK_ASSEMBLY_R8_M6_0/A44_CAP_CORE128_M6_R1_0/CAP_BOTTOM_001 GND nfet_03v3 ad=0 pd=0 as=0 ps=0 w=1.56u l=0.28u
X1872 VREFN A44_DCTRL_STRIP_W_R2_0/CTRL_OUT[3] A44_CDAC_CAP_BANK_ASSEMBLY_R8_M6_0/A44_CAP_CORE128_M6_R1_0/CAP_BOTTOM_001 GND nfet_03v3 ad=0 pd=0 as=0 ps=0 w=1.56u l=0.28u
X1873 VREFN A44_DCTRL_STRIP_W_R2_0/CTRL_OUT[3] A44_CDAC_CAP_BANK_ASSEMBLY_R8_M6_0/A44_CAP_CORE128_M6_R1_0/CAP_BOTTOM_001 GND nfet_03v3 ad=0 pd=0 as=0 ps=0 w=1.56u l=0.28u
X1874 VREFP A44_DCTRL_STRIP_W_R2_0/CTRL_OUT[7] A44_CDAC_CAP_BANK_ASSEMBLY_R8_M6_0/A44_CAP_CORE128_M6_R1_0/CAP_BOTTOM_025 VDD pfet_03v3 ad=0 pd=0 as=16.6842p ps=77.76u w=1.56u l=0.28u
X1875 VREFP A44_DCTRL_STRIP_W_R2_0/CTRL_OUT[7] A44_CDAC_CAP_BANK_ASSEMBLY_R8_M6_0/A44_CAP_CORE128_M6_R1_0/CAP_BOTTOM_025 VDD pfet_03v3 ad=0 pd=0 as=0 ps=0 w=1.56u l=0.28u
X1876 VREFP A44_DCTRL_STRIP_W_R2_0/CTRL_OUT[7] A44_CDAC_CAP_BANK_ASSEMBLY_R8_M6_0/A44_CAP_CORE128_M6_R1_0/CAP_BOTTOM_025 VDD pfet_03v3 ad=0 pd=0 as=0 ps=0 w=1.56u l=0.28u
X1877 VREFP A44_DCTRL_STRIP_W_R2_0/CTRL_OUT[7] A44_CDAC_CAP_BANK_ASSEMBLY_R8_M6_0/A44_CAP_CORE128_M6_R1_0/CAP_BOTTOM_025 VDD pfet_03v3 ad=0 pd=0 as=0 ps=0 w=1.56u l=0.28u
X1878 VREFP A44_DCTRL_STRIP_W_R2_0/CTRL_OUT[7] A44_CDAC_CAP_BANK_ASSEMBLY_R8_M6_0/A44_CAP_CORE128_M6_R1_0/CAP_BOTTOM_025 VDD pfet_03v3 ad=0 pd=0 as=0 ps=0 w=1.56u l=0.28u
X1879 VREFP A44_DCTRL_STRIP_W_R2_0/CTRL_OUT[7] A44_CDAC_CAP_BANK_ASSEMBLY_R8_M6_0/A44_CAP_CORE128_M6_R1_0/CAP_BOTTOM_025 VDD pfet_03v3 ad=0 pd=0 as=0 ps=0 w=1.56u l=0.28u
X1880 VREFP A44_DCTRL_STRIP_W_R2_0/CTRL_OUT[7] A44_CDAC_CAP_BANK_ASSEMBLY_R8_M6_0/A44_CAP_CORE128_M6_R1_0/CAP_BOTTOM_025 VDD pfet_03v3 ad=0 pd=0 as=0 ps=0 w=1.56u l=0.28u
X1881 VREFP A44_DCTRL_STRIP_W_R2_0/CTRL_OUT[7] A44_CDAC_CAP_BANK_ASSEMBLY_R8_M6_0/A44_CAP_CORE128_M6_R1_0/CAP_BOTTOM_025 VDD pfet_03v3 ad=0 pd=0 as=0 ps=0 w=1.56u l=0.28u
X1882 VREFP A44_DCTRL_STRIP_W_R2_0/CTRL_OUT[7] A44_CDAC_CAP_BANK_ASSEMBLY_R8_M6_0/A44_CAP_CORE128_M6_R1_0/CAP_BOTTOM_025 VDD pfet_03v3 ad=0 pd=0 as=0 ps=0 w=1.56u l=0.28u
X1883 VREFP A44_DCTRL_STRIP_W_R2_0/CTRL_OUT[7] A44_CDAC_CAP_BANK_ASSEMBLY_R8_M6_0/A44_CAP_CORE128_M6_R1_0/CAP_BOTTOM_025 VDD pfet_03v3 ad=0 pd=0 as=0 ps=0 w=1.56u l=0.28u
X1884 VREFP A44_DCTRL_STRIP_W_R2_0/CTRL_OUT[7] A44_CDAC_CAP_BANK_ASSEMBLY_R8_M6_0/A44_CAP_CORE128_M6_R1_0/CAP_BOTTOM_025 VDD pfet_03v3 ad=0 pd=0 as=0 ps=0 w=1.56u l=0.28u
X1885 VREFP A44_DCTRL_STRIP_W_R2_0/CTRL_OUT[7] A44_CDAC_CAP_BANK_ASSEMBLY_R8_M6_0/A44_CAP_CORE128_M6_R1_0/CAP_BOTTOM_025 VDD pfet_03v3 ad=0 pd=0 as=0 ps=0 w=1.56u l=0.28u
X1886 VREFP A44_DCTRL_STRIP_W_R2_0/CTRL_OUT[7] A44_CDAC_CAP_BANK_ASSEMBLY_R8_M6_0/A44_CAP_CORE128_M6_R1_0/CAP_BOTTOM_025 VDD pfet_03v3 ad=0 pd=0 as=0 ps=0 w=1.56u l=0.28u
X1887 VREFP A44_DCTRL_STRIP_W_R2_0/CTRL_OUT[7] A44_CDAC_CAP_BANK_ASSEMBLY_R8_M6_0/A44_CAP_CORE128_M6_R1_0/CAP_BOTTOM_025 VDD pfet_03v3 ad=0 pd=0 as=0 ps=0 w=1.56u l=0.28u
X1888 VREFP A44_DCTRL_STRIP_W_R2_0/CTRL_OUT[7] A44_CDAC_CAP_BANK_ASSEMBLY_R8_M6_0/A44_CAP_CORE128_M6_R1_0/CAP_BOTTOM_025 VDD pfet_03v3 ad=0 pd=0 as=0 ps=0 w=1.56u l=0.28u
X1889 VREFP A44_DCTRL_STRIP_W_R2_0/CTRL_OUT[7] A44_CDAC_CAP_BANK_ASSEMBLY_R8_M6_0/A44_CAP_CORE128_M6_R1_0/CAP_BOTTOM_025 VDD pfet_03v3 ad=0 pd=0 as=0 ps=0 w=1.56u l=0.28u
X1890 VREFP A44_DCTRL_STRIP_W_R2_0/CTRL_OUT[7] A44_CDAC_CAP_BANK_ASSEMBLY_R8_M6_0/A44_CAP_CORE128_M6_R1_0/CAP_BOTTOM_025 VDD pfet_03v3 ad=0 pd=0 as=0 ps=0 w=1.56u l=0.28u
X1891 VREFP A44_DCTRL_STRIP_W_R2_0/CTRL_OUT[7] A44_CDAC_CAP_BANK_ASSEMBLY_R8_M6_0/A44_CAP_CORE128_M6_R1_0/CAP_BOTTOM_025 VDD pfet_03v3 ad=0 pd=0 as=0 ps=0 w=1.56u l=0.28u
X1892 VREFN A44_DCTRL_STRIP_W_R2_0/CTRL_OUT[7] A44_CDAC_CAP_BANK_ASSEMBLY_R8_M6_0/A44_CAP_CORE128_M6_R1_0/CAP_BOTTOM_025 GND nfet_03v3 ad=0 pd=0 as=16.6842p ps=77.76u w=1.56u l=0.28u
X1893 VREFN A44_DCTRL_STRIP_W_R2_0/CTRL_OUT[7] A44_CDAC_CAP_BANK_ASSEMBLY_R8_M6_0/A44_CAP_CORE128_M6_R1_0/CAP_BOTTOM_025 GND nfet_03v3 ad=0 pd=0 as=0 ps=0 w=1.56u l=0.28u
X1894 VREFN A44_DCTRL_STRIP_W_R2_0/CTRL_OUT[7] A44_CDAC_CAP_BANK_ASSEMBLY_R8_M6_0/A44_CAP_CORE128_M6_R1_0/CAP_BOTTOM_025 GND nfet_03v3 ad=0 pd=0 as=0 ps=0 w=1.56u l=0.28u
X1895 VREFN A44_DCTRL_STRIP_W_R2_0/CTRL_OUT[7] A44_CDAC_CAP_BANK_ASSEMBLY_R8_M6_0/A44_CAP_CORE128_M6_R1_0/CAP_BOTTOM_025 GND nfet_03v3 ad=0 pd=0 as=0 ps=0 w=1.56u l=0.28u
X1896 VREFN A44_DCTRL_STRIP_W_R2_0/CTRL_OUT[7] A44_CDAC_CAP_BANK_ASSEMBLY_R8_M6_0/A44_CAP_CORE128_M6_R1_0/CAP_BOTTOM_025 GND nfet_03v3 ad=0 pd=0 as=0 ps=0 w=1.56u l=0.28u
X1897 VREFN A44_DCTRL_STRIP_W_R2_0/CTRL_OUT[7] A44_CDAC_CAP_BANK_ASSEMBLY_R8_M6_0/A44_CAP_CORE128_M6_R1_0/CAP_BOTTOM_025 GND nfet_03v3 ad=0 pd=0 as=0 ps=0 w=1.56u l=0.28u
X1898 VREFN A44_DCTRL_STRIP_W_R2_0/CTRL_OUT[7] A44_CDAC_CAP_BANK_ASSEMBLY_R8_M6_0/A44_CAP_CORE128_M6_R1_0/CAP_BOTTOM_025 GND nfet_03v3 ad=0 pd=0 as=0 ps=0 w=1.56u l=0.28u
X1899 VREFN A44_DCTRL_STRIP_W_R2_0/CTRL_OUT[7] A44_CDAC_CAP_BANK_ASSEMBLY_R8_M6_0/A44_CAP_CORE128_M6_R1_0/CAP_BOTTOM_025 GND nfet_03v3 ad=0 pd=0 as=0 ps=0 w=1.56u l=0.28u
X1900 VREFN A44_DCTRL_STRIP_W_R2_0/CTRL_OUT[7] A44_CDAC_CAP_BANK_ASSEMBLY_R8_M6_0/A44_CAP_CORE128_M6_R1_0/CAP_BOTTOM_025 GND nfet_03v3 ad=0 pd=0 as=0 ps=0 w=1.56u l=0.28u
X1901 VREFN A44_DCTRL_STRIP_W_R2_0/CTRL_OUT[7] A44_CDAC_CAP_BANK_ASSEMBLY_R8_M6_0/A44_CAP_CORE128_M6_R1_0/CAP_BOTTOM_025 GND nfet_03v3 ad=0 pd=0 as=0 ps=0 w=1.56u l=0.28u
X1902 VREFN A44_DCTRL_STRIP_W_R2_0/CTRL_OUT[7] A44_CDAC_CAP_BANK_ASSEMBLY_R8_M6_0/A44_CAP_CORE128_M6_R1_0/CAP_BOTTOM_025 GND nfet_03v3 ad=0 pd=0 as=0 ps=0 w=1.56u l=0.28u
X1903 VREFN A44_DCTRL_STRIP_W_R2_0/CTRL_OUT[7] A44_CDAC_CAP_BANK_ASSEMBLY_R8_M6_0/A44_CAP_CORE128_M6_R1_0/CAP_BOTTOM_025 GND nfet_03v3 ad=0 pd=0 as=0 ps=0 w=1.56u l=0.28u
X1904 VREFN A44_DCTRL_STRIP_W_R2_0/CTRL_OUT[7] A44_CDAC_CAP_BANK_ASSEMBLY_R8_M6_0/A44_CAP_CORE128_M6_R1_0/CAP_BOTTOM_025 GND nfet_03v3 ad=0 pd=0 as=0 ps=0 w=1.56u l=0.28u
X1905 VREFN A44_DCTRL_STRIP_W_R2_0/CTRL_OUT[7] A44_CDAC_CAP_BANK_ASSEMBLY_R8_M6_0/A44_CAP_CORE128_M6_R1_0/CAP_BOTTOM_025 GND nfet_03v3 ad=0 pd=0 as=0 ps=0 w=1.56u l=0.28u
X1906 VREFN A44_DCTRL_STRIP_W_R2_0/CTRL_OUT[7] A44_CDAC_CAP_BANK_ASSEMBLY_R8_M6_0/A44_CAP_CORE128_M6_R1_0/CAP_BOTTOM_025 GND nfet_03v3 ad=0 pd=0 as=0 ps=0 w=1.56u l=0.28u
X1907 VREFN A44_DCTRL_STRIP_W_R2_0/CTRL_OUT[7] A44_CDAC_CAP_BANK_ASSEMBLY_R8_M6_0/A44_CAP_CORE128_M6_R1_0/CAP_BOTTOM_025 GND nfet_03v3 ad=0 pd=0 as=0 ps=0 w=1.56u l=0.28u
X1908 VREFN A44_DCTRL_STRIP_W_R2_0/CTRL_OUT[7] A44_CDAC_CAP_BANK_ASSEMBLY_R8_M6_0/A44_CAP_CORE128_M6_R1_0/CAP_BOTTOM_025 GND nfet_03v3 ad=0 pd=0 as=0 ps=0 w=1.56u l=0.28u
X1909 VREFN A44_DCTRL_STRIP_W_R2_0/CTRL_OUT[7] A44_CDAC_CAP_BANK_ASSEMBLY_R8_M6_0/A44_CAP_CORE128_M6_R1_0/CAP_BOTTOM_025 GND nfet_03v3 ad=0 pd=0 as=0 ps=0 w=1.56u l=0.28u
X1910 VREFP A44_DCTRL_STRIP_W_R2_0/CTRL_OUT[4] A44_CDAC_CAP_BANK_ASSEMBLY_R8_M6_0/A44_CAP_CORE128_M6_R1_0/CAP_BOTTOM_051 VDD pfet_03v3 ad=0 pd=0 as=16.6842p ps=77.76u w=1.56u l=0.28u
X1911 VREFP A44_DCTRL_STRIP_W_R2_0/CTRL_OUT[4] A44_CDAC_CAP_BANK_ASSEMBLY_R8_M6_0/A44_CAP_CORE128_M6_R1_0/CAP_BOTTOM_051 VDD pfet_03v3 ad=0 pd=0 as=0 ps=0 w=1.56u l=0.28u
X1912 VREFP A44_DCTRL_STRIP_W_R2_0/CTRL_OUT[4] A44_CDAC_CAP_BANK_ASSEMBLY_R8_M6_0/A44_CAP_CORE128_M6_R1_0/CAP_BOTTOM_051 VDD pfet_03v3 ad=0 pd=0 as=0 ps=0 w=1.56u l=0.28u
X1913 VREFP A44_DCTRL_STRIP_W_R2_0/CTRL_OUT[4] A44_CDAC_CAP_BANK_ASSEMBLY_R8_M6_0/A44_CAP_CORE128_M6_R1_0/CAP_BOTTOM_051 VDD pfet_03v3 ad=0 pd=0 as=0 ps=0 w=1.56u l=0.28u
X1914 VREFP A44_DCTRL_STRIP_W_R2_0/CTRL_OUT[4] A44_CDAC_CAP_BANK_ASSEMBLY_R8_M6_0/A44_CAP_CORE128_M6_R1_0/CAP_BOTTOM_051 VDD pfet_03v3 ad=0 pd=0 as=0 ps=0 w=1.56u l=0.28u
X1915 VREFP A44_DCTRL_STRIP_W_R2_0/CTRL_OUT[4] A44_CDAC_CAP_BANK_ASSEMBLY_R8_M6_0/A44_CAP_CORE128_M6_R1_0/CAP_BOTTOM_051 VDD pfet_03v3 ad=0 pd=0 as=0 ps=0 w=1.56u l=0.28u
X1916 VREFP A44_DCTRL_STRIP_W_R2_0/CTRL_OUT[4] A44_CDAC_CAP_BANK_ASSEMBLY_R8_M6_0/A44_CAP_CORE128_M6_R1_0/CAP_BOTTOM_051 VDD pfet_03v3 ad=0 pd=0 as=0 ps=0 w=1.56u l=0.28u
X1917 VREFP A44_DCTRL_STRIP_W_R2_0/CTRL_OUT[4] A44_CDAC_CAP_BANK_ASSEMBLY_R8_M6_0/A44_CAP_CORE128_M6_R1_0/CAP_BOTTOM_051 VDD pfet_03v3 ad=0 pd=0 as=0 ps=0 w=1.56u l=0.28u
X1918 VREFP A44_DCTRL_STRIP_W_R2_0/CTRL_OUT[4] A44_CDAC_CAP_BANK_ASSEMBLY_R8_M6_0/A44_CAP_CORE128_M6_R1_0/CAP_BOTTOM_051 VDD pfet_03v3 ad=0 pd=0 as=0 ps=0 w=1.56u l=0.28u
X1919 VREFP A44_DCTRL_STRIP_W_R2_0/CTRL_OUT[4] A44_CDAC_CAP_BANK_ASSEMBLY_R8_M6_0/A44_CAP_CORE128_M6_R1_0/CAP_BOTTOM_051 VDD pfet_03v3 ad=0 pd=0 as=0 ps=0 w=1.56u l=0.28u
X1920 VREFP A44_DCTRL_STRIP_W_R2_0/CTRL_OUT[4] A44_CDAC_CAP_BANK_ASSEMBLY_R8_M6_0/A44_CAP_CORE128_M6_R1_0/CAP_BOTTOM_051 VDD pfet_03v3 ad=0 pd=0 as=0 ps=0 w=1.56u l=0.28u
X1921 VREFP A44_DCTRL_STRIP_W_R2_0/CTRL_OUT[4] A44_CDAC_CAP_BANK_ASSEMBLY_R8_M6_0/A44_CAP_CORE128_M6_R1_0/CAP_BOTTOM_051 VDD pfet_03v3 ad=0 pd=0 as=0 ps=0 w=1.56u l=0.28u
X1922 VREFP A44_DCTRL_STRIP_W_R2_0/CTRL_OUT[4] A44_CDAC_CAP_BANK_ASSEMBLY_R8_M6_0/A44_CAP_CORE128_M6_R1_0/CAP_BOTTOM_051 VDD pfet_03v3 ad=0 pd=0 as=0 ps=0 w=1.56u l=0.28u
X1923 VREFP A44_DCTRL_STRIP_W_R2_0/CTRL_OUT[4] A44_CDAC_CAP_BANK_ASSEMBLY_R8_M6_0/A44_CAP_CORE128_M6_R1_0/CAP_BOTTOM_051 VDD pfet_03v3 ad=0 pd=0 as=0 ps=0 w=1.56u l=0.28u
X1924 VREFP A44_DCTRL_STRIP_W_R2_0/CTRL_OUT[4] A44_CDAC_CAP_BANK_ASSEMBLY_R8_M6_0/A44_CAP_CORE128_M6_R1_0/CAP_BOTTOM_051 VDD pfet_03v3 ad=0 pd=0 as=0 ps=0 w=1.56u l=0.28u
X1925 VREFP A44_DCTRL_STRIP_W_R2_0/CTRL_OUT[4] A44_CDAC_CAP_BANK_ASSEMBLY_R8_M6_0/A44_CAP_CORE128_M6_R1_0/CAP_BOTTOM_051 VDD pfet_03v3 ad=0 pd=0 as=0 ps=0 w=1.56u l=0.28u
X1926 VREFP A44_DCTRL_STRIP_W_R2_0/CTRL_OUT[4] A44_CDAC_CAP_BANK_ASSEMBLY_R8_M6_0/A44_CAP_CORE128_M6_R1_0/CAP_BOTTOM_051 VDD pfet_03v3 ad=0 pd=0 as=0 ps=0 w=1.56u l=0.28u
X1927 VREFP A44_DCTRL_STRIP_W_R2_0/CTRL_OUT[4] A44_CDAC_CAP_BANK_ASSEMBLY_R8_M6_0/A44_CAP_CORE128_M6_R1_0/CAP_BOTTOM_051 VDD pfet_03v3 ad=0 pd=0 as=0 ps=0 w=1.56u l=0.28u
X1928 VREFN A44_DCTRL_STRIP_W_R2_0/CTRL_OUT[4] A44_CDAC_CAP_BANK_ASSEMBLY_R8_M6_0/A44_CAP_CORE128_M6_R1_0/CAP_BOTTOM_051 GND nfet_03v3 ad=0 pd=0 as=16.6842p ps=77.76u w=1.56u l=0.28u
X1929 VREFN A44_DCTRL_STRIP_W_R2_0/CTRL_OUT[4] A44_CDAC_CAP_BANK_ASSEMBLY_R8_M6_0/A44_CAP_CORE128_M6_R1_0/CAP_BOTTOM_051 GND nfet_03v3 ad=0 pd=0 as=0 ps=0 w=1.56u l=0.28u
X1930 VREFN A44_DCTRL_STRIP_W_R2_0/CTRL_OUT[4] A44_CDAC_CAP_BANK_ASSEMBLY_R8_M6_0/A44_CAP_CORE128_M6_R1_0/CAP_BOTTOM_051 GND nfet_03v3 ad=0 pd=0 as=0 ps=0 w=1.56u l=0.28u
X1931 VREFN A44_DCTRL_STRIP_W_R2_0/CTRL_OUT[4] A44_CDAC_CAP_BANK_ASSEMBLY_R8_M6_0/A44_CAP_CORE128_M6_R1_0/CAP_BOTTOM_051 GND nfet_03v3 ad=0 pd=0 as=0 ps=0 w=1.56u l=0.28u
X1932 VREFN A44_DCTRL_STRIP_W_R2_0/CTRL_OUT[4] A44_CDAC_CAP_BANK_ASSEMBLY_R8_M6_0/A44_CAP_CORE128_M6_R1_0/CAP_BOTTOM_051 GND nfet_03v3 ad=0 pd=0 as=0 ps=0 w=1.56u l=0.28u
X1933 VREFN A44_DCTRL_STRIP_W_R2_0/CTRL_OUT[4] A44_CDAC_CAP_BANK_ASSEMBLY_R8_M6_0/A44_CAP_CORE128_M6_R1_0/CAP_BOTTOM_051 GND nfet_03v3 ad=0 pd=0 as=0 ps=0 w=1.56u l=0.28u
X1934 VREFN A44_DCTRL_STRIP_W_R2_0/CTRL_OUT[4] A44_CDAC_CAP_BANK_ASSEMBLY_R8_M6_0/A44_CAP_CORE128_M6_R1_0/CAP_BOTTOM_051 GND nfet_03v3 ad=0 pd=0 as=0 ps=0 w=1.56u l=0.28u
X1935 VREFN A44_DCTRL_STRIP_W_R2_0/CTRL_OUT[4] A44_CDAC_CAP_BANK_ASSEMBLY_R8_M6_0/A44_CAP_CORE128_M6_R1_0/CAP_BOTTOM_051 GND nfet_03v3 ad=0 pd=0 as=0 ps=0 w=1.56u l=0.28u
X1936 VREFN A44_DCTRL_STRIP_W_R2_0/CTRL_OUT[4] A44_CDAC_CAP_BANK_ASSEMBLY_R8_M6_0/A44_CAP_CORE128_M6_R1_0/CAP_BOTTOM_051 GND nfet_03v3 ad=0 pd=0 as=0 ps=0 w=1.56u l=0.28u
X1937 VREFN A44_DCTRL_STRIP_W_R2_0/CTRL_OUT[4] A44_CDAC_CAP_BANK_ASSEMBLY_R8_M6_0/A44_CAP_CORE128_M6_R1_0/CAP_BOTTOM_051 GND nfet_03v3 ad=0 pd=0 as=0 ps=0 w=1.56u l=0.28u
X1938 VREFN A44_DCTRL_STRIP_W_R2_0/CTRL_OUT[4] A44_CDAC_CAP_BANK_ASSEMBLY_R8_M6_0/A44_CAP_CORE128_M6_R1_0/CAP_BOTTOM_051 GND nfet_03v3 ad=0 pd=0 as=0 ps=0 w=1.56u l=0.28u
X1939 VREFN A44_DCTRL_STRIP_W_R2_0/CTRL_OUT[4] A44_CDAC_CAP_BANK_ASSEMBLY_R8_M6_0/A44_CAP_CORE128_M6_R1_0/CAP_BOTTOM_051 GND nfet_03v3 ad=0 pd=0 as=0 ps=0 w=1.56u l=0.28u
X1940 VREFN A44_DCTRL_STRIP_W_R2_0/CTRL_OUT[4] A44_CDAC_CAP_BANK_ASSEMBLY_R8_M6_0/A44_CAP_CORE128_M6_R1_0/CAP_BOTTOM_051 GND nfet_03v3 ad=0 pd=0 as=0 ps=0 w=1.56u l=0.28u
X1941 VREFN A44_DCTRL_STRIP_W_R2_0/CTRL_OUT[4] A44_CDAC_CAP_BANK_ASSEMBLY_R8_M6_0/A44_CAP_CORE128_M6_R1_0/CAP_BOTTOM_051 GND nfet_03v3 ad=0 pd=0 as=0 ps=0 w=1.56u l=0.28u
X1942 VREFN A44_DCTRL_STRIP_W_R2_0/CTRL_OUT[4] A44_CDAC_CAP_BANK_ASSEMBLY_R8_M6_0/A44_CAP_CORE128_M6_R1_0/CAP_BOTTOM_051 GND nfet_03v3 ad=0 pd=0 as=0 ps=0 w=1.56u l=0.28u
X1943 VREFN A44_DCTRL_STRIP_W_R2_0/CTRL_OUT[4] A44_CDAC_CAP_BANK_ASSEMBLY_R8_M6_0/A44_CAP_CORE128_M6_R1_0/CAP_BOTTOM_051 GND nfet_03v3 ad=0 pd=0 as=0 ps=0 w=1.56u l=0.28u
X1944 VREFN A44_DCTRL_STRIP_W_R2_0/CTRL_OUT[4] A44_CDAC_CAP_BANK_ASSEMBLY_R8_M6_0/A44_CAP_CORE128_M6_R1_0/CAP_BOTTOM_051 GND nfet_03v3 ad=0 pd=0 as=0 ps=0 w=1.56u l=0.28u
X1945 VREFN A44_DCTRL_STRIP_W_R2_0/CTRL_OUT[4] A44_CDAC_CAP_BANK_ASSEMBLY_R8_M6_0/A44_CAP_CORE128_M6_R1_0/CAP_BOTTOM_051 GND nfet_03v3 ad=0 pd=0 as=0 ps=0 w=1.56u l=0.28u
X1946 VREFP A44_DCTRL_STRIP_W_R2_0/CTRL_OUT[5] A44_CDAC_CAP_BANK_ASSEMBLY_R8_M6_0/A44_CAP_CORE128_M6_R1_0/CAP_BOTTOM_009 VDD pfet_03v3 ad=0 pd=0 as=16.6842p ps=77.76u w=1.56u l=0.28u
X1947 VREFP A44_DCTRL_STRIP_W_R2_0/CTRL_OUT[5] A44_CDAC_CAP_BANK_ASSEMBLY_R8_M6_0/A44_CAP_CORE128_M6_R1_0/CAP_BOTTOM_009 VDD pfet_03v3 ad=0 pd=0 as=0 ps=0 w=1.56u l=0.28u
X1948 VREFP A44_DCTRL_STRIP_W_R2_0/CTRL_OUT[5] A44_CDAC_CAP_BANK_ASSEMBLY_R8_M6_0/A44_CAP_CORE128_M6_R1_0/CAP_BOTTOM_009 VDD pfet_03v3 ad=0 pd=0 as=0 ps=0 w=1.56u l=0.28u
X1949 VREFP A44_DCTRL_STRIP_W_R2_0/CTRL_OUT[5] A44_CDAC_CAP_BANK_ASSEMBLY_R8_M6_0/A44_CAP_CORE128_M6_R1_0/CAP_BOTTOM_009 VDD pfet_03v3 ad=0 pd=0 as=0 ps=0 w=1.56u l=0.28u
X1950 VREFP A44_DCTRL_STRIP_W_R2_0/CTRL_OUT[5] A44_CDAC_CAP_BANK_ASSEMBLY_R8_M6_0/A44_CAP_CORE128_M6_R1_0/CAP_BOTTOM_009 VDD pfet_03v3 ad=0 pd=0 as=0 ps=0 w=1.56u l=0.28u
X1951 VREFP A44_DCTRL_STRIP_W_R2_0/CTRL_OUT[5] A44_CDAC_CAP_BANK_ASSEMBLY_R8_M6_0/A44_CAP_CORE128_M6_R1_0/CAP_BOTTOM_009 VDD pfet_03v3 ad=0 pd=0 as=0 ps=0 w=1.56u l=0.28u
X1952 VREFP A44_DCTRL_STRIP_W_R2_0/CTRL_OUT[5] A44_CDAC_CAP_BANK_ASSEMBLY_R8_M6_0/A44_CAP_CORE128_M6_R1_0/CAP_BOTTOM_009 VDD pfet_03v3 ad=0 pd=0 as=0 ps=0 w=1.56u l=0.28u
X1953 VREFP A44_DCTRL_STRIP_W_R2_0/CTRL_OUT[5] A44_CDAC_CAP_BANK_ASSEMBLY_R8_M6_0/A44_CAP_CORE128_M6_R1_0/CAP_BOTTOM_009 VDD pfet_03v3 ad=0 pd=0 as=0 ps=0 w=1.56u l=0.28u
X1954 VREFP A44_DCTRL_STRIP_W_R2_0/CTRL_OUT[5] A44_CDAC_CAP_BANK_ASSEMBLY_R8_M6_0/A44_CAP_CORE128_M6_R1_0/CAP_BOTTOM_009 VDD pfet_03v3 ad=0 pd=0 as=0 ps=0 w=1.56u l=0.28u
X1955 VREFP A44_DCTRL_STRIP_W_R2_0/CTRL_OUT[5] A44_CDAC_CAP_BANK_ASSEMBLY_R8_M6_0/A44_CAP_CORE128_M6_R1_0/CAP_BOTTOM_009 VDD pfet_03v3 ad=0 pd=0 as=0 ps=0 w=1.56u l=0.28u
X1956 VREFP A44_DCTRL_STRIP_W_R2_0/CTRL_OUT[5] A44_CDAC_CAP_BANK_ASSEMBLY_R8_M6_0/A44_CAP_CORE128_M6_R1_0/CAP_BOTTOM_009 VDD pfet_03v3 ad=0 pd=0 as=0 ps=0 w=1.56u l=0.28u
X1957 VREFP A44_DCTRL_STRIP_W_R2_0/CTRL_OUT[5] A44_CDAC_CAP_BANK_ASSEMBLY_R8_M6_0/A44_CAP_CORE128_M6_R1_0/CAP_BOTTOM_009 VDD pfet_03v3 ad=0 pd=0 as=0 ps=0 w=1.56u l=0.28u
X1958 VREFP A44_DCTRL_STRIP_W_R2_0/CTRL_OUT[5] A44_CDAC_CAP_BANK_ASSEMBLY_R8_M6_0/A44_CAP_CORE128_M6_R1_0/CAP_BOTTOM_009 VDD pfet_03v3 ad=0 pd=0 as=0 ps=0 w=1.56u l=0.28u
X1959 VREFP A44_DCTRL_STRIP_W_R2_0/CTRL_OUT[5] A44_CDAC_CAP_BANK_ASSEMBLY_R8_M6_0/A44_CAP_CORE128_M6_R1_0/CAP_BOTTOM_009 VDD pfet_03v3 ad=0 pd=0 as=0 ps=0 w=1.56u l=0.28u
X1960 VREFP A44_DCTRL_STRIP_W_R2_0/CTRL_OUT[5] A44_CDAC_CAP_BANK_ASSEMBLY_R8_M6_0/A44_CAP_CORE128_M6_R1_0/CAP_BOTTOM_009 VDD pfet_03v3 ad=0 pd=0 as=0 ps=0 w=1.56u l=0.28u
X1961 VREFP A44_DCTRL_STRIP_W_R2_0/CTRL_OUT[5] A44_CDAC_CAP_BANK_ASSEMBLY_R8_M6_0/A44_CAP_CORE128_M6_R1_0/CAP_BOTTOM_009 VDD pfet_03v3 ad=0 pd=0 as=0 ps=0 w=1.56u l=0.28u
X1962 VREFP A44_DCTRL_STRIP_W_R2_0/CTRL_OUT[5] A44_CDAC_CAP_BANK_ASSEMBLY_R8_M6_0/A44_CAP_CORE128_M6_R1_0/CAP_BOTTOM_009 VDD pfet_03v3 ad=0 pd=0 as=0 ps=0 w=1.56u l=0.28u
X1963 VREFP A44_DCTRL_STRIP_W_R2_0/CTRL_OUT[5] A44_CDAC_CAP_BANK_ASSEMBLY_R8_M6_0/A44_CAP_CORE128_M6_R1_0/CAP_BOTTOM_009 VDD pfet_03v3 ad=0 pd=0 as=0 ps=0 w=1.56u l=0.28u
X1964 VREFN A44_DCTRL_STRIP_W_R2_0/CTRL_OUT[5] A44_CDAC_CAP_BANK_ASSEMBLY_R8_M6_0/A44_CAP_CORE128_M6_R1_0/CAP_BOTTOM_009 GND nfet_03v3 ad=0 pd=0 as=16.6842p ps=77.76u w=1.56u l=0.28u
X1965 VREFN A44_DCTRL_STRIP_W_R2_0/CTRL_OUT[5] A44_CDAC_CAP_BANK_ASSEMBLY_R8_M6_0/A44_CAP_CORE128_M6_R1_0/CAP_BOTTOM_009 GND nfet_03v3 ad=0 pd=0 as=0 ps=0 w=1.56u l=0.28u
X1966 VREFN A44_DCTRL_STRIP_W_R2_0/CTRL_OUT[5] A44_CDAC_CAP_BANK_ASSEMBLY_R8_M6_0/A44_CAP_CORE128_M6_R1_0/CAP_BOTTOM_009 GND nfet_03v3 ad=0 pd=0 as=0 ps=0 w=1.56u l=0.28u
X1967 VREFN A44_DCTRL_STRIP_W_R2_0/CTRL_OUT[5] A44_CDAC_CAP_BANK_ASSEMBLY_R8_M6_0/A44_CAP_CORE128_M6_R1_0/CAP_BOTTOM_009 GND nfet_03v3 ad=0 pd=0 as=0 ps=0 w=1.56u l=0.28u
X1968 VREFN A44_DCTRL_STRIP_W_R2_0/CTRL_OUT[5] A44_CDAC_CAP_BANK_ASSEMBLY_R8_M6_0/A44_CAP_CORE128_M6_R1_0/CAP_BOTTOM_009 GND nfet_03v3 ad=0 pd=0 as=0 ps=0 w=1.56u l=0.28u
X1969 VREFN A44_DCTRL_STRIP_W_R2_0/CTRL_OUT[5] A44_CDAC_CAP_BANK_ASSEMBLY_R8_M6_0/A44_CAP_CORE128_M6_R1_0/CAP_BOTTOM_009 GND nfet_03v3 ad=0 pd=0 as=0 ps=0 w=1.56u l=0.28u
X1970 VREFN A44_DCTRL_STRIP_W_R2_0/CTRL_OUT[5] A44_CDAC_CAP_BANK_ASSEMBLY_R8_M6_0/A44_CAP_CORE128_M6_R1_0/CAP_BOTTOM_009 GND nfet_03v3 ad=0 pd=0 as=0 ps=0 w=1.56u l=0.28u
X1971 VREFN A44_DCTRL_STRIP_W_R2_0/CTRL_OUT[5] A44_CDAC_CAP_BANK_ASSEMBLY_R8_M6_0/A44_CAP_CORE128_M6_R1_0/CAP_BOTTOM_009 GND nfet_03v3 ad=0 pd=0 as=0 ps=0 w=1.56u l=0.28u
X1972 VREFN A44_DCTRL_STRIP_W_R2_0/CTRL_OUT[5] A44_CDAC_CAP_BANK_ASSEMBLY_R8_M6_0/A44_CAP_CORE128_M6_R1_0/CAP_BOTTOM_009 GND nfet_03v3 ad=0 pd=0 as=0 ps=0 w=1.56u l=0.28u
X1973 VREFN A44_DCTRL_STRIP_W_R2_0/CTRL_OUT[5] A44_CDAC_CAP_BANK_ASSEMBLY_R8_M6_0/A44_CAP_CORE128_M6_R1_0/CAP_BOTTOM_009 GND nfet_03v3 ad=0 pd=0 as=0 ps=0 w=1.56u l=0.28u
X1974 VREFN A44_DCTRL_STRIP_W_R2_0/CTRL_OUT[5] A44_CDAC_CAP_BANK_ASSEMBLY_R8_M6_0/A44_CAP_CORE128_M6_R1_0/CAP_BOTTOM_009 GND nfet_03v3 ad=0 pd=0 as=0 ps=0 w=1.56u l=0.28u
X1975 VREFN A44_DCTRL_STRIP_W_R2_0/CTRL_OUT[5] A44_CDAC_CAP_BANK_ASSEMBLY_R8_M6_0/A44_CAP_CORE128_M6_R1_0/CAP_BOTTOM_009 GND nfet_03v3 ad=0 pd=0 as=0 ps=0 w=1.56u l=0.28u
X1976 VREFN A44_DCTRL_STRIP_W_R2_0/CTRL_OUT[5] A44_CDAC_CAP_BANK_ASSEMBLY_R8_M6_0/A44_CAP_CORE128_M6_R1_0/CAP_BOTTOM_009 GND nfet_03v3 ad=0 pd=0 as=0 ps=0 w=1.56u l=0.28u
X1977 VREFN A44_DCTRL_STRIP_W_R2_0/CTRL_OUT[5] A44_CDAC_CAP_BANK_ASSEMBLY_R8_M6_0/A44_CAP_CORE128_M6_R1_0/CAP_BOTTOM_009 GND nfet_03v3 ad=0 pd=0 as=0 ps=0 w=1.56u l=0.28u
X1978 VREFN A44_DCTRL_STRIP_W_R2_0/CTRL_OUT[5] A44_CDAC_CAP_BANK_ASSEMBLY_R8_M6_0/A44_CAP_CORE128_M6_R1_0/CAP_BOTTOM_009 GND nfet_03v3 ad=0 pd=0 as=0 ps=0 w=1.56u l=0.28u
X1979 VREFN A44_DCTRL_STRIP_W_R2_0/CTRL_OUT[5] A44_CDAC_CAP_BANK_ASSEMBLY_R8_M6_0/A44_CAP_CORE128_M6_R1_0/CAP_BOTTOM_009 GND nfet_03v3 ad=0 pd=0 as=0 ps=0 w=1.56u l=0.28u
X1980 VREFN A44_DCTRL_STRIP_W_R2_0/CTRL_OUT[5] A44_CDAC_CAP_BANK_ASSEMBLY_R8_M6_0/A44_CAP_CORE128_M6_R1_0/CAP_BOTTOM_009 GND nfet_03v3 ad=0 pd=0 as=0 ps=0 w=1.56u l=0.28u
X1981 VREFN A44_DCTRL_STRIP_W_R2_0/CTRL_OUT[5] A44_CDAC_CAP_BANK_ASSEMBLY_R8_M6_0/A44_CAP_CORE128_M6_R1_0/CAP_BOTTOM_009 GND nfet_03v3 ad=0 pd=0 as=0 ps=0 w=1.56u l=0.28u
X1982 VREFP A44_DCTRL_STRIP_W_R2_0/CTRL_OUT[7] A44_CDAC_CAP_BANK_ASSEMBLY_R8_M6_0/A44_CAP_CORE128_M6_R1_0/CAP_BOTTOM_035 VDD pfet_03v3 ad=0 pd=0 as=16.6842p ps=77.76u w=1.56u l=0.28u
X1983 VREFP A44_DCTRL_STRIP_W_R2_0/CTRL_OUT[7] A44_CDAC_CAP_BANK_ASSEMBLY_R8_M6_0/A44_CAP_CORE128_M6_R1_0/CAP_BOTTOM_035 VDD pfet_03v3 ad=0 pd=0 as=0 ps=0 w=1.56u l=0.28u
X1984 VREFP A44_DCTRL_STRIP_W_R2_0/CTRL_OUT[7] A44_CDAC_CAP_BANK_ASSEMBLY_R8_M6_0/A44_CAP_CORE128_M6_R1_0/CAP_BOTTOM_035 VDD pfet_03v3 ad=0 pd=0 as=0 ps=0 w=1.56u l=0.28u
X1985 VREFP A44_DCTRL_STRIP_W_R2_0/CTRL_OUT[7] A44_CDAC_CAP_BANK_ASSEMBLY_R8_M6_0/A44_CAP_CORE128_M6_R1_0/CAP_BOTTOM_035 VDD pfet_03v3 ad=0 pd=0 as=0 ps=0 w=1.56u l=0.28u
X1986 VREFP A44_DCTRL_STRIP_W_R2_0/CTRL_OUT[7] A44_CDAC_CAP_BANK_ASSEMBLY_R8_M6_0/A44_CAP_CORE128_M6_R1_0/CAP_BOTTOM_035 VDD pfet_03v3 ad=0 pd=0 as=0 ps=0 w=1.56u l=0.28u
X1987 VREFP A44_DCTRL_STRIP_W_R2_0/CTRL_OUT[7] A44_CDAC_CAP_BANK_ASSEMBLY_R8_M6_0/A44_CAP_CORE128_M6_R1_0/CAP_BOTTOM_035 VDD pfet_03v3 ad=0 pd=0 as=0 ps=0 w=1.56u l=0.28u
X1988 VREFP A44_DCTRL_STRIP_W_R2_0/CTRL_OUT[7] A44_CDAC_CAP_BANK_ASSEMBLY_R8_M6_0/A44_CAP_CORE128_M6_R1_0/CAP_BOTTOM_035 VDD pfet_03v3 ad=0 pd=0 as=0 ps=0 w=1.56u l=0.28u
X1989 VREFP A44_DCTRL_STRIP_W_R2_0/CTRL_OUT[7] A44_CDAC_CAP_BANK_ASSEMBLY_R8_M6_0/A44_CAP_CORE128_M6_R1_0/CAP_BOTTOM_035 VDD pfet_03v3 ad=0 pd=0 as=0 ps=0 w=1.56u l=0.28u
X1990 VREFP A44_DCTRL_STRIP_W_R2_0/CTRL_OUT[7] A44_CDAC_CAP_BANK_ASSEMBLY_R8_M6_0/A44_CAP_CORE128_M6_R1_0/CAP_BOTTOM_035 VDD pfet_03v3 ad=0 pd=0 as=0 ps=0 w=1.56u l=0.28u
X1991 VREFP A44_DCTRL_STRIP_W_R2_0/CTRL_OUT[7] A44_CDAC_CAP_BANK_ASSEMBLY_R8_M6_0/A44_CAP_CORE128_M6_R1_0/CAP_BOTTOM_035 VDD pfet_03v3 ad=0 pd=0 as=0 ps=0 w=1.56u l=0.28u
X1992 VREFP A44_DCTRL_STRIP_W_R2_0/CTRL_OUT[7] A44_CDAC_CAP_BANK_ASSEMBLY_R8_M6_0/A44_CAP_CORE128_M6_R1_0/CAP_BOTTOM_035 VDD pfet_03v3 ad=0 pd=0 as=0 ps=0 w=1.56u l=0.28u
X1993 VREFP A44_DCTRL_STRIP_W_R2_0/CTRL_OUT[7] A44_CDAC_CAP_BANK_ASSEMBLY_R8_M6_0/A44_CAP_CORE128_M6_R1_0/CAP_BOTTOM_035 VDD pfet_03v3 ad=0 pd=0 as=0 ps=0 w=1.56u l=0.28u
X1994 VREFP A44_DCTRL_STRIP_W_R2_0/CTRL_OUT[7] A44_CDAC_CAP_BANK_ASSEMBLY_R8_M6_0/A44_CAP_CORE128_M6_R1_0/CAP_BOTTOM_035 VDD pfet_03v3 ad=0 pd=0 as=0 ps=0 w=1.56u l=0.28u
X1995 VREFP A44_DCTRL_STRIP_W_R2_0/CTRL_OUT[7] A44_CDAC_CAP_BANK_ASSEMBLY_R8_M6_0/A44_CAP_CORE128_M6_R1_0/CAP_BOTTOM_035 VDD pfet_03v3 ad=0 pd=0 as=0 ps=0 w=1.56u l=0.28u
X1996 VREFP A44_DCTRL_STRIP_W_R2_0/CTRL_OUT[7] A44_CDAC_CAP_BANK_ASSEMBLY_R8_M6_0/A44_CAP_CORE128_M6_R1_0/CAP_BOTTOM_035 VDD pfet_03v3 ad=0 pd=0 as=0 ps=0 w=1.56u l=0.28u
X1997 VREFP A44_DCTRL_STRIP_W_R2_0/CTRL_OUT[7] A44_CDAC_CAP_BANK_ASSEMBLY_R8_M6_0/A44_CAP_CORE128_M6_R1_0/CAP_BOTTOM_035 VDD pfet_03v3 ad=0 pd=0 as=0 ps=0 w=1.56u l=0.28u
X1998 VREFP A44_DCTRL_STRIP_W_R2_0/CTRL_OUT[7] A44_CDAC_CAP_BANK_ASSEMBLY_R8_M6_0/A44_CAP_CORE128_M6_R1_0/CAP_BOTTOM_035 VDD pfet_03v3 ad=0 pd=0 as=0 ps=0 w=1.56u l=0.28u
X1999 VREFP A44_DCTRL_STRIP_W_R2_0/CTRL_OUT[7] A44_CDAC_CAP_BANK_ASSEMBLY_R8_M6_0/A44_CAP_CORE128_M6_R1_0/CAP_BOTTOM_035 VDD pfet_03v3 ad=0 pd=0 as=0 ps=0 w=1.56u l=0.28u
X2000 VREFN A44_DCTRL_STRIP_W_R2_0/CTRL_OUT[7] A44_CDAC_CAP_BANK_ASSEMBLY_R8_M6_0/A44_CAP_CORE128_M6_R1_0/CAP_BOTTOM_035 GND nfet_03v3 ad=0 pd=0 as=16.6842p ps=77.76u w=1.56u l=0.28u
X2001 VREFN A44_DCTRL_STRIP_W_R2_0/CTRL_OUT[7] A44_CDAC_CAP_BANK_ASSEMBLY_R8_M6_0/A44_CAP_CORE128_M6_R1_0/CAP_BOTTOM_035 GND nfet_03v3 ad=0 pd=0 as=0 ps=0 w=1.56u l=0.28u
X2002 VREFN A44_DCTRL_STRIP_W_R2_0/CTRL_OUT[7] A44_CDAC_CAP_BANK_ASSEMBLY_R8_M6_0/A44_CAP_CORE128_M6_R1_0/CAP_BOTTOM_035 GND nfet_03v3 ad=0 pd=0 as=0 ps=0 w=1.56u l=0.28u
X2003 VREFN A44_DCTRL_STRIP_W_R2_0/CTRL_OUT[7] A44_CDAC_CAP_BANK_ASSEMBLY_R8_M6_0/A44_CAP_CORE128_M6_R1_0/CAP_BOTTOM_035 GND nfet_03v3 ad=0 pd=0 as=0 ps=0 w=1.56u l=0.28u
X2004 VREFN A44_DCTRL_STRIP_W_R2_0/CTRL_OUT[7] A44_CDAC_CAP_BANK_ASSEMBLY_R8_M6_0/A44_CAP_CORE128_M6_R1_0/CAP_BOTTOM_035 GND nfet_03v3 ad=0 pd=0 as=0 ps=0 w=1.56u l=0.28u
X2005 VREFN A44_DCTRL_STRIP_W_R2_0/CTRL_OUT[7] A44_CDAC_CAP_BANK_ASSEMBLY_R8_M6_0/A44_CAP_CORE128_M6_R1_0/CAP_BOTTOM_035 GND nfet_03v3 ad=0 pd=0 as=0 ps=0 w=1.56u l=0.28u
X2006 VREFN A44_DCTRL_STRIP_W_R2_0/CTRL_OUT[7] A44_CDAC_CAP_BANK_ASSEMBLY_R8_M6_0/A44_CAP_CORE128_M6_R1_0/CAP_BOTTOM_035 GND nfet_03v3 ad=0 pd=0 as=0 ps=0 w=1.56u l=0.28u
X2007 VREFN A44_DCTRL_STRIP_W_R2_0/CTRL_OUT[7] A44_CDAC_CAP_BANK_ASSEMBLY_R8_M6_0/A44_CAP_CORE128_M6_R1_0/CAP_BOTTOM_035 GND nfet_03v3 ad=0 pd=0 as=0 ps=0 w=1.56u l=0.28u
X2008 VREFN A44_DCTRL_STRIP_W_R2_0/CTRL_OUT[7] A44_CDAC_CAP_BANK_ASSEMBLY_R8_M6_0/A44_CAP_CORE128_M6_R1_0/CAP_BOTTOM_035 GND nfet_03v3 ad=0 pd=0 as=0 ps=0 w=1.56u l=0.28u
X2009 VREFN A44_DCTRL_STRIP_W_R2_0/CTRL_OUT[7] A44_CDAC_CAP_BANK_ASSEMBLY_R8_M6_0/A44_CAP_CORE128_M6_R1_0/CAP_BOTTOM_035 GND nfet_03v3 ad=0 pd=0 as=0 ps=0 w=1.56u l=0.28u
X2010 VREFN A44_DCTRL_STRIP_W_R2_0/CTRL_OUT[7] A44_CDAC_CAP_BANK_ASSEMBLY_R8_M6_0/A44_CAP_CORE128_M6_R1_0/CAP_BOTTOM_035 GND nfet_03v3 ad=0 pd=0 as=0 ps=0 w=1.56u l=0.28u
X2011 VREFN A44_DCTRL_STRIP_W_R2_0/CTRL_OUT[7] A44_CDAC_CAP_BANK_ASSEMBLY_R8_M6_0/A44_CAP_CORE128_M6_R1_0/CAP_BOTTOM_035 GND nfet_03v3 ad=0 pd=0 as=0 ps=0 w=1.56u l=0.28u
X2012 VREFN A44_DCTRL_STRIP_W_R2_0/CTRL_OUT[7] A44_CDAC_CAP_BANK_ASSEMBLY_R8_M6_0/A44_CAP_CORE128_M6_R1_0/CAP_BOTTOM_035 GND nfet_03v3 ad=0 pd=0 as=0 ps=0 w=1.56u l=0.28u
X2013 VREFN A44_DCTRL_STRIP_W_R2_0/CTRL_OUT[7] A44_CDAC_CAP_BANK_ASSEMBLY_R8_M6_0/A44_CAP_CORE128_M6_R1_0/CAP_BOTTOM_035 GND nfet_03v3 ad=0 pd=0 as=0 ps=0 w=1.56u l=0.28u
X2014 VREFN A44_DCTRL_STRIP_W_R2_0/CTRL_OUT[7] A44_CDAC_CAP_BANK_ASSEMBLY_R8_M6_0/A44_CAP_CORE128_M6_R1_0/CAP_BOTTOM_035 GND nfet_03v3 ad=0 pd=0 as=0 ps=0 w=1.56u l=0.28u
X2015 VREFN A44_DCTRL_STRIP_W_R2_0/CTRL_OUT[7] A44_CDAC_CAP_BANK_ASSEMBLY_R8_M6_0/A44_CAP_CORE128_M6_R1_0/CAP_BOTTOM_035 GND nfet_03v3 ad=0 pd=0 as=0 ps=0 w=1.56u l=0.28u
X2016 VREFN A44_DCTRL_STRIP_W_R2_0/CTRL_OUT[7] A44_CDAC_CAP_BANK_ASSEMBLY_R8_M6_0/A44_CAP_CORE128_M6_R1_0/CAP_BOTTOM_035 GND nfet_03v3 ad=0 pd=0 as=0 ps=0 w=1.56u l=0.28u
X2017 VREFN A44_DCTRL_STRIP_W_R2_0/CTRL_OUT[7] A44_CDAC_CAP_BANK_ASSEMBLY_R8_M6_0/A44_CAP_CORE128_M6_R1_0/CAP_BOTTOM_035 GND nfet_03v3 ad=0 pd=0 as=0 ps=0 w=1.56u l=0.28u
X2018 VREFP A44_DCTRL_STRIP_W_R2_0/CTRL_OUT[6] A44_CDAC_CAP_BANK_ASSEMBLY_R8_M6_0/A44_CAP_CORE128_M6_R1_0/CAP_BOTTOM_061 VDD pfet_03v3 ad=0 pd=0 as=16.6842p ps=77.76u w=1.56u l=0.28u
X2019 VREFP A44_DCTRL_STRIP_W_R2_0/CTRL_OUT[6] A44_CDAC_CAP_BANK_ASSEMBLY_R8_M6_0/A44_CAP_CORE128_M6_R1_0/CAP_BOTTOM_061 VDD pfet_03v3 ad=0 pd=0 as=0 ps=0 w=1.56u l=0.28u
X2020 VREFP A44_DCTRL_STRIP_W_R2_0/CTRL_OUT[6] A44_CDAC_CAP_BANK_ASSEMBLY_R8_M6_0/A44_CAP_CORE128_M6_R1_0/CAP_BOTTOM_061 VDD pfet_03v3 ad=0 pd=0 as=0 ps=0 w=1.56u l=0.28u
X2021 VREFP A44_DCTRL_STRIP_W_R2_0/CTRL_OUT[6] A44_CDAC_CAP_BANK_ASSEMBLY_R8_M6_0/A44_CAP_CORE128_M6_R1_0/CAP_BOTTOM_061 VDD pfet_03v3 ad=0 pd=0 as=0 ps=0 w=1.56u l=0.28u
X2022 VREFP A44_DCTRL_STRIP_W_R2_0/CTRL_OUT[6] A44_CDAC_CAP_BANK_ASSEMBLY_R8_M6_0/A44_CAP_CORE128_M6_R1_0/CAP_BOTTOM_061 VDD pfet_03v3 ad=0 pd=0 as=0 ps=0 w=1.56u l=0.28u
X2023 VREFP A44_DCTRL_STRIP_W_R2_0/CTRL_OUT[6] A44_CDAC_CAP_BANK_ASSEMBLY_R8_M6_0/A44_CAP_CORE128_M6_R1_0/CAP_BOTTOM_061 VDD pfet_03v3 ad=0 pd=0 as=0 ps=0 w=1.56u l=0.28u
X2024 VREFP A44_DCTRL_STRIP_W_R2_0/CTRL_OUT[6] A44_CDAC_CAP_BANK_ASSEMBLY_R8_M6_0/A44_CAP_CORE128_M6_R1_0/CAP_BOTTOM_061 VDD pfet_03v3 ad=0 pd=0 as=0 ps=0 w=1.56u l=0.28u
X2025 VREFP A44_DCTRL_STRIP_W_R2_0/CTRL_OUT[6] A44_CDAC_CAP_BANK_ASSEMBLY_R8_M6_0/A44_CAP_CORE128_M6_R1_0/CAP_BOTTOM_061 VDD pfet_03v3 ad=0 pd=0 as=0 ps=0 w=1.56u l=0.28u
X2026 VREFP A44_DCTRL_STRIP_W_R2_0/CTRL_OUT[6] A44_CDAC_CAP_BANK_ASSEMBLY_R8_M6_0/A44_CAP_CORE128_M6_R1_0/CAP_BOTTOM_061 VDD pfet_03v3 ad=0 pd=0 as=0 ps=0 w=1.56u l=0.28u
X2027 VREFP A44_DCTRL_STRIP_W_R2_0/CTRL_OUT[6] A44_CDAC_CAP_BANK_ASSEMBLY_R8_M6_0/A44_CAP_CORE128_M6_R1_0/CAP_BOTTOM_061 VDD pfet_03v3 ad=0 pd=0 as=0 ps=0 w=1.56u l=0.28u
X2028 VREFP A44_DCTRL_STRIP_W_R2_0/CTRL_OUT[6] A44_CDAC_CAP_BANK_ASSEMBLY_R8_M6_0/A44_CAP_CORE128_M6_R1_0/CAP_BOTTOM_061 VDD pfet_03v3 ad=0 pd=0 as=0 ps=0 w=1.56u l=0.28u
X2029 VREFP A44_DCTRL_STRIP_W_R2_0/CTRL_OUT[6] A44_CDAC_CAP_BANK_ASSEMBLY_R8_M6_0/A44_CAP_CORE128_M6_R1_0/CAP_BOTTOM_061 VDD pfet_03v3 ad=0 pd=0 as=0 ps=0 w=1.56u l=0.28u
X2030 VREFP A44_DCTRL_STRIP_W_R2_0/CTRL_OUT[6] A44_CDAC_CAP_BANK_ASSEMBLY_R8_M6_0/A44_CAP_CORE128_M6_R1_0/CAP_BOTTOM_061 VDD pfet_03v3 ad=0 pd=0 as=0 ps=0 w=1.56u l=0.28u
X2031 VREFP A44_DCTRL_STRIP_W_R2_0/CTRL_OUT[6] A44_CDAC_CAP_BANK_ASSEMBLY_R8_M6_0/A44_CAP_CORE128_M6_R1_0/CAP_BOTTOM_061 VDD pfet_03v3 ad=0 pd=0 as=0 ps=0 w=1.56u l=0.28u
X2032 VREFP A44_DCTRL_STRIP_W_R2_0/CTRL_OUT[6] A44_CDAC_CAP_BANK_ASSEMBLY_R8_M6_0/A44_CAP_CORE128_M6_R1_0/CAP_BOTTOM_061 VDD pfet_03v3 ad=0 pd=0 as=0 ps=0 w=1.56u l=0.28u
X2033 VREFP A44_DCTRL_STRIP_W_R2_0/CTRL_OUT[6] A44_CDAC_CAP_BANK_ASSEMBLY_R8_M6_0/A44_CAP_CORE128_M6_R1_0/CAP_BOTTOM_061 VDD pfet_03v3 ad=0 pd=0 as=0 ps=0 w=1.56u l=0.28u
X2034 VREFP A44_DCTRL_STRIP_W_R2_0/CTRL_OUT[6] A44_CDAC_CAP_BANK_ASSEMBLY_R8_M6_0/A44_CAP_CORE128_M6_R1_0/CAP_BOTTOM_061 VDD pfet_03v3 ad=0 pd=0 as=0 ps=0 w=1.56u l=0.28u
X2035 VREFP A44_DCTRL_STRIP_W_R2_0/CTRL_OUT[6] A44_CDAC_CAP_BANK_ASSEMBLY_R8_M6_0/A44_CAP_CORE128_M6_R1_0/CAP_BOTTOM_061 VDD pfet_03v3 ad=0 pd=0 as=0 ps=0 w=1.56u l=0.28u
X2036 VREFN A44_DCTRL_STRIP_W_R2_0/CTRL_OUT[6] A44_CDAC_CAP_BANK_ASSEMBLY_R8_M6_0/A44_CAP_CORE128_M6_R1_0/CAP_BOTTOM_061 GND nfet_03v3 ad=0 pd=0 as=16.6842p ps=77.76u w=1.56u l=0.28u
X2037 VREFN A44_DCTRL_STRIP_W_R2_0/CTRL_OUT[6] A44_CDAC_CAP_BANK_ASSEMBLY_R8_M6_0/A44_CAP_CORE128_M6_R1_0/CAP_BOTTOM_061 GND nfet_03v3 ad=0 pd=0 as=0 ps=0 w=1.56u l=0.28u
X2038 VREFN A44_DCTRL_STRIP_W_R2_0/CTRL_OUT[6] A44_CDAC_CAP_BANK_ASSEMBLY_R8_M6_0/A44_CAP_CORE128_M6_R1_0/CAP_BOTTOM_061 GND nfet_03v3 ad=0 pd=0 as=0 ps=0 w=1.56u l=0.28u
X2039 VREFN A44_DCTRL_STRIP_W_R2_0/CTRL_OUT[6] A44_CDAC_CAP_BANK_ASSEMBLY_R8_M6_0/A44_CAP_CORE128_M6_R1_0/CAP_BOTTOM_061 GND nfet_03v3 ad=0 pd=0 as=0 ps=0 w=1.56u l=0.28u
X2040 VREFN A44_DCTRL_STRIP_W_R2_0/CTRL_OUT[6] A44_CDAC_CAP_BANK_ASSEMBLY_R8_M6_0/A44_CAP_CORE128_M6_R1_0/CAP_BOTTOM_061 GND nfet_03v3 ad=0 pd=0 as=0 ps=0 w=1.56u l=0.28u
X2041 VREFN A44_DCTRL_STRIP_W_R2_0/CTRL_OUT[6] A44_CDAC_CAP_BANK_ASSEMBLY_R8_M6_0/A44_CAP_CORE128_M6_R1_0/CAP_BOTTOM_061 GND nfet_03v3 ad=0 pd=0 as=0 ps=0 w=1.56u l=0.28u
X2042 VREFN A44_DCTRL_STRIP_W_R2_0/CTRL_OUT[6] A44_CDAC_CAP_BANK_ASSEMBLY_R8_M6_0/A44_CAP_CORE128_M6_R1_0/CAP_BOTTOM_061 GND nfet_03v3 ad=0 pd=0 as=0 ps=0 w=1.56u l=0.28u
X2043 VREFN A44_DCTRL_STRIP_W_R2_0/CTRL_OUT[6] A44_CDAC_CAP_BANK_ASSEMBLY_R8_M6_0/A44_CAP_CORE128_M6_R1_0/CAP_BOTTOM_061 GND nfet_03v3 ad=0 pd=0 as=0 ps=0 w=1.56u l=0.28u
X2044 VREFN A44_DCTRL_STRIP_W_R2_0/CTRL_OUT[6] A44_CDAC_CAP_BANK_ASSEMBLY_R8_M6_0/A44_CAP_CORE128_M6_R1_0/CAP_BOTTOM_061 GND nfet_03v3 ad=0 pd=0 as=0 ps=0 w=1.56u l=0.28u
X2045 VREFN A44_DCTRL_STRIP_W_R2_0/CTRL_OUT[6] A44_CDAC_CAP_BANK_ASSEMBLY_R8_M6_0/A44_CAP_CORE128_M6_R1_0/CAP_BOTTOM_061 GND nfet_03v3 ad=0 pd=0 as=0 ps=0 w=1.56u l=0.28u
X2046 VREFN A44_DCTRL_STRIP_W_R2_0/CTRL_OUT[6] A44_CDAC_CAP_BANK_ASSEMBLY_R8_M6_0/A44_CAP_CORE128_M6_R1_0/CAP_BOTTOM_061 GND nfet_03v3 ad=0 pd=0 as=0 ps=0 w=1.56u l=0.28u
X2047 VREFN A44_DCTRL_STRIP_W_R2_0/CTRL_OUT[6] A44_CDAC_CAP_BANK_ASSEMBLY_R8_M6_0/A44_CAP_CORE128_M6_R1_0/CAP_BOTTOM_061 GND nfet_03v3 ad=0 pd=0 as=0 ps=0 w=1.56u l=0.28u
X2048 VREFN A44_DCTRL_STRIP_W_R2_0/CTRL_OUT[6] A44_CDAC_CAP_BANK_ASSEMBLY_R8_M6_0/A44_CAP_CORE128_M6_R1_0/CAP_BOTTOM_061 GND nfet_03v3 ad=0 pd=0 as=0 ps=0 w=1.56u l=0.28u
X2049 VREFN A44_DCTRL_STRIP_W_R2_0/CTRL_OUT[6] A44_CDAC_CAP_BANK_ASSEMBLY_R8_M6_0/A44_CAP_CORE128_M6_R1_0/CAP_BOTTOM_061 GND nfet_03v3 ad=0 pd=0 as=0 ps=0 w=1.56u l=0.28u
X2050 VREFN A44_DCTRL_STRIP_W_R2_0/CTRL_OUT[6] A44_CDAC_CAP_BANK_ASSEMBLY_R8_M6_0/A44_CAP_CORE128_M6_R1_0/CAP_BOTTOM_061 GND nfet_03v3 ad=0 pd=0 as=0 ps=0 w=1.56u l=0.28u
X2051 VREFN A44_DCTRL_STRIP_W_R2_0/CTRL_OUT[6] A44_CDAC_CAP_BANK_ASSEMBLY_R8_M6_0/A44_CAP_CORE128_M6_R1_0/CAP_BOTTOM_061 GND nfet_03v3 ad=0 pd=0 as=0 ps=0 w=1.56u l=0.28u
X2052 VREFN A44_DCTRL_STRIP_W_R2_0/CTRL_OUT[6] A44_CDAC_CAP_BANK_ASSEMBLY_R8_M6_0/A44_CAP_CORE128_M6_R1_0/CAP_BOTTOM_061 GND nfet_03v3 ad=0 pd=0 as=0 ps=0 w=1.56u l=0.28u
X2053 VREFN A44_DCTRL_STRIP_W_R2_0/CTRL_OUT[6] A44_CDAC_CAP_BANK_ASSEMBLY_R8_M6_0/A44_CAP_CORE128_M6_R1_0/CAP_BOTTOM_061 GND nfet_03v3 ad=0 pd=0 as=0 ps=0 w=1.56u l=0.28u
X2054 VREFP A44_DCTRL_STRIP_W_R2_0/CTRL_OUT[5] A44_CDAC_CAP_BANK_ASSEMBLY_R8_M6_0/A44_CAP_CORE128_M6_R1_0/CAP_BOTTOM_059 VDD pfet_03v3 ad=0 pd=0 as=16.6842p ps=77.76u w=1.56u l=0.28u
X2055 VREFP A44_DCTRL_STRIP_W_R2_0/CTRL_OUT[5] A44_CDAC_CAP_BANK_ASSEMBLY_R8_M6_0/A44_CAP_CORE128_M6_R1_0/CAP_BOTTOM_059 VDD pfet_03v3 ad=0 pd=0 as=0 ps=0 w=1.56u l=0.28u
X2056 VREFP A44_DCTRL_STRIP_W_R2_0/CTRL_OUT[5] A44_CDAC_CAP_BANK_ASSEMBLY_R8_M6_0/A44_CAP_CORE128_M6_R1_0/CAP_BOTTOM_059 VDD pfet_03v3 ad=0 pd=0 as=0 ps=0 w=1.56u l=0.28u
X2057 VREFP A44_DCTRL_STRIP_W_R2_0/CTRL_OUT[5] A44_CDAC_CAP_BANK_ASSEMBLY_R8_M6_0/A44_CAP_CORE128_M6_R1_0/CAP_BOTTOM_059 VDD pfet_03v3 ad=0 pd=0 as=0 ps=0 w=1.56u l=0.28u
X2058 VREFP A44_DCTRL_STRIP_W_R2_0/CTRL_OUT[5] A44_CDAC_CAP_BANK_ASSEMBLY_R8_M6_0/A44_CAP_CORE128_M6_R1_0/CAP_BOTTOM_059 VDD pfet_03v3 ad=0 pd=0 as=0 ps=0 w=1.56u l=0.28u
X2059 VREFP A44_DCTRL_STRIP_W_R2_0/CTRL_OUT[5] A44_CDAC_CAP_BANK_ASSEMBLY_R8_M6_0/A44_CAP_CORE128_M6_R1_0/CAP_BOTTOM_059 VDD pfet_03v3 ad=0 pd=0 as=0 ps=0 w=1.56u l=0.28u
X2060 VREFP A44_DCTRL_STRIP_W_R2_0/CTRL_OUT[5] A44_CDAC_CAP_BANK_ASSEMBLY_R8_M6_0/A44_CAP_CORE128_M6_R1_0/CAP_BOTTOM_059 VDD pfet_03v3 ad=0 pd=0 as=0 ps=0 w=1.56u l=0.28u
X2061 VREFP A44_DCTRL_STRIP_W_R2_0/CTRL_OUT[5] A44_CDAC_CAP_BANK_ASSEMBLY_R8_M6_0/A44_CAP_CORE128_M6_R1_0/CAP_BOTTOM_059 VDD pfet_03v3 ad=0 pd=0 as=0 ps=0 w=1.56u l=0.28u
X2062 VREFP A44_DCTRL_STRIP_W_R2_0/CTRL_OUT[5] A44_CDAC_CAP_BANK_ASSEMBLY_R8_M6_0/A44_CAP_CORE128_M6_R1_0/CAP_BOTTOM_059 VDD pfet_03v3 ad=0 pd=0 as=0 ps=0 w=1.56u l=0.28u
X2063 VREFP A44_DCTRL_STRIP_W_R2_0/CTRL_OUT[5] A44_CDAC_CAP_BANK_ASSEMBLY_R8_M6_0/A44_CAP_CORE128_M6_R1_0/CAP_BOTTOM_059 VDD pfet_03v3 ad=0 pd=0 as=0 ps=0 w=1.56u l=0.28u
X2064 VREFP A44_DCTRL_STRIP_W_R2_0/CTRL_OUT[5] A44_CDAC_CAP_BANK_ASSEMBLY_R8_M6_0/A44_CAP_CORE128_M6_R1_0/CAP_BOTTOM_059 VDD pfet_03v3 ad=0 pd=0 as=0 ps=0 w=1.56u l=0.28u
X2065 VREFP A44_DCTRL_STRIP_W_R2_0/CTRL_OUT[5] A44_CDAC_CAP_BANK_ASSEMBLY_R8_M6_0/A44_CAP_CORE128_M6_R1_0/CAP_BOTTOM_059 VDD pfet_03v3 ad=0 pd=0 as=0 ps=0 w=1.56u l=0.28u
X2066 VREFP A44_DCTRL_STRIP_W_R2_0/CTRL_OUT[5] A44_CDAC_CAP_BANK_ASSEMBLY_R8_M6_0/A44_CAP_CORE128_M6_R1_0/CAP_BOTTOM_059 VDD pfet_03v3 ad=0 pd=0 as=0 ps=0 w=1.56u l=0.28u
X2067 VREFP A44_DCTRL_STRIP_W_R2_0/CTRL_OUT[5] A44_CDAC_CAP_BANK_ASSEMBLY_R8_M6_0/A44_CAP_CORE128_M6_R1_0/CAP_BOTTOM_059 VDD pfet_03v3 ad=0 pd=0 as=0 ps=0 w=1.56u l=0.28u
X2068 VREFP A44_DCTRL_STRIP_W_R2_0/CTRL_OUT[5] A44_CDAC_CAP_BANK_ASSEMBLY_R8_M6_0/A44_CAP_CORE128_M6_R1_0/CAP_BOTTOM_059 VDD pfet_03v3 ad=0 pd=0 as=0 ps=0 w=1.56u l=0.28u
X2069 VREFP A44_DCTRL_STRIP_W_R2_0/CTRL_OUT[5] A44_CDAC_CAP_BANK_ASSEMBLY_R8_M6_0/A44_CAP_CORE128_M6_R1_0/CAP_BOTTOM_059 VDD pfet_03v3 ad=0 pd=0 as=0 ps=0 w=1.56u l=0.28u
X2070 VREFP A44_DCTRL_STRIP_W_R2_0/CTRL_OUT[5] A44_CDAC_CAP_BANK_ASSEMBLY_R8_M6_0/A44_CAP_CORE128_M6_R1_0/CAP_BOTTOM_059 VDD pfet_03v3 ad=0 pd=0 as=0 ps=0 w=1.56u l=0.28u
X2071 VREFP A44_DCTRL_STRIP_W_R2_0/CTRL_OUT[5] A44_CDAC_CAP_BANK_ASSEMBLY_R8_M6_0/A44_CAP_CORE128_M6_R1_0/CAP_BOTTOM_059 VDD pfet_03v3 ad=0 pd=0 as=0 ps=0 w=1.56u l=0.28u
X2072 VREFN A44_DCTRL_STRIP_W_R2_0/CTRL_OUT[5] A44_CDAC_CAP_BANK_ASSEMBLY_R8_M6_0/A44_CAP_CORE128_M6_R1_0/CAP_BOTTOM_059 GND nfet_03v3 ad=0 pd=0 as=16.6842p ps=77.76u w=1.56u l=0.28u
X2073 VREFN A44_DCTRL_STRIP_W_R2_0/CTRL_OUT[5] A44_CDAC_CAP_BANK_ASSEMBLY_R8_M6_0/A44_CAP_CORE128_M6_R1_0/CAP_BOTTOM_059 GND nfet_03v3 ad=0 pd=0 as=0 ps=0 w=1.56u l=0.28u
X2074 VREFN A44_DCTRL_STRIP_W_R2_0/CTRL_OUT[5] A44_CDAC_CAP_BANK_ASSEMBLY_R8_M6_0/A44_CAP_CORE128_M6_R1_0/CAP_BOTTOM_059 GND nfet_03v3 ad=0 pd=0 as=0 ps=0 w=1.56u l=0.28u
X2075 VREFN A44_DCTRL_STRIP_W_R2_0/CTRL_OUT[5] A44_CDAC_CAP_BANK_ASSEMBLY_R8_M6_0/A44_CAP_CORE128_M6_R1_0/CAP_BOTTOM_059 GND nfet_03v3 ad=0 pd=0 as=0 ps=0 w=1.56u l=0.28u
X2076 VREFN A44_DCTRL_STRIP_W_R2_0/CTRL_OUT[5] A44_CDAC_CAP_BANK_ASSEMBLY_R8_M6_0/A44_CAP_CORE128_M6_R1_0/CAP_BOTTOM_059 GND nfet_03v3 ad=0 pd=0 as=0 ps=0 w=1.56u l=0.28u
X2077 VREFN A44_DCTRL_STRIP_W_R2_0/CTRL_OUT[5] A44_CDAC_CAP_BANK_ASSEMBLY_R8_M6_0/A44_CAP_CORE128_M6_R1_0/CAP_BOTTOM_059 GND nfet_03v3 ad=0 pd=0 as=0 ps=0 w=1.56u l=0.28u
X2078 VREFN A44_DCTRL_STRIP_W_R2_0/CTRL_OUT[5] A44_CDAC_CAP_BANK_ASSEMBLY_R8_M6_0/A44_CAP_CORE128_M6_R1_0/CAP_BOTTOM_059 GND nfet_03v3 ad=0 pd=0 as=0 ps=0 w=1.56u l=0.28u
X2079 VREFN A44_DCTRL_STRIP_W_R2_0/CTRL_OUT[5] A44_CDAC_CAP_BANK_ASSEMBLY_R8_M6_0/A44_CAP_CORE128_M6_R1_0/CAP_BOTTOM_059 GND nfet_03v3 ad=0 pd=0 as=0 ps=0 w=1.56u l=0.28u
X2080 VREFN A44_DCTRL_STRIP_W_R2_0/CTRL_OUT[5] A44_CDAC_CAP_BANK_ASSEMBLY_R8_M6_0/A44_CAP_CORE128_M6_R1_0/CAP_BOTTOM_059 GND nfet_03v3 ad=0 pd=0 as=0 ps=0 w=1.56u l=0.28u
X2081 VREFN A44_DCTRL_STRIP_W_R2_0/CTRL_OUT[5] A44_CDAC_CAP_BANK_ASSEMBLY_R8_M6_0/A44_CAP_CORE128_M6_R1_0/CAP_BOTTOM_059 GND nfet_03v3 ad=0 pd=0 as=0 ps=0 w=1.56u l=0.28u
X2082 VREFN A44_DCTRL_STRIP_W_R2_0/CTRL_OUT[5] A44_CDAC_CAP_BANK_ASSEMBLY_R8_M6_0/A44_CAP_CORE128_M6_R1_0/CAP_BOTTOM_059 GND nfet_03v3 ad=0 pd=0 as=0 ps=0 w=1.56u l=0.28u
X2083 VREFN A44_DCTRL_STRIP_W_R2_0/CTRL_OUT[5] A44_CDAC_CAP_BANK_ASSEMBLY_R8_M6_0/A44_CAP_CORE128_M6_R1_0/CAP_BOTTOM_059 GND nfet_03v3 ad=0 pd=0 as=0 ps=0 w=1.56u l=0.28u
X2084 VREFN A44_DCTRL_STRIP_W_R2_0/CTRL_OUT[5] A44_CDAC_CAP_BANK_ASSEMBLY_R8_M6_0/A44_CAP_CORE128_M6_R1_0/CAP_BOTTOM_059 GND nfet_03v3 ad=0 pd=0 as=0 ps=0 w=1.56u l=0.28u
X2085 VREFN A44_DCTRL_STRIP_W_R2_0/CTRL_OUT[5] A44_CDAC_CAP_BANK_ASSEMBLY_R8_M6_0/A44_CAP_CORE128_M6_R1_0/CAP_BOTTOM_059 GND nfet_03v3 ad=0 pd=0 as=0 ps=0 w=1.56u l=0.28u
X2086 VREFN A44_DCTRL_STRIP_W_R2_0/CTRL_OUT[5] A44_CDAC_CAP_BANK_ASSEMBLY_R8_M6_0/A44_CAP_CORE128_M6_R1_0/CAP_BOTTOM_059 GND nfet_03v3 ad=0 pd=0 as=0 ps=0 w=1.56u l=0.28u
X2087 VREFN A44_DCTRL_STRIP_W_R2_0/CTRL_OUT[5] A44_CDAC_CAP_BANK_ASSEMBLY_R8_M6_0/A44_CAP_CORE128_M6_R1_0/CAP_BOTTOM_059 GND nfet_03v3 ad=0 pd=0 as=0 ps=0 w=1.56u l=0.28u
X2088 VREFN A44_DCTRL_STRIP_W_R2_0/CTRL_OUT[5] A44_CDAC_CAP_BANK_ASSEMBLY_R8_M6_0/A44_CAP_CORE128_M6_R1_0/CAP_BOTTOM_059 GND nfet_03v3 ad=0 pd=0 as=0 ps=0 w=1.56u l=0.28u
X2089 VREFN A44_DCTRL_STRIP_W_R2_0/CTRL_OUT[5] A44_CDAC_CAP_BANK_ASSEMBLY_R8_M6_0/A44_CAP_CORE128_M6_R1_0/CAP_BOTTOM_059 GND nfet_03v3 ad=0 pd=0 as=0 ps=0 w=1.56u l=0.28u
X2090 VREFP A44_DCTRL_STRIP_W_R2_0/CTRL_OUT[5] A44_CDAC_CAP_BANK_ASSEMBLY_R8_M6_0/A44_CAP_CORE128_M6_R1_0/CAP_BOTTOM_022 VDD pfet_03v3 ad=0 pd=0 as=16.6842p ps=77.76u w=1.56u l=0.28u
X2091 VREFP A44_DCTRL_STRIP_W_R2_0/CTRL_OUT[5] A44_CDAC_CAP_BANK_ASSEMBLY_R8_M6_0/A44_CAP_CORE128_M6_R1_0/CAP_BOTTOM_022 VDD pfet_03v3 ad=0 pd=0 as=0 ps=0 w=1.56u l=0.28u
X2092 VREFP A44_DCTRL_STRIP_W_R2_0/CTRL_OUT[5] A44_CDAC_CAP_BANK_ASSEMBLY_R8_M6_0/A44_CAP_CORE128_M6_R1_0/CAP_BOTTOM_022 VDD pfet_03v3 ad=0 pd=0 as=0 ps=0 w=1.56u l=0.28u
X2093 VREFP A44_DCTRL_STRIP_W_R2_0/CTRL_OUT[5] A44_CDAC_CAP_BANK_ASSEMBLY_R8_M6_0/A44_CAP_CORE128_M6_R1_0/CAP_BOTTOM_022 VDD pfet_03v3 ad=0 pd=0 as=0 ps=0 w=1.56u l=0.28u
X2094 VREFP A44_DCTRL_STRIP_W_R2_0/CTRL_OUT[5] A44_CDAC_CAP_BANK_ASSEMBLY_R8_M6_0/A44_CAP_CORE128_M6_R1_0/CAP_BOTTOM_022 VDD pfet_03v3 ad=0 pd=0 as=0 ps=0 w=1.56u l=0.28u
X2095 VREFP A44_DCTRL_STRIP_W_R2_0/CTRL_OUT[5] A44_CDAC_CAP_BANK_ASSEMBLY_R8_M6_0/A44_CAP_CORE128_M6_R1_0/CAP_BOTTOM_022 VDD pfet_03v3 ad=0 pd=0 as=0 ps=0 w=1.56u l=0.28u
X2096 VREFP A44_DCTRL_STRIP_W_R2_0/CTRL_OUT[5] A44_CDAC_CAP_BANK_ASSEMBLY_R8_M6_0/A44_CAP_CORE128_M6_R1_0/CAP_BOTTOM_022 VDD pfet_03v3 ad=0 pd=0 as=0 ps=0 w=1.56u l=0.28u
X2097 VREFP A44_DCTRL_STRIP_W_R2_0/CTRL_OUT[5] A44_CDAC_CAP_BANK_ASSEMBLY_R8_M6_0/A44_CAP_CORE128_M6_R1_0/CAP_BOTTOM_022 VDD pfet_03v3 ad=0 pd=0 as=0 ps=0 w=1.56u l=0.28u
X2098 VREFP A44_DCTRL_STRIP_W_R2_0/CTRL_OUT[5] A44_CDAC_CAP_BANK_ASSEMBLY_R8_M6_0/A44_CAP_CORE128_M6_R1_0/CAP_BOTTOM_022 VDD pfet_03v3 ad=0 pd=0 as=0 ps=0 w=1.56u l=0.28u
X2099 VREFP A44_DCTRL_STRIP_W_R2_0/CTRL_OUT[5] A44_CDAC_CAP_BANK_ASSEMBLY_R8_M6_0/A44_CAP_CORE128_M6_R1_0/CAP_BOTTOM_022 VDD pfet_03v3 ad=0 pd=0 as=0 ps=0 w=1.56u l=0.28u
X2100 VREFP A44_DCTRL_STRIP_W_R2_0/CTRL_OUT[5] A44_CDAC_CAP_BANK_ASSEMBLY_R8_M6_0/A44_CAP_CORE128_M6_R1_0/CAP_BOTTOM_022 VDD pfet_03v3 ad=0 pd=0 as=0 ps=0 w=1.56u l=0.28u
X2101 VREFP A44_DCTRL_STRIP_W_R2_0/CTRL_OUT[5] A44_CDAC_CAP_BANK_ASSEMBLY_R8_M6_0/A44_CAP_CORE128_M6_R1_0/CAP_BOTTOM_022 VDD pfet_03v3 ad=0 pd=0 as=0 ps=0 w=1.56u l=0.28u
X2102 VREFP A44_DCTRL_STRIP_W_R2_0/CTRL_OUT[5] A44_CDAC_CAP_BANK_ASSEMBLY_R8_M6_0/A44_CAP_CORE128_M6_R1_0/CAP_BOTTOM_022 VDD pfet_03v3 ad=0 pd=0 as=0 ps=0 w=1.56u l=0.28u
X2103 VREFP A44_DCTRL_STRIP_W_R2_0/CTRL_OUT[5] A44_CDAC_CAP_BANK_ASSEMBLY_R8_M6_0/A44_CAP_CORE128_M6_R1_0/CAP_BOTTOM_022 VDD pfet_03v3 ad=0 pd=0 as=0 ps=0 w=1.56u l=0.28u
X2104 VREFP A44_DCTRL_STRIP_W_R2_0/CTRL_OUT[5] A44_CDAC_CAP_BANK_ASSEMBLY_R8_M6_0/A44_CAP_CORE128_M6_R1_0/CAP_BOTTOM_022 VDD pfet_03v3 ad=0 pd=0 as=0 ps=0 w=1.56u l=0.28u
X2105 VREFP A44_DCTRL_STRIP_W_R2_0/CTRL_OUT[5] A44_CDAC_CAP_BANK_ASSEMBLY_R8_M6_0/A44_CAP_CORE128_M6_R1_0/CAP_BOTTOM_022 VDD pfet_03v3 ad=0 pd=0 as=0 ps=0 w=1.56u l=0.28u
X2106 VREFP A44_DCTRL_STRIP_W_R2_0/CTRL_OUT[5] A44_CDAC_CAP_BANK_ASSEMBLY_R8_M6_0/A44_CAP_CORE128_M6_R1_0/CAP_BOTTOM_022 VDD pfet_03v3 ad=0 pd=0 as=0 ps=0 w=1.56u l=0.28u
X2107 VREFP A44_DCTRL_STRIP_W_R2_0/CTRL_OUT[5] A44_CDAC_CAP_BANK_ASSEMBLY_R8_M6_0/A44_CAP_CORE128_M6_R1_0/CAP_BOTTOM_022 VDD pfet_03v3 ad=0 pd=0 as=0 ps=0 w=1.56u l=0.28u
X2108 VREFN A44_DCTRL_STRIP_W_R2_0/CTRL_OUT[5] A44_CDAC_CAP_BANK_ASSEMBLY_R8_M6_0/A44_CAP_CORE128_M6_R1_0/CAP_BOTTOM_022 GND nfet_03v3 ad=0 pd=0 as=16.6842p ps=77.76u w=1.56u l=0.28u
X2109 VREFN A44_DCTRL_STRIP_W_R2_0/CTRL_OUT[5] A44_CDAC_CAP_BANK_ASSEMBLY_R8_M6_0/A44_CAP_CORE128_M6_R1_0/CAP_BOTTOM_022 GND nfet_03v3 ad=0 pd=0 as=0 ps=0 w=1.56u l=0.28u
X2110 VREFN A44_DCTRL_STRIP_W_R2_0/CTRL_OUT[5] A44_CDAC_CAP_BANK_ASSEMBLY_R8_M6_0/A44_CAP_CORE128_M6_R1_0/CAP_BOTTOM_022 GND nfet_03v3 ad=0 pd=0 as=0 ps=0 w=1.56u l=0.28u
X2111 VREFN A44_DCTRL_STRIP_W_R2_0/CTRL_OUT[5] A44_CDAC_CAP_BANK_ASSEMBLY_R8_M6_0/A44_CAP_CORE128_M6_R1_0/CAP_BOTTOM_022 GND nfet_03v3 ad=0 pd=0 as=0 ps=0 w=1.56u l=0.28u
X2112 VREFN A44_DCTRL_STRIP_W_R2_0/CTRL_OUT[5] A44_CDAC_CAP_BANK_ASSEMBLY_R8_M6_0/A44_CAP_CORE128_M6_R1_0/CAP_BOTTOM_022 GND nfet_03v3 ad=0 pd=0 as=0 ps=0 w=1.56u l=0.28u
X2113 VREFN A44_DCTRL_STRIP_W_R2_0/CTRL_OUT[5] A44_CDAC_CAP_BANK_ASSEMBLY_R8_M6_0/A44_CAP_CORE128_M6_R1_0/CAP_BOTTOM_022 GND nfet_03v3 ad=0 pd=0 as=0 ps=0 w=1.56u l=0.28u
X2114 VREFN A44_DCTRL_STRIP_W_R2_0/CTRL_OUT[5] A44_CDAC_CAP_BANK_ASSEMBLY_R8_M6_0/A44_CAP_CORE128_M6_R1_0/CAP_BOTTOM_022 GND nfet_03v3 ad=0 pd=0 as=0 ps=0 w=1.56u l=0.28u
X2115 VREFN A44_DCTRL_STRIP_W_R2_0/CTRL_OUT[5] A44_CDAC_CAP_BANK_ASSEMBLY_R8_M6_0/A44_CAP_CORE128_M6_R1_0/CAP_BOTTOM_022 GND nfet_03v3 ad=0 pd=0 as=0 ps=0 w=1.56u l=0.28u
X2116 VREFN A44_DCTRL_STRIP_W_R2_0/CTRL_OUT[5] A44_CDAC_CAP_BANK_ASSEMBLY_R8_M6_0/A44_CAP_CORE128_M6_R1_0/CAP_BOTTOM_022 GND nfet_03v3 ad=0 pd=0 as=0 ps=0 w=1.56u l=0.28u
X2117 VREFN A44_DCTRL_STRIP_W_R2_0/CTRL_OUT[5] A44_CDAC_CAP_BANK_ASSEMBLY_R8_M6_0/A44_CAP_CORE128_M6_R1_0/CAP_BOTTOM_022 GND nfet_03v3 ad=0 pd=0 as=0 ps=0 w=1.56u l=0.28u
X2118 VREFN A44_DCTRL_STRIP_W_R2_0/CTRL_OUT[5] A44_CDAC_CAP_BANK_ASSEMBLY_R8_M6_0/A44_CAP_CORE128_M6_R1_0/CAP_BOTTOM_022 GND nfet_03v3 ad=0 pd=0 as=0 ps=0 w=1.56u l=0.28u
X2119 VREFN A44_DCTRL_STRIP_W_R2_0/CTRL_OUT[5] A44_CDAC_CAP_BANK_ASSEMBLY_R8_M6_0/A44_CAP_CORE128_M6_R1_0/CAP_BOTTOM_022 GND nfet_03v3 ad=0 pd=0 as=0 ps=0 w=1.56u l=0.28u
X2120 VREFN A44_DCTRL_STRIP_W_R2_0/CTRL_OUT[5] A44_CDAC_CAP_BANK_ASSEMBLY_R8_M6_0/A44_CAP_CORE128_M6_R1_0/CAP_BOTTOM_022 GND nfet_03v3 ad=0 pd=0 as=0 ps=0 w=1.56u l=0.28u
X2121 VREFN A44_DCTRL_STRIP_W_R2_0/CTRL_OUT[5] A44_CDAC_CAP_BANK_ASSEMBLY_R8_M6_0/A44_CAP_CORE128_M6_R1_0/CAP_BOTTOM_022 GND nfet_03v3 ad=0 pd=0 as=0 ps=0 w=1.56u l=0.28u
X2122 VREFN A44_DCTRL_STRIP_W_R2_0/CTRL_OUT[5] A44_CDAC_CAP_BANK_ASSEMBLY_R8_M6_0/A44_CAP_CORE128_M6_R1_0/CAP_BOTTOM_022 GND nfet_03v3 ad=0 pd=0 as=0 ps=0 w=1.56u l=0.28u
X2123 VREFN A44_DCTRL_STRIP_W_R2_0/CTRL_OUT[5] A44_CDAC_CAP_BANK_ASSEMBLY_R8_M6_0/A44_CAP_CORE128_M6_R1_0/CAP_BOTTOM_022 GND nfet_03v3 ad=0 pd=0 as=0 ps=0 w=1.56u l=0.28u
X2124 VREFN A44_DCTRL_STRIP_W_R2_0/CTRL_OUT[5] A44_CDAC_CAP_BANK_ASSEMBLY_R8_M6_0/A44_CAP_CORE128_M6_R1_0/CAP_BOTTOM_022 GND nfet_03v3 ad=0 pd=0 as=0 ps=0 w=1.56u l=0.28u
X2125 VREFN A44_DCTRL_STRIP_W_R2_0/CTRL_OUT[5] A44_CDAC_CAP_BANK_ASSEMBLY_R8_M6_0/A44_CAP_CORE128_M6_R1_0/CAP_BOTTOM_022 GND nfet_03v3 ad=0 pd=0 as=0 ps=0 w=1.56u l=0.28u
X2126 VREFP A44_DCTRL_STRIP_W_R2_0/CTRL_OUT[7] A44_CDAC_CAP_BANK_ASSEMBLY_R8_M6_0/A44_CAP_CORE128_M6_R1_0/CAP_BOTTOM_045 VDD pfet_03v3 ad=0 pd=0 as=16.6842p ps=77.76u w=1.56u l=0.28u
X2127 VREFP A44_DCTRL_STRIP_W_R2_0/CTRL_OUT[7] A44_CDAC_CAP_BANK_ASSEMBLY_R8_M6_0/A44_CAP_CORE128_M6_R1_0/CAP_BOTTOM_045 VDD pfet_03v3 ad=0 pd=0 as=0 ps=0 w=1.56u l=0.28u
X2128 VREFP A44_DCTRL_STRIP_W_R2_0/CTRL_OUT[7] A44_CDAC_CAP_BANK_ASSEMBLY_R8_M6_0/A44_CAP_CORE128_M6_R1_0/CAP_BOTTOM_045 VDD pfet_03v3 ad=0 pd=0 as=0 ps=0 w=1.56u l=0.28u
X2129 VREFP A44_DCTRL_STRIP_W_R2_0/CTRL_OUT[7] A44_CDAC_CAP_BANK_ASSEMBLY_R8_M6_0/A44_CAP_CORE128_M6_R1_0/CAP_BOTTOM_045 VDD pfet_03v3 ad=0 pd=0 as=0 ps=0 w=1.56u l=0.28u
X2130 VREFP A44_DCTRL_STRIP_W_R2_0/CTRL_OUT[7] A44_CDAC_CAP_BANK_ASSEMBLY_R8_M6_0/A44_CAP_CORE128_M6_R1_0/CAP_BOTTOM_045 VDD pfet_03v3 ad=0 pd=0 as=0 ps=0 w=1.56u l=0.28u
X2131 VREFP A44_DCTRL_STRIP_W_R2_0/CTRL_OUT[7] A44_CDAC_CAP_BANK_ASSEMBLY_R8_M6_0/A44_CAP_CORE128_M6_R1_0/CAP_BOTTOM_045 VDD pfet_03v3 ad=0 pd=0 as=0 ps=0 w=1.56u l=0.28u
X2132 VREFP A44_DCTRL_STRIP_W_R2_0/CTRL_OUT[7] A44_CDAC_CAP_BANK_ASSEMBLY_R8_M6_0/A44_CAP_CORE128_M6_R1_0/CAP_BOTTOM_045 VDD pfet_03v3 ad=0 pd=0 as=0 ps=0 w=1.56u l=0.28u
X2133 VREFP A44_DCTRL_STRIP_W_R2_0/CTRL_OUT[7] A44_CDAC_CAP_BANK_ASSEMBLY_R8_M6_0/A44_CAP_CORE128_M6_R1_0/CAP_BOTTOM_045 VDD pfet_03v3 ad=0 pd=0 as=0 ps=0 w=1.56u l=0.28u
X2134 VREFP A44_DCTRL_STRIP_W_R2_0/CTRL_OUT[7] A44_CDAC_CAP_BANK_ASSEMBLY_R8_M6_0/A44_CAP_CORE128_M6_R1_0/CAP_BOTTOM_045 VDD pfet_03v3 ad=0 pd=0 as=0 ps=0 w=1.56u l=0.28u
X2135 VREFP A44_DCTRL_STRIP_W_R2_0/CTRL_OUT[7] A44_CDAC_CAP_BANK_ASSEMBLY_R8_M6_0/A44_CAP_CORE128_M6_R1_0/CAP_BOTTOM_045 VDD pfet_03v3 ad=0 pd=0 as=0 ps=0 w=1.56u l=0.28u
X2136 VREFP A44_DCTRL_STRIP_W_R2_0/CTRL_OUT[7] A44_CDAC_CAP_BANK_ASSEMBLY_R8_M6_0/A44_CAP_CORE128_M6_R1_0/CAP_BOTTOM_045 VDD pfet_03v3 ad=0 pd=0 as=0 ps=0 w=1.56u l=0.28u
X2137 VREFP A44_DCTRL_STRIP_W_R2_0/CTRL_OUT[7] A44_CDAC_CAP_BANK_ASSEMBLY_R8_M6_0/A44_CAP_CORE128_M6_R1_0/CAP_BOTTOM_045 VDD pfet_03v3 ad=0 pd=0 as=0 ps=0 w=1.56u l=0.28u
X2138 VREFP A44_DCTRL_STRIP_W_R2_0/CTRL_OUT[7] A44_CDAC_CAP_BANK_ASSEMBLY_R8_M6_0/A44_CAP_CORE128_M6_R1_0/CAP_BOTTOM_045 VDD pfet_03v3 ad=0 pd=0 as=0 ps=0 w=1.56u l=0.28u
X2139 VREFP A44_DCTRL_STRIP_W_R2_0/CTRL_OUT[7] A44_CDAC_CAP_BANK_ASSEMBLY_R8_M6_0/A44_CAP_CORE128_M6_R1_0/CAP_BOTTOM_045 VDD pfet_03v3 ad=0 pd=0 as=0 ps=0 w=1.56u l=0.28u
X2140 VREFP A44_DCTRL_STRIP_W_R2_0/CTRL_OUT[7] A44_CDAC_CAP_BANK_ASSEMBLY_R8_M6_0/A44_CAP_CORE128_M6_R1_0/CAP_BOTTOM_045 VDD pfet_03v3 ad=0 pd=0 as=0 ps=0 w=1.56u l=0.28u
X2141 VREFP A44_DCTRL_STRIP_W_R2_0/CTRL_OUT[7] A44_CDAC_CAP_BANK_ASSEMBLY_R8_M6_0/A44_CAP_CORE128_M6_R1_0/CAP_BOTTOM_045 VDD pfet_03v3 ad=0 pd=0 as=0 ps=0 w=1.56u l=0.28u
X2142 VREFP A44_DCTRL_STRIP_W_R2_0/CTRL_OUT[7] A44_CDAC_CAP_BANK_ASSEMBLY_R8_M6_0/A44_CAP_CORE128_M6_R1_0/CAP_BOTTOM_045 VDD pfet_03v3 ad=0 pd=0 as=0 ps=0 w=1.56u l=0.28u
X2143 VREFP A44_DCTRL_STRIP_W_R2_0/CTRL_OUT[7] A44_CDAC_CAP_BANK_ASSEMBLY_R8_M6_0/A44_CAP_CORE128_M6_R1_0/CAP_BOTTOM_045 VDD pfet_03v3 ad=0 pd=0 as=0 ps=0 w=1.56u l=0.28u
X2144 VREFN A44_DCTRL_STRIP_W_R2_0/CTRL_OUT[7] A44_CDAC_CAP_BANK_ASSEMBLY_R8_M6_0/A44_CAP_CORE128_M6_R1_0/CAP_BOTTOM_045 GND nfet_03v3 ad=0 pd=0 as=16.6842p ps=77.76u w=1.56u l=0.28u
X2145 VREFN A44_DCTRL_STRIP_W_R2_0/CTRL_OUT[7] A44_CDAC_CAP_BANK_ASSEMBLY_R8_M6_0/A44_CAP_CORE128_M6_R1_0/CAP_BOTTOM_045 GND nfet_03v3 ad=0 pd=0 as=0 ps=0 w=1.56u l=0.28u
X2146 VREFN A44_DCTRL_STRIP_W_R2_0/CTRL_OUT[7] A44_CDAC_CAP_BANK_ASSEMBLY_R8_M6_0/A44_CAP_CORE128_M6_R1_0/CAP_BOTTOM_045 GND nfet_03v3 ad=0 pd=0 as=0 ps=0 w=1.56u l=0.28u
X2147 VREFN A44_DCTRL_STRIP_W_R2_0/CTRL_OUT[7] A44_CDAC_CAP_BANK_ASSEMBLY_R8_M6_0/A44_CAP_CORE128_M6_R1_0/CAP_BOTTOM_045 GND nfet_03v3 ad=0 pd=0 as=0 ps=0 w=1.56u l=0.28u
X2148 VREFN A44_DCTRL_STRIP_W_R2_0/CTRL_OUT[7] A44_CDAC_CAP_BANK_ASSEMBLY_R8_M6_0/A44_CAP_CORE128_M6_R1_0/CAP_BOTTOM_045 GND nfet_03v3 ad=0 pd=0 as=0 ps=0 w=1.56u l=0.28u
X2149 VREFN A44_DCTRL_STRIP_W_R2_0/CTRL_OUT[7] A44_CDAC_CAP_BANK_ASSEMBLY_R8_M6_0/A44_CAP_CORE128_M6_R1_0/CAP_BOTTOM_045 GND nfet_03v3 ad=0 pd=0 as=0 ps=0 w=1.56u l=0.28u
X2150 VREFN A44_DCTRL_STRIP_W_R2_0/CTRL_OUT[7] A44_CDAC_CAP_BANK_ASSEMBLY_R8_M6_0/A44_CAP_CORE128_M6_R1_0/CAP_BOTTOM_045 GND nfet_03v3 ad=0 pd=0 as=0 ps=0 w=1.56u l=0.28u
X2151 VREFN A44_DCTRL_STRIP_W_R2_0/CTRL_OUT[7] A44_CDAC_CAP_BANK_ASSEMBLY_R8_M6_0/A44_CAP_CORE128_M6_R1_0/CAP_BOTTOM_045 GND nfet_03v3 ad=0 pd=0 as=0 ps=0 w=1.56u l=0.28u
X2152 VREFN A44_DCTRL_STRIP_W_R2_0/CTRL_OUT[7] A44_CDAC_CAP_BANK_ASSEMBLY_R8_M6_0/A44_CAP_CORE128_M6_R1_0/CAP_BOTTOM_045 GND nfet_03v3 ad=0 pd=0 as=0 ps=0 w=1.56u l=0.28u
X2153 VREFN A44_DCTRL_STRIP_W_R2_0/CTRL_OUT[7] A44_CDAC_CAP_BANK_ASSEMBLY_R8_M6_0/A44_CAP_CORE128_M6_R1_0/CAP_BOTTOM_045 GND nfet_03v3 ad=0 pd=0 as=0 ps=0 w=1.56u l=0.28u
X2154 VREFN A44_DCTRL_STRIP_W_R2_0/CTRL_OUT[7] A44_CDAC_CAP_BANK_ASSEMBLY_R8_M6_0/A44_CAP_CORE128_M6_R1_0/CAP_BOTTOM_045 GND nfet_03v3 ad=0 pd=0 as=0 ps=0 w=1.56u l=0.28u
X2155 VREFN A44_DCTRL_STRIP_W_R2_0/CTRL_OUT[7] A44_CDAC_CAP_BANK_ASSEMBLY_R8_M6_0/A44_CAP_CORE128_M6_R1_0/CAP_BOTTOM_045 GND nfet_03v3 ad=0 pd=0 as=0 ps=0 w=1.56u l=0.28u
X2156 VREFN A44_DCTRL_STRIP_W_R2_0/CTRL_OUT[7] A44_CDAC_CAP_BANK_ASSEMBLY_R8_M6_0/A44_CAP_CORE128_M6_R1_0/CAP_BOTTOM_045 GND nfet_03v3 ad=0 pd=0 as=0 ps=0 w=1.56u l=0.28u
X2157 VREFN A44_DCTRL_STRIP_W_R2_0/CTRL_OUT[7] A44_CDAC_CAP_BANK_ASSEMBLY_R8_M6_0/A44_CAP_CORE128_M6_R1_0/CAP_BOTTOM_045 GND nfet_03v3 ad=0 pd=0 as=0 ps=0 w=1.56u l=0.28u
X2158 VREFN A44_DCTRL_STRIP_W_R2_0/CTRL_OUT[7] A44_CDAC_CAP_BANK_ASSEMBLY_R8_M6_0/A44_CAP_CORE128_M6_R1_0/CAP_BOTTOM_045 GND nfet_03v3 ad=0 pd=0 as=0 ps=0 w=1.56u l=0.28u
X2159 VREFN A44_DCTRL_STRIP_W_R2_0/CTRL_OUT[7] A44_CDAC_CAP_BANK_ASSEMBLY_R8_M6_0/A44_CAP_CORE128_M6_R1_0/CAP_BOTTOM_045 GND nfet_03v3 ad=0 pd=0 as=0 ps=0 w=1.56u l=0.28u
X2160 VREFN A44_DCTRL_STRIP_W_R2_0/CTRL_OUT[7] A44_CDAC_CAP_BANK_ASSEMBLY_R8_M6_0/A44_CAP_CORE128_M6_R1_0/CAP_BOTTOM_045 GND nfet_03v3 ad=0 pd=0 as=0 ps=0 w=1.56u l=0.28u
X2161 VREFN A44_DCTRL_STRIP_W_R2_0/CTRL_OUT[7] A44_CDAC_CAP_BANK_ASSEMBLY_R8_M6_0/A44_CAP_CORE128_M6_R1_0/CAP_BOTTOM_045 GND nfet_03v3 ad=0 pd=0 as=0 ps=0 w=1.56u l=0.28u
X2162 VREFP A44_DCTRL_STRIP_W_R2_0/CTRL_OUT[7] A44_CDAC_CAP_BANK_ASSEMBLY_R8_M6_0/A44_CAP_CORE128_M6_R1_0/CAP_BOTTOM_043 VDD pfet_03v3 ad=0 pd=0 as=16.6842p ps=77.76u w=1.56u l=0.28u
X2163 VREFP A44_DCTRL_STRIP_W_R2_0/CTRL_OUT[7] A44_CDAC_CAP_BANK_ASSEMBLY_R8_M6_0/A44_CAP_CORE128_M6_R1_0/CAP_BOTTOM_043 VDD pfet_03v3 ad=0 pd=0 as=0 ps=0 w=1.56u l=0.28u
X2164 VREFP A44_DCTRL_STRIP_W_R2_0/CTRL_OUT[7] A44_CDAC_CAP_BANK_ASSEMBLY_R8_M6_0/A44_CAP_CORE128_M6_R1_0/CAP_BOTTOM_043 VDD pfet_03v3 ad=0 pd=0 as=0 ps=0 w=1.56u l=0.28u
X2165 VREFP A44_DCTRL_STRIP_W_R2_0/CTRL_OUT[7] A44_CDAC_CAP_BANK_ASSEMBLY_R8_M6_0/A44_CAP_CORE128_M6_R1_0/CAP_BOTTOM_043 VDD pfet_03v3 ad=0 pd=0 as=0 ps=0 w=1.56u l=0.28u
X2166 VREFP A44_DCTRL_STRIP_W_R2_0/CTRL_OUT[7] A44_CDAC_CAP_BANK_ASSEMBLY_R8_M6_0/A44_CAP_CORE128_M6_R1_0/CAP_BOTTOM_043 VDD pfet_03v3 ad=0 pd=0 as=0 ps=0 w=1.56u l=0.28u
X2167 VREFP A44_DCTRL_STRIP_W_R2_0/CTRL_OUT[7] A44_CDAC_CAP_BANK_ASSEMBLY_R8_M6_0/A44_CAP_CORE128_M6_R1_0/CAP_BOTTOM_043 VDD pfet_03v3 ad=0 pd=0 as=0 ps=0 w=1.56u l=0.28u
X2168 VREFP A44_DCTRL_STRIP_W_R2_0/CTRL_OUT[7] A44_CDAC_CAP_BANK_ASSEMBLY_R8_M6_0/A44_CAP_CORE128_M6_R1_0/CAP_BOTTOM_043 VDD pfet_03v3 ad=0 pd=0 as=0 ps=0 w=1.56u l=0.28u
X2169 VREFP A44_DCTRL_STRIP_W_R2_0/CTRL_OUT[7] A44_CDAC_CAP_BANK_ASSEMBLY_R8_M6_0/A44_CAP_CORE128_M6_R1_0/CAP_BOTTOM_043 VDD pfet_03v3 ad=0 pd=0 as=0 ps=0 w=1.56u l=0.28u
X2170 VREFP A44_DCTRL_STRIP_W_R2_0/CTRL_OUT[7] A44_CDAC_CAP_BANK_ASSEMBLY_R8_M6_0/A44_CAP_CORE128_M6_R1_0/CAP_BOTTOM_043 VDD pfet_03v3 ad=0 pd=0 as=0 ps=0 w=1.56u l=0.28u
X2171 VREFP A44_DCTRL_STRIP_W_R2_0/CTRL_OUT[7] A44_CDAC_CAP_BANK_ASSEMBLY_R8_M6_0/A44_CAP_CORE128_M6_R1_0/CAP_BOTTOM_043 VDD pfet_03v3 ad=0 pd=0 as=0 ps=0 w=1.56u l=0.28u
X2172 VREFP A44_DCTRL_STRIP_W_R2_0/CTRL_OUT[7] A44_CDAC_CAP_BANK_ASSEMBLY_R8_M6_0/A44_CAP_CORE128_M6_R1_0/CAP_BOTTOM_043 VDD pfet_03v3 ad=0 pd=0 as=0 ps=0 w=1.56u l=0.28u
X2173 VREFP A44_DCTRL_STRIP_W_R2_0/CTRL_OUT[7] A44_CDAC_CAP_BANK_ASSEMBLY_R8_M6_0/A44_CAP_CORE128_M6_R1_0/CAP_BOTTOM_043 VDD pfet_03v3 ad=0 pd=0 as=0 ps=0 w=1.56u l=0.28u
X2174 VREFP A44_DCTRL_STRIP_W_R2_0/CTRL_OUT[7] A44_CDAC_CAP_BANK_ASSEMBLY_R8_M6_0/A44_CAP_CORE128_M6_R1_0/CAP_BOTTOM_043 VDD pfet_03v3 ad=0 pd=0 as=0 ps=0 w=1.56u l=0.28u
X2175 VREFP A44_DCTRL_STRIP_W_R2_0/CTRL_OUT[7] A44_CDAC_CAP_BANK_ASSEMBLY_R8_M6_0/A44_CAP_CORE128_M6_R1_0/CAP_BOTTOM_043 VDD pfet_03v3 ad=0 pd=0 as=0 ps=0 w=1.56u l=0.28u
X2176 VREFP A44_DCTRL_STRIP_W_R2_0/CTRL_OUT[7] A44_CDAC_CAP_BANK_ASSEMBLY_R8_M6_0/A44_CAP_CORE128_M6_R1_0/CAP_BOTTOM_043 VDD pfet_03v3 ad=0 pd=0 as=0 ps=0 w=1.56u l=0.28u
X2177 VREFP A44_DCTRL_STRIP_W_R2_0/CTRL_OUT[7] A44_CDAC_CAP_BANK_ASSEMBLY_R8_M6_0/A44_CAP_CORE128_M6_R1_0/CAP_BOTTOM_043 VDD pfet_03v3 ad=0 pd=0 as=0 ps=0 w=1.56u l=0.28u
X2178 VREFP A44_DCTRL_STRIP_W_R2_0/CTRL_OUT[7] A44_CDAC_CAP_BANK_ASSEMBLY_R8_M6_0/A44_CAP_CORE128_M6_R1_0/CAP_BOTTOM_043 VDD pfet_03v3 ad=0 pd=0 as=0 ps=0 w=1.56u l=0.28u
X2179 VREFP A44_DCTRL_STRIP_W_R2_0/CTRL_OUT[7] A44_CDAC_CAP_BANK_ASSEMBLY_R8_M6_0/A44_CAP_CORE128_M6_R1_0/CAP_BOTTOM_043 VDD pfet_03v3 ad=0 pd=0 as=0 ps=0 w=1.56u l=0.28u
X2180 VREFN A44_DCTRL_STRIP_W_R2_0/CTRL_OUT[7] A44_CDAC_CAP_BANK_ASSEMBLY_R8_M6_0/A44_CAP_CORE128_M6_R1_0/CAP_BOTTOM_043 GND nfet_03v3 ad=0 pd=0 as=16.6842p ps=77.76u w=1.56u l=0.28u
X2181 VREFN A44_DCTRL_STRIP_W_R2_0/CTRL_OUT[7] A44_CDAC_CAP_BANK_ASSEMBLY_R8_M6_0/A44_CAP_CORE128_M6_R1_0/CAP_BOTTOM_043 GND nfet_03v3 ad=0 pd=0 as=0 ps=0 w=1.56u l=0.28u
X2182 VREFN A44_DCTRL_STRIP_W_R2_0/CTRL_OUT[7] A44_CDAC_CAP_BANK_ASSEMBLY_R8_M6_0/A44_CAP_CORE128_M6_R1_0/CAP_BOTTOM_043 GND nfet_03v3 ad=0 pd=0 as=0 ps=0 w=1.56u l=0.28u
X2183 VREFN A44_DCTRL_STRIP_W_R2_0/CTRL_OUT[7] A44_CDAC_CAP_BANK_ASSEMBLY_R8_M6_0/A44_CAP_CORE128_M6_R1_0/CAP_BOTTOM_043 GND nfet_03v3 ad=0 pd=0 as=0 ps=0 w=1.56u l=0.28u
X2184 VREFN A44_DCTRL_STRIP_W_R2_0/CTRL_OUT[7] A44_CDAC_CAP_BANK_ASSEMBLY_R8_M6_0/A44_CAP_CORE128_M6_R1_0/CAP_BOTTOM_043 GND nfet_03v3 ad=0 pd=0 as=0 ps=0 w=1.56u l=0.28u
X2185 VREFN A44_DCTRL_STRIP_W_R2_0/CTRL_OUT[7] A44_CDAC_CAP_BANK_ASSEMBLY_R8_M6_0/A44_CAP_CORE128_M6_R1_0/CAP_BOTTOM_043 GND nfet_03v3 ad=0 pd=0 as=0 ps=0 w=1.56u l=0.28u
X2186 VREFN A44_DCTRL_STRIP_W_R2_0/CTRL_OUT[7] A44_CDAC_CAP_BANK_ASSEMBLY_R8_M6_0/A44_CAP_CORE128_M6_R1_0/CAP_BOTTOM_043 GND nfet_03v3 ad=0 pd=0 as=0 ps=0 w=1.56u l=0.28u
X2187 VREFN A44_DCTRL_STRIP_W_R2_0/CTRL_OUT[7] A44_CDAC_CAP_BANK_ASSEMBLY_R8_M6_0/A44_CAP_CORE128_M6_R1_0/CAP_BOTTOM_043 GND nfet_03v3 ad=0 pd=0 as=0 ps=0 w=1.56u l=0.28u
X2188 VREFN A44_DCTRL_STRIP_W_R2_0/CTRL_OUT[7] A44_CDAC_CAP_BANK_ASSEMBLY_R8_M6_0/A44_CAP_CORE128_M6_R1_0/CAP_BOTTOM_043 GND nfet_03v3 ad=0 pd=0 as=0 ps=0 w=1.56u l=0.28u
X2189 VREFN A44_DCTRL_STRIP_W_R2_0/CTRL_OUT[7] A44_CDAC_CAP_BANK_ASSEMBLY_R8_M6_0/A44_CAP_CORE128_M6_R1_0/CAP_BOTTOM_043 GND nfet_03v3 ad=0 pd=0 as=0 ps=0 w=1.56u l=0.28u
X2190 VREFN A44_DCTRL_STRIP_W_R2_0/CTRL_OUT[7] A44_CDAC_CAP_BANK_ASSEMBLY_R8_M6_0/A44_CAP_CORE128_M6_R1_0/CAP_BOTTOM_043 GND nfet_03v3 ad=0 pd=0 as=0 ps=0 w=1.56u l=0.28u
X2191 VREFN A44_DCTRL_STRIP_W_R2_0/CTRL_OUT[7] A44_CDAC_CAP_BANK_ASSEMBLY_R8_M6_0/A44_CAP_CORE128_M6_R1_0/CAP_BOTTOM_043 GND nfet_03v3 ad=0 pd=0 as=0 ps=0 w=1.56u l=0.28u
X2192 VREFN A44_DCTRL_STRIP_W_R2_0/CTRL_OUT[7] A44_CDAC_CAP_BANK_ASSEMBLY_R8_M6_0/A44_CAP_CORE128_M6_R1_0/CAP_BOTTOM_043 GND nfet_03v3 ad=0 pd=0 as=0 ps=0 w=1.56u l=0.28u
X2193 VREFN A44_DCTRL_STRIP_W_R2_0/CTRL_OUT[7] A44_CDAC_CAP_BANK_ASSEMBLY_R8_M6_0/A44_CAP_CORE128_M6_R1_0/CAP_BOTTOM_043 GND nfet_03v3 ad=0 pd=0 as=0 ps=0 w=1.56u l=0.28u
X2194 VREFN A44_DCTRL_STRIP_W_R2_0/CTRL_OUT[7] A44_CDAC_CAP_BANK_ASSEMBLY_R8_M6_0/A44_CAP_CORE128_M6_R1_0/CAP_BOTTOM_043 GND nfet_03v3 ad=0 pd=0 as=0 ps=0 w=1.56u l=0.28u
X2195 VREFN A44_DCTRL_STRIP_W_R2_0/CTRL_OUT[7] A44_CDAC_CAP_BANK_ASSEMBLY_R8_M6_0/A44_CAP_CORE128_M6_R1_0/CAP_BOTTOM_043 GND nfet_03v3 ad=0 pd=0 as=0 ps=0 w=1.56u l=0.28u
X2196 VREFN A44_DCTRL_STRIP_W_R2_0/CTRL_OUT[7] A44_CDAC_CAP_BANK_ASSEMBLY_R8_M6_0/A44_CAP_CORE128_M6_R1_0/CAP_BOTTOM_043 GND nfet_03v3 ad=0 pd=0 as=0 ps=0 w=1.56u l=0.28u
X2197 VREFN A44_DCTRL_STRIP_W_R2_0/CTRL_OUT[7] A44_CDAC_CAP_BANK_ASSEMBLY_R8_M6_0/A44_CAP_CORE128_M6_R1_0/CAP_BOTTOM_043 GND nfet_03v3 ad=0 pd=0 as=0 ps=0 w=1.56u l=0.28u
X2198 VREFP A44_DCTRL_STRIP_W_R2_0/CTRL_OUT[7] A44_CDAC_CAP_BANK_ASSEMBLY_R8_M6_0/A44_CAP_CORE128_M6_R1_0/CAP_BOTTOM_006 VDD pfet_03v3 ad=0 pd=0 as=16.6842p ps=77.76u w=1.56u l=0.28u
X2199 VREFP A44_DCTRL_STRIP_W_R2_0/CTRL_OUT[7] A44_CDAC_CAP_BANK_ASSEMBLY_R8_M6_0/A44_CAP_CORE128_M6_R1_0/CAP_BOTTOM_006 VDD pfet_03v3 ad=0 pd=0 as=0 ps=0 w=1.56u l=0.28u
X2200 VREFP A44_DCTRL_STRIP_W_R2_0/CTRL_OUT[7] A44_CDAC_CAP_BANK_ASSEMBLY_R8_M6_0/A44_CAP_CORE128_M6_R1_0/CAP_BOTTOM_006 VDD pfet_03v3 ad=0 pd=0 as=0 ps=0 w=1.56u l=0.28u
X2201 VREFP A44_DCTRL_STRIP_W_R2_0/CTRL_OUT[7] A44_CDAC_CAP_BANK_ASSEMBLY_R8_M6_0/A44_CAP_CORE128_M6_R1_0/CAP_BOTTOM_006 VDD pfet_03v3 ad=0 pd=0 as=0 ps=0 w=1.56u l=0.28u
X2202 VREFP A44_DCTRL_STRIP_W_R2_0/CTRL_OUT[7] A44_CDAC_CAP_BANK_ASSEMBLY_R8_M6_0/A44_CAP_CORE128_M6_R1_0/CAP_BOTTOM_006 VDD pfet_03v3 ad=0 pd=0 as=0 ps=0 w=1.56u l=0.28u
X2203 VREFP A44_DCTRL_STRIP_W_R2_0/CTRL_OUT[7] A44_CDAC_CAP_BANK_ASSEMBLY_R8_M6_0/A44_CAP_CORE128_M6_R1_0/CAP_BOTTOM_006 VDD pfet_03v3 ad=0 pd=0 as=0 ps=0 w=1.56u l=0.28u
X2204 VREFP A44_DCTRL_STRIP_W_R2_0/CTRL_OUT[7] A44_CDAC_CAP_BANK_ASSEMBLY_R8_M6_0/A44_CAP_CORE128_M6_R1_0/CAP_BOTTOM_006 VDD pfet_03v3 ad=0 pd=0 as=0 ps=0 w=1.56u l=0.28u
X2205 VREFP A44_DCTRL_STRIP_W_R2_0/CTRL_OUT[7] A44_CDAC_CAP_BANK_ASSEMBLY_R8_M6_0/A44_CAP_CORE128_M6_R1_0/CAP_BOTTOM_006 VDD pfet_03v3 ad=0 pd=0 as=0 ps=0 w=1.56u l=0.28u
X2206 VREFP A44_DCTRL_STRIP_W_R2_0/CTRL_OUT[7] A44_CDAC_CAP_BANK_ASSEMBLY_R8_M6_0/A44_CAP_CORE128_M6_R1_0/CAP_BOTTOM_006 VDD pfet_03v3 ad=0 pd=0 as=0 ps=0 w=1.56u l=0.28u
X2207 VREFP A44_DCTRL_STRIP_W_R2_0/CTRL_OUT[7] A44_CDAC_CAP_BANK_ASSEMBLY_R8_M6_0/A44_CAP_CORE128_M6_R1_0/CAP_BOTTOM_006 VDD pfet_03v3 ad=0 pd=0 as=0 ps=0 w=1.56u l=0.28u
X2208 VREFP A44_DCTRL_STRIP_W_R2_0/CTRL_OUT[7] A44_CDAC_CAP_BANK_ASSEMBLY_R8_M6_0/A44_CAP_CORE128_M6_R1_0/CAP_BOTTOM_006 VDD pfet_03v3 ad=0 pd=0 as=0 ps=0 w=1.56u l=0.28u
X2209 VREFP A44_DCTRL_STRIP_W_R2_0/CTRL_OUT[7] A44_CDAC_CAP_BANK_ASSEMBLY_R8_M6_0/A44_CAP_CORE128_M6_R1_0/CAP_BOTTOM_006 VDD pfet_03v3 ad=0 pd=0 as=0 ps=0 w=1.56u l=0.28u
X2210 VREFP A44_DCTRL_STRIP_W_R2_0/CTRL_OUT[7] A44_CDAC_CAP_BANK_ASSEMBLY_R8_M6_0/A44_CAP_CORE128_M6_R1_0/CAP_BOTTOM_006 VDD pfet_03v3 ad=0 pd=0 as=0 ps=0 w=1.56u l=0.28u
X2211 VREFP A44_DCTRL_STRIP_W_R2_0/CTRL_OUT[7] A44_CDAC_CAP_BANK_ASSEMBLY_R8_M6_0/A44_CAP_CORE128_M6_R1_0/CAP_BOTTOM_006 VDD pfet_03v3 ad=0 pd=0 as=0 ps=0 w=1.56u l=0.28u
X2212 VREFP A44_DCTRL_STRIP_W_R2_0/CTRL_OUT[7] A44_CDAC_CAP_BANK_ASSEMBLY_R8_M6_0/A44_CAP_CORE128_M6_R1_0/CAP_BOTTOM_006 VDD pfet_03v3 ad=0 pd=0 as=0 ps=0 w=1.56u l=0.28u
X2213 VREFP A44_DCTRL_STRIP_W_R2_0/CTRL_OUT[7] A44_CDAC_CAP_BANK_ASSEMBLY_R8_M6_0/A44_CAP_CORE128_M6_R1_0/CAP_BOTTOM_006 VDD pfet_03v3 ad=0 pd=0 as=0 ps=0 w=1.56u l=0.28u
X2214 VREFP A44_DCTRL_STRIP_W_R2_0/CTRL_OUT[7] A44_CDAC_CAP_BANK_ASSEMBLY_R8_M6_0/A44_CAP_CORE128_M6_R1_0/CAP_BOTTOM_006 VDD pfet_03v3 ad=0 pd=0 as=0 ps=0 w=1.56u l=0.28u
X2215 VREFP A44_DCTRL_STRIP_W_R2_0/CTRL_OUT[7] A44_CDAC_CAP_BANK_ASSEMBLY_R8_M6_0/A44_CAP_CORE128_M6_R1_0/CAP_BOTTOM_006 VDD pfet_03v3 ad=0 pd=0 as=0 ps=0 w=1.56u l=0.28u
X2216 VREFN A44_DCTRL_STRIP_W_R2_0/CTRL_OUT[7] A44_CDAC_CAP_BANK_ASSEMBLY_R8_M6_0/A44_CAP_CORE128_M6_R1_0/CAP_BOTTOM_006 GND nfet_03v3 ad=0 pd=0 as=16.6842p ps=77.76u w=1.56u l=0.28u
X2217 VREFN A44_DCTRL_STRIP_W_R2_0/CTRL_OUT[7] A44_CDAC_CAP_BANK_ASSEMBLY_R8_M6_0/A44_CAP_CORE128_M6_R1_0/CAP_BOTTOM_006 GND nfet_03v3 ad=0 pd=0 as=0 ps=0 w=1.56u l=0.28u
X2218 VREFN A44_DCTRL_STRIP_W_R2_0/CTRL_OUT[7] A44_CDAC_CAP_BANK_ASSEMBLY_R8_M6_0/A44_CAP_CORE128_M6_R1_0/CAP_BOTTOM_006 GND nfet_03v3 ad=0 pd=0 as=0 ps=0 w=1.56u l=0.28u
X2219 VREFN A44_DCTRL_STRIP_W_R2_0/CTRL_OUT[7] A44_CDAC_CAP_BANK_ASSEMBLY_R8_M6_0/A44_CAP_CORE128_M6_R1_0/CAP_BOTTOM_006 GND nfet_03v3 ad=0 pd=0 as=0 ps=0 w=1.56u l=0.28u
X2220 VREFN A44_DCTRL_STRIP_W_R2_0/CTRL_OUT[7] A44_CDAC_CAP_BANK_ASSEMBLY_R8_M6_0/A44_CAP_CORE128_M6_R1_0/CAP_BOTTOM_006 GND nfet_03v3 ad=0 pd=0 as=0 ps=0 w=1.56u l=0.28u
X2221 VREFN A44_DCTRL_STRIP_W_R2_0/CTRL_OUT[7] A44_CDAC_CAP_BANK_ASSEMBLY_R8_M6_0/A44_CAP_CORE128_M6_R1_0/CAP_BOTTOM_006 GND nfet_03v3 ad=0 pd=0 as=0 ps=0 w=1.56u l=0.28u
X2222 VREFN A44_DCTRL_STRIP_W_R2_0/CTRL_OUT[7] A44_CDAC_CAP_BANK_ASSEMBLY_R8_M6_0/A44_CAP_CORE128_M6_R1_0/CAP_BOTTOM_006 GND nfet_03v3 ad=0 pd=0 as=0 ps=0 w=1.56u l=0.28u
X2223 VREFN A44_DCTRL_STRIP_W_R2_0/CTRL_OUT[7] A44_CDAC_CAP_BANK_ASSEMBLY_R8_M6_0/A44_CAP_CORE128_M6_R1_0/CAP_BOTTOM_006 GND nfet_03v3 ad=0 pd=0 as=0 ps=0 w=1.56u l=0.28u
X2224 VREFN A44_DCTRL_STRIP_W_R2_0/CTRL_OUT[7] A44_CDAC_CAP_BANK_ASSEMBLY_R8_M6_0/A44_CAP_CORE128_M6_R1_0/CAP_BOTTOM_006 GND nfet_03v3 ad=0 pd=0 as=0 ps=0 w=1.56u l=0.28u
X2225 VREFN A44_DCTRL_STRIP_W_R2_0/CTRL_OUT[7] A44_CDAC_CAP_BANK_ASSEMBLY_R8_M6_0/A44_CAP_CORE128_M6_R1_0/CAP_BOTTOM_006 GND nfet_03v3 ad=0 pd=0 as=0 ps=0 w=1.56u l=0.28u
X2226 VREFN A44_DCTRL_STRIP_W_R2_0/CTRL_OUT[7] A44_CDAC_CAP_BANK_ASSEMBLY_R8_M6_0/A44_CAP_CORE128_M6_R1_0/CAP_BOTTOM_006 GND nfet_03v3 ad=0 pd=0 as=0 ps=0 w=1.56u l=0.28u
X2227 VREFN A44_DCTRL_STRIP_W_R2_0/CTRL_OUT[7] A44_CDAC_CAP_BANK_ASSEMBLY_R8_M6_0/A44_CAP_CORE128_M6_R1_0/CAP_BOTTOM_006 GND nfet_03v3 ad=0 pd=0 as=0 ps=0 w=1.56u l=0.28u
X2228 VREFN A44_DCTRL_STRIP_W_R2_0/CTRL_OUT[7] A44_CDAC_CAP_BANK_ASSEMBLY_R8_M6_0/A44_CAP_CORE128_M6_R1_0/CAP_BOTTOM_006 GND nfet_03v3 ad=0 pd=0 as=0 ps=0 w=1.56u l=0.28u
X2229 VREFN A44_DCTRL_STRIP_W_R2_0/CTRL_OUT[7] A44_CDAC_CAP_BANK_ASSEMBLY_R8_M6_0/A44_CAP_CORE128_M6_R1_0/CAP_BOTTOM_006 GND nfet_03v3 ad=0 pd=0 as=0 ps=0 w=1.56u l=0.28u
X2230 VREFN A44_DCTRL_STRIP_W_R2_0/CTRL_OUT[7] A44_CDAC_CAP_BANK_ASSEMBLY_R8_M6_0/A44_CAP_CORE128_M6_R1_0/CAP_BOTTOM_006 GND nfet_03v3 ad=0 pd=0 as=0 ps=0 w=1.56u l=0.28u
X2231 VREFN A44_DCTRL_STRIP_W_R2_0/CTRL_OUT[7] A44_CDAC_CAP_BANK_ASSEMBLY_R8_M6_0/A44_CAP_CORE128_M6_R1_0/CAP_BOTTOM_006 GND nfet_03v3 ad=0 pd=0 as=0 ps=0 w=1.56u l=0.28u
X2232 VREFN A44_DCTRL_STRIP_W_R2_0/CTRL_OUT[7] A44_CDAC_CAP_BANK_ASSEMBLY_R8_M6_0/A44_CAP_CORE128_M6_R1_0/CAP_BOTTOM_006 GND nfet_03v3 ad=0 pd=0 as=0 ps=0 w=1.56u l=0.28u
X2233 VREFN A44_DCTRL_STRIP_W_R2_0/CTRL_OUT[7] A44_CDAC_CAP_BANK_ASSEMBLY_R8_M6_0/A44_CAP_CORE128_M6_R1_0/CAP_BOTTOM_006 GND nfet_03v3 ad=0 pd=0 as=0 ps=0 w=1.56u l=0.28u
X2234 VREFP A44_DCTRL_STRIP_W_R2_0/CTRL_OUT[7] A44_CDAC_CAP_BANK_ASSEMBLY_R8_M6_0/A44_CAP_CORE128_M6_R1_0/CAP_BOTTOM_056 VDD pfet_03v3 ad=0 pd=0 as=16.6842p ps=77.76u w=1.56u l=0.28u
X2235 VREFP A44_DCTRL_STRIP_W_R2_0/CTRL_OUT[7] A44_CDAC_CAP_BANK_ASSEMBLY_R8_M6_0/A44_CAP_CORE128_M6_R1_0/CAP_BOTTOM_056 VDD pfet_03v3 ad=0 pd=0 as=0 ps=0 w=1.56u l=0.28u
X2236 VREFP A44_DCTRL_STRIP_W_R2_0/CTRL_OUT[7] A44_CDAC_CAP_BANK_ASSEMBLY_R8_M6_0/A44_CAP_CORE128_M6_R1_0/CAP_BOTTOM_056 VDD pfet_03v3 ad=0 pd=0 as=0 ps=0 w=1.56u l=0.28u
X2237 VREFP A44_DCTRL_STRIP_W_R2_0/CTRL_OUT[7] A44_CDAC_CAP_BANK_ASSEMBLY_R8_M6_0/A44_CAP_CORE128_M6_R1_0/CAP_BOTTOM_056 VDD pfet_03v3 ad=0 pd=0 as=0 ps=0 w=1.56u l=0.28u
X2238 VREFP A44_DCTRL_STRIP_W_R2_0/CTRL_OUT[7] A44_CDAC_CAP_BANK_ASSEMBLY_R8_M6_0/A44_CAP_CORE128_M6_R1_0/CAP_BOTTOM_056 VDD pfet_03v3 ad=0 pd=0 as=0 ps=0 w=1.56u l=0.28u
X2239 VREFP A44_DCTRL_STRIP_W_R2_0/CTRL_OUT[7] A44_CDAC_CAP_BANK_ASSEMBLY_R8_M6_0/A44_CAP_CORE128_M6_R1_0/CAP_BOTTOM_056 VDD pfet_03v3 ad=0 pd=0 as=0 ps=0 w=1.56u l=0.28u
X2240 VREFP A44_DCTRL_STRIP_W_R2_0/CTRL_OUT[7] A44_CDAC_CAP_BANK_ASSEMBLY_R8_M6_0/A44_CAP_CORE128_M6_R1_0/CAP_BOTTOM_056 VDD pfet_03v3 ad=0 pd=0 as=0 ps=0 w=1.56u l=0.28u
X2241 VREFP A44_DCTRL_STRIP_W_R2_0/CTRL_OUT[7] A44_CDAC_CAP_BANK_ASSEMBLY_R8_M6_0/A44_CAP_CORE128_M6_R1_0/CAP_BOTTOM_056 VDD pfet_03v3 ad=0 pd=0 as=0 ps=0 w=1.56u l=0.28u
X2242 VREFP A44_DCTRL_STRIP_W_R2_0/CTRL_OUT[7] A44_CDAC_CAP_BANK_ASSEMBLY_R8_M6_0/A44_CAP_CORE128_M6_R1_0/CAP_BOTTOM_056 VDD pfet_03v3 ad=0 pd=0 as=0 ps=0 w=1.56u l=0.28u
X2243 VREFP A44_DCTRL_STRIP_W_R2_0/CTRL_OUT[7] A44_CDAC_CAP_BANK_ASSEMBLY_R8_M6_0/A44_CAP_CORE128_M6_R1_0/CAP_BOTTOM_056 VDD pfet_03v3 ad=0 pd=0 as=0 ps=0 w=1.56u l=0.28u
X2244 VREFP A44_DCTRL_STRIP_W_R2_0/CTRL_OUT[7] A44_CDAC_CAP_BANK_ASSEMBLY_R8_M6_0/A44_CAP_CORE128_M6_R1_0/CAP_BOTTOM_056 VDD pfet_03v3 ad=0 pd=0 as=0 ps=0 w=1.56u l=0.28u
X2245 VREFP A44_DCTRL_STRIP_W_R2_0/CTRL_OUT[7] A44_CDAC_CAP_BANK_ASSEMBLY_R8_M6_0/A44_CAP_CORE128_M6_R1_0/CAP_BOTTOM_056 VDD pfet_03v3 ad=0 pd=0 as=0 ps=0 w=1.56u l=0.28u
X2246 VREFP A44_DCTRL_STRIP_W_R2_0/CTRL_OUT[7] A44_CDAC_CAP_BANK_ASSEMBLY_R8_M6_0/A44_CAP_CORE128_M6_R1_0/CAP_BOTTOM_056 VDD pfet_03v3 ad=0 pd=0 as=0 ps=0 w=1.56u l=0.28u
X2247 VREFP A44_DCTRL_STRIP_W_R2_0/CTRL_OUT[7] A44_CDAC_CAP_BANK_ASSEMBLY_R8_M6_0/A44_CAP_CORE128_M6_R1_0/CAP_BOTTOM_056 VDD pfet_03v3 ad=0 pd=0 as=0 ps=0 w=1.56u l=0.28u
X2248 VREFP A44_DCTRL_STRIP_W_R2_0/CTRL_OUT[7] A44_CDAC_CAP_BANK_ASSEMBLY_R8_M6_0/A44_CAP_CORE128_M6_R1_0/CAP_BOTTOM_056 VDD pfet_03v3 ad=0 pd=0 as=0 ps=0 w=1.56u l=0.28u
X2249 VREFP A44_DCTRL_STRIP_W_R2_0/CTRL_OUT[7] A44_CDAC_CAP_BANK_ASSEMBLY_R8_M6_0/A44_CAP_CORE128_M6_R1_0/CAP_BOTTOM_056 VDD pfet_03v3 ad=0 pd=0 as=0 ps=0 w=1.56u l=0.28u
X2250 VREFP A44_DCTRL_STRIP_W_R2_0/CTRL_OUT[7] A44_CDAC_CAP_BANK_ASSEMBLY_R8_M6_0/A44_CAP_CORE128_M6_R1_0/CAP_BOTTOM_056 VDD pfet_03v3 ad=0 pd=0 as=0 ps=0 w=1.56u l=0.28u
X2251 VREFP A44_DCTRL_STRIP_W_R2_0/CTRL_OUT[7] A44_CDAC_CAP_BANK_ASSEMBLY_R8_M6_0/A44_CAP_CORE128_M6_R1_0/CAP_BOTTOM_056 VDD pfet_03v3 ad=0 pd=0 as=0 ps=0 w=1.56u l=0.28u
X2252 VREFN A44_DCTRL_STRIP_W_R2_0/CTRL_OUT[7] A44_CDAC_CAP_BANK_ASSEMBLY_R8_M6_0/A44_CAP_CORE128_M6_R1_0/CAP_BOTTOM_056 GND nfet_03v3 ad=0 pd=0 as=16.6842p ps=77.76u w=1.56u l=0.28u
X2253 VREFN A44_DCTRL_STRIP_W_R2_0/CTRL_OUT[7] A44_CDAC_CAP_BANK_ASSEMBLY_R8_M6_0/A44_CAP_CORE128_M6_R1_0/CAP_BOTTOM_056 GND nfet_03v3 ad=0 pd=0 as=0 ps=0 w=1.56u l=0.28u
X2254 VREFN A44_DCTRL_STRIP_W_R2_0/CTRL_OUT[7] A44_CDAC_CAP_BANK_ASSEMBLY_R8_M6_0/A44_CAP_CORE128_M6_R1_0/CAP_BOTTOM_056 GND nfet_03v3 ad=0 pd=0 as=0 ps=0 w=1.56u l=0.28u
X2255 VREFN A44_DCTRL_STRIP_W_R2_0/CTRL_OUT[7] A44_CDAC_CAP_BANK_ASSEMBLY_R8_M6_0/A44_CAP_CORE128_M6_R1_0/CAP_BOTTOM_056 GND nfet_03v3 ad=0 pd=0 as=0 ps=0 w=1.56u l=0.28u
X2256 VREFN A44_DCTRL_STRIP_W_R2_0/CTRL_OUT[7] A44_CDAC_CAP_BANK_ASSEMBLY_R8_M6_0/A44_CAP_CORE128_M6_R1_0/CAP_BOTTOM_056 GND nfet_03v3 ad=0 pd=0 as=0 ps=0 w=1.56u l=0.28u
X2257 VREFN A44_DCTRL_STRIP_W_R2_0/CTRL_OUT[7] A44_CDAC_CAP_BANK_ASSEMBLY_R8_M6_0/A44_CAP_CORE128_M6_R1_0/CAP_BOTTOM_056 GND nfet_03v3 ad=0 pd=0 as=0 ps=0 w=1.56u l=0.28u
X2258 VREFN A44_DCTRL_STRIP_W_R2_0/CTRL_OUT[7] A44_CDAC_CAP_BANK_ASSEMBLY_R8_M6_0/A44_CAP_CORE128_M6_R1_0/CAP_BOTTOM_056 GND nfet_03v3 ad=0 pd=0 as=0 ps=0 w=1.56u l=0.28u
X2259 VREFN A44_DCTRL_STRIP_W_R2_0/CTRL_OUT[7] A44_CDAC_CAP_BANK_ASSEMBLY_R8_M6_0/A44_CAP_CORE128_M6_R1_0/CAP_BOTTOM_056 GND nfet_03v3 ad=0 pd=0 as=0 ps=0 w=1.56u l=0.28u
X2260 VREFN A44_DCTRL_STRIP_W_R2_0/CTRL_OUT[7] A44_CDAC_CAP_BANK_ASSEMBLY_R8_M6_0/A44_CAP_CORE128_M6_R1_0/CAP_BOTTOM_056 GND nfet_03v3 ad=0 pd=0 as=0 ps=0 w=1.56u l=0.28u
X2261 VREFN A44_DCTRL_STRIP_W_R2_0/CTRL_OUT[7] A44_CDAC_CAP_BANK_ASSEMBLY_R8_M6_0/A44_CAP_CORE128_M6_R1_0/CAP_BOTTOM_056 GND nfet_03v3 ad=0 pd=0 as=0 ps=0 w=1.56u l=0.28u
X2262 VREFN A44_DCTRL_STRIP_W_R2_0/CTRL_OUT[7] A44_CDAC_CAP_BANK_ASSEMBLY_R8_M6_0/A44_CAP_CORE128_M6_R1_0/CAP_BOTTOM_056 GND nfet_03v3 ad=0 pd=0 as=0 ps=0 w=1.56u l=0.28u
X2263 VREFN A44_DCTRL_STRIP_W_R2_0/CTRL_OUT[7] A44_CDAC_CAP_BANK_ASSEMBLY_R8_M6_0/A44_CAP_CORE128_M6_R1_0/CAP_BOTTOM_056 GND nfet_03v3 ad=0 pd=0 as=0 ps=0 w=1.56u l=0.28u
X2264 VREFN A44_DCTRL_STRIP_W_R2_0/CTRL_OUT[7] A44_CDAC_CAP_BANK_ASSEMBLY_R8_M6_0/A44_CAP_CORE128_M6_R1_0/CAP_BOTTOM_056 GND nfet_03v3 ad=0 pd=0 as=0 ps=0 w=1.56u l=0.28u
X2265 VREFN A44_DCTRL_STRIP_W_R2_0/CTRL_OUT[7] A44_CDAC_CAP_BANK_ASSEMBLY_R8_M6_0/A44_CAP_CORE128_M6_R1_0/CAP_BOTTOM_056 GND nfet_03v3 ad=0 pd=0 as=0 ps=0 w=1.56u l=0.28u
X2266 VREFN A44_DCTRL_STRIP_W_R2_0/CTRL_OUT[7] A44_CDAC_CAP_BANK_ASSEMBLY_R8_M6_0/A44_CAP_CORE128_M6_R1_0/CAP_BOTTOM_056 GND nfet_03v3 ad=0 pd=0 as=0 ps=0 w=1.56u l=0.28u
X2267 VREFN A44_DCTRL_STRIP_W_R2_0/CTRL_OUT[7] A44_CDAC_CAP_BANK_ASSEMBLY_R8_M6_0/A44_CAP_CORE128_M6_R1_0/CAP_BOTTOM_056 GND nfet_03v3 ad=0 pd=0 as=0 ps=0 w=1.56u l=0.28u
X2268 VREFN A44_DCTRL_STRIP_W_R2_0/CTRL_OUT[7] A44_CDAC_CAP_BANK_ASSEMBLY_R8_M6_0/A44_CAP_CORE128_M6_R1_0/CAP_BOTTOM_056 GND nfet_03v3 ad=0 pd=0 as=0 ps=0 w=1.56u l=0.28u
X2269 VREFN A44_DCTRL_STRIP_W_R2_0/CTRL_OUT[7] A44_CDAC_CAP_BANK_ASSEMBLY_R8_M6_0/A44_CAP_CORE128_M6_R1_0/CAP_BOTTOM_056 GND nfet_03v3 ad=0 pd=0 as=0 ps=0 w=1.56u l=0.28u
X2270 VREFP A44_DCTRL_STRIP_W_R2_0/CTRL_OUT[4] A44_CDAC_CAP_BANK_ASSEMBLY_R8_M6_0/A44_CAP_CORE128_M6_R1_0/CAP_BOTTOM_040 VDD pfet_03v3 ad=0 pd=0 as=16.6842p ps=77.76u w=1.56u l=0.28u
X2271 VREFP A44_DCTRL_STRIP_W_R2_0/CTRL_OUT[4] A44_CDAC_CAP_BANK_ASSEMBLY_R8_M6_0/A44_CAP_CORE128_M6_R1_0/CAP_BOTTOM_040 VDD pfet_03v3 ad=0 pd=0 as=0 ps=0 w=1.56u l=0.28u
X2272 VREFP A44_DCTRL_STRIP_W_R2_0/CTRL_OUT[4] A44_CDAC_CAP_BANK_ASSEMBLY_R8_M6_0/A44_CAP_CORE128_M6_R1_0/CAP_BOTTOM_040 VDD pfet_03v3 ad=0 pd=0 as=0 ps=0 w=1.56u l=0.28u
X2273 VREFP A44_DCTRL_STRIP_W_R2_0/CTRL_OUT[4] A44_CDAC_CAP_BANK_ASSEMBLY_R8_M6_0/A44_CAP_CORE128_M6_R1_0/CAP_BOTTOM_040 VDD pfet_03v3 ad=0 pd=0 as=0 ps=0 w=1.56u l=0.28u
X2274 VREFP A44_DCTRL_STRIP_W_R2_0/CTRL_OUT[4] A44_CDAC_CAP_BANK_ASSEMBLY_R8_M6_0/A44_CAP_CORE128_M6_R1_0/CAP_BOTTOM_040 VDD pfet_03v3 ad=0 pd=0 as=0 ps=0 w=1.56u l=0.28u
X2275 VREFP A44_DCTRL_STRIP_W_R2_0/CTRL_OUT[4] A44_CDAC_CAP_BANK_ASSEMBLY_R8_M6_0/A44_CAP_CORE128_M6_R1_0/CAP_BOTTOM_040 VDD pfet_03v3 ad=0 pd=0 as=0 ps=0 w=1.56u l=0.28u
X2276 VREFP A44_DCTRL_STRIP_W_R2_0/CTRL_OUT[4] A44_CDAC_CAP_BANK_ASSEMBLY_R8_M6_0/A44_CAP_CORE128_M6_R1_0/CAP_BOTTOM_040 VDD pfet_03v3 ad=0 pd=0 as=0 ps=0 w=1.56u l=0.28u
X2277 VREFP A44_DCTRL_STRIP_W_R2_0/CTRL_OUT[4] A44_CDAC_CAP_BANK_ASSEMBLY_R8_M6_0/A44_CAP_CORE128_M6_R1_0/CAP_BOTTOM_040 VDD pfet_03v3 ad=0 pd=0 as=0 ps=0 w=1.56u l=0.28u
X2278 VREFP A44_DCTRL_STRIP_W_R2_0/CTRL_OUT[4] A44_CDAC_CAP_BANK_ASSEMBLY_R8_M6_0/A44_CAP_CORE128_M6_R1_0/CAP_BOTTOM_040 VDD pfet_03v3 ad=0 pd=0 as=0 ps=0 w=1.56u l=0.28u
X2279 VREFP A44_DCTRL_STRIP_W_R2_0/CTRL_OUT[4] A44_CDAC_CAP_BANK_ASSEMBLY_R8_M6_0/A44_CAP_CORE128_M6_R1_0/CAP_BOTTOM_040 VDD pfet_03v3 ad=0 pd=0 as=0 ps=0 w=1.56u l=0.28u
X2280 VREFP A44_DCTRL_STRIP_W_R2_0/CTRL_OUT[4] A44_CDAC_CAP_BANK_ASSEMBLY_R8_M6_0/A44_CAP_CORE128_M6_R1_0/CAP_BOTTOM_040 VDD pfet_03v3 ad=0 pd=0 as=0 ps=0 w=1.56u l=0.28u
X2281 VREFP A44_DCTRL_STRIP_W_R2_0/CTRL_OUT[4] A44_CDAC_CAP_BANK_ASSEMBLY_R8_M6_0/A44_CAP_CORE128_M6_R1_0/CAP_BOTTOM_040 VDD pfet_03v3 ad=0 pd=0 as=0 ps=0 w=1.56u l=0.28u
X2282 VREFP A44_DCTRL_STRIP_W_R2_0/CTRL_OUT[4] A44_CDAC_CAP_BANK_ASSEMBLY_R8_M6_0/A44_CAP_CORE128_M6_R1_0/CAP_BOTTOM_040 VDD pfet_03v3 ad=0 pd=0 as=0 ps=0 w=1.56u l=0.28u
X2283 VREFP A44_DCTRL_STRIP_W_R2_0/CTRL_OUT[4] A44_CDAC_CAP_BANK_ASSEMBLY_R8_M6_0/A44_CAP_CORE128_M6_R1_0/CAP_BOTTOM_040 VDD pfet_03v3 ad=0 pd=0 as=0 ps=0 w=1.56u l=0.28u
X2284 VREFP A44_DCTRL_STRIP_W_R2_0/CTRL_OUT[4] A44_CDAC_CAP_BANK_ASSEMBLY_R8_M6_0/A44_CAP_CORE128_M6_R1_0/CAP_BOTTOM_040 VDD pfet_03v3 ad=0 pd=0 as=0 ps=0 w=1.56u l=0.28u
X2285 VREFP A44_DCTRL_STRIP_W_R2_0/CTRL_OUT[4] A44_CDAC_CAP_BANK_ASSEMBLY_R8_M6_0/A44_CAP_CORE128_M6_R1_0/CAP_BOTTOM_040 VDD pfet_03v3 ad=0 pd=0 as=0 ps=0 w=1.56u l=0.28u
X2286 VREFP A44_DCTRL_STRIP_W_R2_0/CTRL_OUT[4] A44_CDAC_CAP_BANK_ASSEMBLY_R8_M6_0/A44_CAP_CORE128_M6_R1_0/CAP_BOTTOM_040 VDD pfet_03v3 ad=0 pd=0 as=0 ps=0 w=1.56u l=0.28u
X2287 VREFP A44_DCTRL_STRIP_W_R2_0/CTRL_OUT[4] A44_CDAC_CAP_BANK_ASSEMBLY_R8_M6_0/A44_CAP_CORE128_M6_R1_0/CAP_BOTTOM_040 VDD pfet_03v3 ad=0 pd=0 as=0 ps=0 w=1.56u l=0.28u
X2288 VREFN A44_DCTRL_STRIP_W_R2_0/CTRL_OUT[4] A44_CDAC_CAP_BANK_ASSEMBLY_R8_M6_0/A44_CAP_CORE128_M6_R1_0/CAP_BOTTOM_040 GND nfet_03v3 ad=0 pd=0 as=16.6842p ps=77.76u w=1.56u l=0.28u
X2289 VREFN A44_DCTRL_STRIP_W_R2_0/CTRL_OUT[4] A44_CDAC_CAP_BANK_ASSEMBLY_R8_M6_0/A44_CAP_CORE128_M6_R1_0/CAP_BOTTOM_040 GND nfet_03v3 ad=0 pd=0 as=0 ps=0 w=1.56u l=0.28u
X2290 VREFN A44_DCTRL_STRIP_W_R2_0/CTRL_OUT[4] A44_CDAC_CAP_BANK_ASSEMBLY_R8_M6_0/A44_CAP_CORE128_M6_R1_0/CAP_BOTTOM_040 GND nfet_03v3 ad=0 pd=0 as=0 ps=0 w=1.56u l=0.28u
X2291 VREFN A44_DCTRL_STRIP_W_R2_0/CTRL_OUT[4] A44_CDAC_CAP_BANK_ASSEMBLY_R8_M6_0/A44_CAP_CORE128_M6_R1_0/CAP_BOTTOM_040 GND nfet_03v3 ad=0 pd=0 as=0 ps=0 w=1.56u l=0.28u
X2292 VREFN A44_DCTRL_STRIP_W_R2_0/CTRL_OUT[4] A44_CDAC_CAP_BANK_ASSEMBLY_R8_M6_0/A44_CAP_CORE128_M6_R1_0/CAP_BOTTOM_040 GND nfet_03v3 ad=0 pd=0 as=0 ps=0 w=1.56u l=0.28u
X2293 VREFN A44_DCTRL_STRIP_W_R2_0/CTRL_OUT[4] A44_CDAC_CAP_BANK_ASSEMBLY_R8_M6_0/A44_CAP_CORE128_M6_R1_0/CAP_BOTTOM_040 GND nfet_03v3 ad=0 pd=0 as=0 ps=0 w=1.56u l=0.28u
X2294 VREFN A44_DCTRL_STRIP_W_R2_0/CTRL_OUT[4] A44_CDAC_CAP_BANK_ASSEMBLY_R8_M6_0/A44_CAP_CORE128_M6_R1_0/CAP_BOTTOM_040 GND nfet_03v3 ad=0 pd=0 as=0 ps=0 w=1.56u l=0.28u
X2295 VREFN A44_DCTRL_STRIP_W_R2_0/CTRL_OUT[4] A44_CDAC_CAP_BANK_ASSEMBLY_R8_M6_0/A44_CAP_CORE128_M6_R1_0/CAP_BOTTOM_040 GND nfet_03v3 ad=0 pd=0 as=0 ps=0 w=1.56u l=0.28u
X2296 VREFN A44_DCTRL_STRIP_W_R2_0/CTRL_OUT[4] A44_CDAC_CAP_BANK_ASSEMBLY_R8_M6_0/A44_CAP_CORE128_M6_R1_0/CAP_BOTTOM_040 GND nfet_03v3 ad=0 pd=0 as=0 ps=0 w=1.56u l=0.28u
X2297 VREFN A44_DCTRL_STRIP_W_R2_0/CTRL_OUT[4] A44_CDAC_CAP_BANK_ASSEMBLY_R8_M6_0/A44_CAP_CORE128_M6_R1_0/CAP_BOTTOM_040 GND nfet_03v3 ad=0 pd=0 as=0 ps=0 w=1.56u l=0.28u
X2298 VREFN A44_DCTRL_STRIP_W_R2_0/CTRL_OUT[4] A44_CDAC_CAP_BANK_ASSEMBLY_R8_M6_0/A44_CAP_CORE128_M6_R1_0/CAP_BOTTOM_040 GND nfet_03v3 ad=0 pd=0 as=0 ps=0 w=1.56u l=0.28u
X2299 VREFN A44_DCTRL_STRIP_W_R2_0/CTRL_OUT[4] A44_CDAC_CAP_BANK_ASSEMBLY_R8_M6_0/A44_CAP_CORE128_M6_R1_0/CAP_BOTTOM_040 GND nfet_03v3 ad=0 pd=0 as=0 ps=0 w=1.56u l=0.28u
X2300 VREFN A44_DCTRL_STRIP_W_R2_0/CTRL_OUT[4] A44_CDAC_CAP_BANK_ASSEMBLY_R8_M6_0/A44_CAP_CORE128_M6_R1_0/CAP_BOTTOM_040 GND nfet_03v3 ad=0 pd=0 as=0 ps=0 w=1.56u l=0.28u
X2301 VREFN A44_DCTRL_STRIP_W_R2_0/CTRL_OUT[4] A44_CDAC_CAP_BANK_ASSEMBLY_R8_M6_0/A44_CAP_CORE128_M6_R1_0/CAP_BOTTOM_040 GND nfet_03v3 ad=0 pd=0 as=0 ps=0 w=1.56u l=0.28u
X2302 VREFN A44_DCTRL_STRIP_W_R2_0/CTRL_OUT[4] A44_CDAC_CAP_BANK_ASSEMBLY_R8_M6_0/A44_CAP_CORE128_M6_R1_0/CAP_BOTTOM_040 GND nfet_03v3 ad=0 pd=0 as=0 ps=0 w=1.56u l=0.28u
X2303 VREFN A44_DCTRL_STRIP_W_R2_0/CTRL_OUT[4] A44_CDAC_CAP_BANK_ASSEMBLY_R8_M6_0/A44_CAP_CORE128_M6_R1_0/CAP_BOTTOM_040 GND nfet_03v3 ad=0 pd=0 as=0 ps=0 w=1.56u l=0.28u
X2304 VREFN A44_DCTRL_STRIP_W_R2_0/CTRL_OUT[4] A44_CDAC_CAP_BANK_ASSEMBLY_R8_M6_0/A44_CAP_CORE128_M6_R1_0/CAP_BOTTOM_040 GND nfet_03v3 ad=0 pd=0 as=0 ps=0 w=1.56u l=0.28u
X2305 VREFN A44_DCTRL_STRIP_W_R2_0/CTRL_OUT[4] A44_CDAC_CAP_BANK_ASSEMBLY_R8_M6_0/A44_CAP_CORE128_M6_R1_0/CAP_BOTTOM_040 GND nfet_03v3 ad=0 pd=0 as=0 ps=0 w=1.56u l=0.28u
X2306 VREFP A44_DCTRL_STRIP_W_R2_0/CTRL_OUT[7] A44_CDAC_CAP_BANK_ASSEMBLY_R8_M6_0/A44_CAP_CORE128_M6_R1_0/CAP_BOTTOM_027 VDD pfet_03v3 ad=0 pd=0 as=16.6842p ps=77.76u w=1.56u l=0.28u
X2307 VREFP A44_DCTRL_STRIP_W_R2_0/CTRL_OUT[7] A44_CDAC_CAP_BANK_ASSEMBLY_R8_M6_0/A44_CAP_CORE128_M6_R1_0/CAP_BOTTOM_027 VDD pfet_03v3 ad=0 pd=0 as=0 ps=0 w=1.56u l=0.28u
X2308 VREFP A44_DCTRL_STRIP_W_R2_0/CTRL_OUT[7] A44_CDAC_CAP_BANK_ASSEMBLY_R8_M6_0/A44_CAP_CORE128_M6_R1_0/CAP_BOTTOM_027 VDD pfet_03v3 ad=0 pd=0 as=0 ps=0 w=1.56u l=0.28u
X2309 VREFP A44_DCTRL_STRIP_W_R2_0/CTRL_OUT[7] A44_CDAC_CAP_BANK_ASSEMBLY_R8_M6_0/A44_CAP_CORE128_M6_R1_0/CAP_BOTTOM_027 VDD pfet_03v3 ad=0 pd=0 as=0 ps=0 w=1.56u l=0.28u
X2310 VREFP A44_DCTRL_STRIP_W_R2_0/CTRL_OUT[7] A44_CDAC_CAP_BANK_ASSEMBLY_R8_M6_0/A44_CAP_CORE128_M6_R1_0/CAP_BOTTOM_027 VDD pfet_03v3 ad=0 pd=0 as=0 ps=0 w=1.56u l=0.28u
X2311 VREFP A44_DCTRL_STRIP_W_R2_0/CTRL_OUT[7] A44_CDAC_CAP_BANK_ASSEMBLY_R8_M6_0/A44_CAP_CORE128_M6_R1_0/CAP_BOTTOM_027 VDD pfet_03v3 ad=0 pd=0 as=0 ps=0 w=1.56u l=0.28u
X2312 VREFP A44_DCTRL_STRIP_W_R2_0/CTRL_OUT[7] A44_CDAC_CAP_BANK_ASSEMBLY_R8_M6_0/A44_CAP_CORE128_M6_R1_0/CAP_BOTTOM_027 VDD pfet_03v3 ad=0 pd=0 as=0 ps=0 w=1.56u l=0.28u
X2313 VREFP A44_DCTRL_STRIP_W_R2_0/CTRL_OUT[7] A44_CDAC_CAP_BANK_ASSEMBLY_R8_M6_0/A44_CAP_CORE128_M6_R1_0/CAP_BOTTOM_027 VDD pfet_03v3 ad=0 pd=0 as=0 ps=0 w=1.56u l=0.28u
X2314 VREFP A44_DCTRL_STRIP_W_R2_0/CTRL_OUT[7] A44_CDAC_CAP_BANK_ASSEMBLY_R8_M6_0/A44_CAP_CORE128_M6_R1_0/CAP_BOTTOM_027 VDD pfet_03v3 ad=0 pd=0 as=0 ps=0 w=1.56u l=0.28u
X2315 VREFP A44_DCTRL_STRIP_W_R2_0/CTRL_OUT[7] A44_CDAC_CAP_BANK_ASSEMBLY_R8_M6_0/A44_CAP_CORE128_M6_R1_0/CAP_BOTTOM_027 VDD pfet_03v3 ad=0 pd=0 as=0 ps=0 w=1.56u l=0.28u
X2316 VREFP A44_DCTRL_STRIP_W_R2_0/CTRL_OUT[7] A44_CDAC_CAP_BANK_ASSEMBLY_R8_M6_0/A44_CAP_CORE128_M6_R1_0/CAP_BOTTOM_027 VDD pfet_03v3 ad=0 pd=0 as=0 ps=0 w=1.56u l=0.28u
X2317 VREFP A44_DCTRL_STRIP_W_R2_0/CTRL_OUT[7] A44_CDAC_CAP_BANK_ASSEMBLY_R8_M6_0/A44_CAP_CORE128_M6_R1_0/CAP_BOTTOM_027 VDD pfet_03v3 ad=0 pd=0 as=0 ps=0 w=1.56u l=0.28u
X2318 VREFP A44_DCTRL_STRIP_W_R2_0/CTRL_OUT[7] A44_CDAC_CAP_BANK_ASSEMBLY_R8_M6_0/A44_CAP_CORE128_M6_R1_0/CAP_BOTTOM_027 VDD pfet_03v3 ad=0 pd=0 as=0 ps=0 w=1.56u l=0.28u
X2319 VREFP A44_DCTRL_STRIP_W_R2_0/CTRL_OUT[7] A44_CDAC_CAP_BANK_ASSEMBLY_R8_M6_0/A44_CAP_CORE128_M6_R1_0/CAP_BOTTOM_027 VDD pfet_03v3 ad=0 pd=0 as=0 ps=0 w=1.56u l=0.28u
X2320 VREFP A44_DCTRL_STRIP_W_R2_0/CTRL_OUT[7] A44_CDAC_CAP_BANK_ASSEMBLY_R8_M6_0/A44_CAP_CORE128_M6_R1_0/CAP_BOTTOM_027 VDD pfet_03v3 ad=0 pd=0 as=0 ps=0 w=1.56u l=0.28u
X2321 VREFP A44_DCTRL_STRIP_W_R2_0/CTRL_OUT[7] A44_CDAC_CAP_BANK_ASSEMBLY_R8_M6_0/A44_CAP_CORE128_M6_R1_0/CAP_BOTTOM_027 VDD pfet_03v3 ad=0 pd=0 as=0 ps=0 w=1.56u l=0.28u
X2322 VREFP A44_DCTRL_STRIP_W_R2_0/CTRL_OUT[7] A44_CDAC_CAP_BANK_ASSEMBLY_R8_M6_0/A44_CAP_CORE128_M6_R1_0/CAP_BOTTOM_027 VDD pfet_03v3 ad=0 pd=0 as=0 ps=0 w=1.56u l=0.28u
X2323 VREFP A44_DCTRL_STRIP_W_R2_0/CTRL_OUT[7] A44_CDAC_CAP_BANK_ASSEMBLY_R8_M6_0/A44_CAP_CORE128_M6_R1_0/CAP_BOTTOM_027 VDD pfet_03v3 ad=0 pd=0 as=0 ps=0 w=1.56u l=0.28u
X2324 VREFN A44_DCTRL_STRIP_W_R2_0/CTRL_OUT[7] A44_CDAC_CAP_BANK_ASSEMBLY_R8_M6_0/A44_CAP_CORE128_M6_R1_0/CAP_BOTTOM_027 GND nfet_03v3 ad=0 pd=0 as=16.6842p ps=77.76u w=1.56u l=0.28u
X2325 VREFN A44_DCTRL_STRIP_W_R2_0/CTRL_OUT[7] A44_CDAC_CAP_BANK_ASSEMBLY_R8_M6_0/A44_CAP_CORE128_M6_R1_0/CAP_BOTTOM_027 GND nfet_03v3 ad=0 pd=0 as=0 ps=0 w=1.56u l=0.28u
X2326 VREFN A44_DCTRL_STRIP_W_R2_0/CTRL_OUT[7] A44_CDAC_CAP_BANK_ASSEMBLY_R8_M6_0/A44_CAP_CORE128_M6_R1_0/CAP_BOTTOM_027 GND nfet_03v3 ad=0 pd=0 as=0 ps=0 w=1.56u l=0.28u
X2327 VREFN A44_DCTRL_STRIP_W_R2_0/CTRL_OUT[7] A44_CDAC_CAP_BANK_ASSEMBLY_R8_M6_0/A44_CAP_CORE128_M6_R1_0/CAP_BOTTOM_027 GND nfet_03v3 ad=0 pd=0 as=0 ps=0 w=1.56u l=0.28u
X2328 VREFN A44_DCTRL_STRIP_W_R2_0/CTRL_OUT[7] A44_CDAC_CAP_BANK_ASSEMBLY_R8_M6_0/A44_CAP_CORE128_M6_R1_0/CAP_BOTTOM_027 GND nfet_03v3 ad=0 pd=0 as=0 ps=0 w=1.56u l=0.28u
X2329 VREFN A44_DCTRL_STRIP_W_R2_0/CTRL_OUT[7] A44_CDAC_CAP_BANK_ASSEMBLY_R8_M6_0/A44_CAP_CORE128_M6_R1_0/CAP_BOTTOM_027 GND nfet_03v3 ad=0 pd=0 as=0 ps=0 w=1.56u l=0.28u
X2330 VREFN A44_DCTRL_STRIP_W_R2_0/CTRL_OUT[7] A44_CDAC_CAP_BANK_ASSEMBLY_R8_M6_0/A44_CAP_CORE128_M6_R1_0/CAP_BOTTOM_027 GND nfet_03v3 ad=0 pd=0 as=0 ps=0 w=1.56u l=0.28u
X2331 VREFN A44_DCTRL_STRIP_W_R2_0/CTRL_OUT[7] A44_CDAC_CAP_BANK_ASSEMBLY_R8_M6_0/A44_CAP_CORE128_M6_R1_0/CAP_BOTTOM_027 GND nfet_03v3 ad=0 pd=0 as=0 ps=0 w=1.56u l=0.28u
X2332 VREFN A44_DCTRL_STRIP_W_R2_0/CTRL_OUT[7] A44_CDAC_CAP_BANK_ASSEMBLY_R8_M6_0/A44_CAP_CORE128_M6_R1_0/CAP_BOTTOM_027 GND nfet_03v3 ad=0 pd=0 as=0 ps=0 w=1.56u l=0.28u
X2333 VREFN A44_DCTRL_STRIP_W_R2_0/CTRL_OUT[7] A44_CDAC_CAP_BANK_ASSEMBLY_R8_M6_0/A44_CAP_CORE128_M6_R1_0/CAP_BOTTOM_027 GND nfet_03v3 ad=0 pd=0 as=0 ps=0 w=1.56u l=0.28u
X2334 VREFN A44_DCTRL_STRIP_W_R2_0/CTRL_OUT[7] A44_CDAC_CAP_BANK_ASSEMBLY_R8_M6_0/A44_CAP_CORE128_M6_R1_0/CAP_BOTTOM_027 GND nfet_03v3 ad=0 pd=0 as=0 ps=0 w=1.56u l=0.28u
X2335 VREFN A44_DCTRL_STRIP_W_R2_0/CTRL_OUT[7] A44_CDAC_CAP_BANK_ASSEMBLY_R8_M6_0/A44_CAP_CORE128_M6_R1_0/CAP_BOTTOM_027 GND nfet_03v3 ad=0 pd=0 as=0 ps=0 w=1.56u l=0.28u
X2336 VREFN A44_DCTRL_STRIP_W_R2_0/CTRL_OUT[7] A44_CDAC_CAP_BANK_ASSEMBLY_R8_M6_0/A44_CAP_CORE128_M6_R1_0/CAP_BOTTOM_027 GND nfet_03v3 ad=0 pd=0 as=0 ps=0 w=1.56u l=0.28u
X2337 VREFN A44_DCTRL_STRIP_W_R2_0/CTRL_OUT[7] A44_CDAC_CAP_BANK_ASSEMBLY_R8_M6_0/A44_CAP_CORE128_M6_R1_0/CAP_BOTTOM_027 GND nfet_03v3 ad=0 pd=0 as=0 ps=0 w=1.56u l=0.28u
X2338 VREFN A44_DCTRL_STRIP_W_R2_0/CTRL_OUT[7] A44_CDAC_CAP_BANK_ASSEMBLY_R8_M6_0/A44_CAP_CORE128_M6_R1_0/CAP_BOTTOM_027 GND nfet_03v3 ad=0 pd=0 as=0 ps=0 w=1.56u l=0.28u
X2339 VREFN A44_DCTRL_STRIP_W_R2_0/CTRL_OUT[7] A44_CDAC_CAP_BANK_ASSEMBLY_R8_M6_0/A44_CAP_CORE128_M6_R1_0/CAP_BOTTOM_027 GND nfet_03v3 ad=0 pd=0 as=0 ps=0 w=1.56u l=0.28u
X2340 VREFN A44_DCTRL_STRIP_W_R2_0/CTRL_OUT[7] A44_CDAC_CAP_BANK_ASSEMBLY_R8_M6_0/A44_CAP_CORE128_M6_R1_0/CAP_BOTTOM_027 GND nfet_03v3 ad=0 pd=0 as=0 ps=0 w=1.56u l=0.28u
X2341 VREFN A44_DCTRL_STRIP_W_R2_0/CTRL_OUT[7] A44_CDAC_CAP_BANK_ASSEMBLY_R8_M6_0/A44_CAP_CORE128_M6_R1_0/CAP_BOTTOM_027 GND nfet_03v3 ad=0 pd=0 as=0 ps=0 w=1.56u l=0.28u
X2342 VREFP A44_DCTRL_STRIP_W_R2_0/CTRL_OUT[6] A44_CDAC_CAP_BANK_ASSEMBLY_R8_M6_0/A44_CAP_CORE128_M6_R1_0/CAP_BOTTOM_011 VDD pfet_03v3 ad=0 pd=0 as=16.6842p ps=77.76u w=1.56u l=0.28u
X2343 VREFP A44_DCTRL_STRIP_W_R2_0/CTRL_OUT[6] A44_CDAC_CAP_BANK_ASSEMBLY_R8_M6_0/A44_CAP_CORE128_M6_R1_0/CAP_BOTTOM_011 VDD pfet_03v3 ad=0 pd=0 as=0 ps=0 w=1.56u l=0.28u
X2344 VREFP A44_DCTRL_STRIP_W_R2_0/CTRL_OUT[6] A44_CDAC_CAP_BANK_ASSEMBLY_R8_M6_0/A44_CAP_CORE128_M6_R1_0/CAP_BOTTOM_011 VDD pfet_03v3 ad=0 pd=0 as=0 ps=0 w=1.56u l=0.28u
X2345 VREFP A44_DCTRL_STRIP_W_R2_0/CTRL_OUT[6] A44_CDAC_CAP_BANK_ASSEMBLY_R8_M6_0/A44_CAP_CORE128_M6_R1_0/CAP_BOTTOM_011 VDD pfet_03v3 ad=0 pd=0 as=0 ps=0 w=1.56u l=0.28u
X2346 VREFP A44_DCTRL_STRIP_W_R2_0/CTRL_OUT[6] A44_CDAC_CAP_BANK_ASSEMBLY_R8_M6_0/A44_CAP_CORE128_M6_R1_0/CAP_BOTTOM_011 VDD pfet_03v3 ad=0 pd=0 as=0 ps=0 w=1.56u l=0.28u
X2347 VREFP A44_DCTRL_STRIP_W_R2_0/CTRL_OUT[6] A44_CDAC_CAP_BANK_ASSEMBLY_R8_M6_0/A44_CAP_CORE128_M6_R1_0/CAP_BOTTOM_011 VDD pfet_03v3 ad=0 pd=0 as=0 ps=0 w=1.56u l=0.28u
X2348 VREFP A44_DCTRL_STRIP_W_R2_0/CTRL_OUT[6] A44_CDAC_CAP_BANK_ASSEMBLY_R8_M6_0/A44_CAP_CORE128_M6_R1_0/CAP_BOTTOM_011 VDD pfet_03v3 ad=0 pd=0 as=0 ps=0 w=1.56u l=0.28u
X2349 VREFP A44_DCTRL_STRIP_W_R2_0/CTRL_OUT[6] A44_CDAC_CAP_BANK_ASSEMBLY_R8_M6_0/A44_CAP_CORE128_M6_R1_0/CAP_BOTTOM_011 VDD pfet_03v3 ad=0 pd=0 as=0 ps=0 w=1.56u l=0.28u
X2350 VREFP A44_DCTRL_STRIP_W_R2_0/CTRL_OUT[6] A44_CDAC_CAP_BANK_ASSEMBLY_R8_M6_0/A44_CAP_CORE128_M6_R1_0/CAP_BOTTOM_011 VDD pfet_03v3 ad=0 pd=0 as=0 ps=0 w=1.56u l=0.28u
X2351 VREFP A44_DCTRL_STRIP_W_R2_0/CTRL_OUT[6] A44_CDAC_CAP_BANK_ASSEMBLY_R8_M6_0/A44_CAP_CORE128_M6_R1_0/CAP_BOTTOM_011 VDD pfet_03v3 ad=0 pd=0 as=0 ps=0 w=1.56u l=0.28u
X2352 VREFP A44_DCTRL_STRIP_W_R2_0/CTRL_OUT[6] A44_CDAC_CAP_BANK_ASSEMBLY_R8_M6_0/A44_CAP_CORE128_M6_R1_0/CAP_BOTTOM_011 VDD pfet_03v3 ad=0 pd=0 as=0 ps=0 w=1.56u l=0.28u
X2353 VREFP A44_DCTRL_STRIP_W_R2_0/CTRL_OUT[6] A44_CDAC_CAP_BANK_ASSEMBLY_R8_M6_0/A44_CAP_CORE128_M6_R1_0/CAP_BOTTOM_011 VDD pfet_03v3 ad=0 pd=0 as=0 ps=0 w=1.56u l=0.28u
X2354 VREFP A44_DCTRL_STRIP_W_R2_0/CTRL_OUT[6] A44_CDAC_CAP_BANK_ASSEMBLY_R8_M6_0/A44_CAP_CORE128_M6_R1_0/CAP_BOTTOM_011 VDD pfet_03v3 ad=0 pd=0 as=0 ps=0 w=1.56u l=0.28u
X2355 VREFP A44_DCTRL_STRIP_W_R2_0/CTRL_OUT[6] A44_CDAC_CAP_BANK_ASSEMBLY_R8_M6_0/A44_CAP_CORE128_M6_R1_0/CAP_BOTTOM_011 VDD pfet_03v3 ad=0 pd=0 as=0 ps=0 w=1.56u l=0.28u
X2356 VREFP A44_DCTRL_STRIP_W_R2_0/CTRL_OUT[6] A44_CDAC_CAP_BANK_ASSEMBLY_R8_M6_0/A44_CAP_CORE128_M6_R1_0/CAP_BOTTOM_011 VDD pfet_03v3 ad=0 pd=0 as=0 ps=0 w=1.56u l=0.28u
X2357 VREFP A44_DCTRL_STRIP_W_R2_0/CTRL_OUT[6] A44_CDAC_CAP_BANK_ASSEMBLY_R8_M6_0/A44_CAP_CORE128_M6_R1_0/CAP_BOTTOM_011 VDD pfet_03v3 ad=0 pd=0 as=0 ps=0 w=1.56u l=0.28u
X2358 VREFP A44_DCTRL_STRIP_W_R2_0/CTRL_OUT[6] A44_CDAC_CAP_BANK_ASSEMBLY_R8_M6_0/A44_CAP_CORE128_M6_R1_0/CAP_BOTTOM_011 VDD pfet_03v3 ad=0 pd=0 as=0 ps=0 w=1.56u l=0.28u
X2359 VREFP A44_DCTRL_STRIP_W_R2_0/CTRL_OUT[6] A44_CDAC_CAP_BANK_ASSEMBLY_R8_M6_0/A44_CAP_CORE128_M6_R1_0/CAP_BOTTOM_011 VDD pfet_03v3 ad=0 pd=0 as=0 ps=0 w=1.56u l=0.28u
X2360 VREFN A44_DCTRL_STRIP_W_R2_0/CTRL_OUT[6] A44_CDAC_CAP_BANK_ASSEMBLY_R8_M6_0/A44_CAP_CORE128_M6_R1_0/CAP_BOTTOM_011 GND nfet_03v3 ad=0 pd=0 as=16.6842p ps=77.76u w=1.56u l=0.28u
X2361 VREFN A44_DCTRL_STRIP_W_R2_0/CTRL_OUT[6] A44_CDAC_CAP_BANK_ASSEMBLY_R8_M6_0/A44_CAP_CORE128_M6_R1_0/CAP_BOTTOM_011 GND nfet_03v3 ad=0 pd=0 as=0 ps=0 w=1.56u l=0.28u
X2362 VREFN A44_DCTRL_STRIP_W_R2_0/CTRL_OUT[6] A44_CDAC_CAP_BANK_ASSEMBLY_R8_M6_0/A44_CAP_CORE128_M6_R1_0/CAP_BOTTOM_011 GND nfet_03v3 ad=0 pd=0 as=0 ps=0 w=1.56u l=0.28u
X2363 VREFN A44_DCTRL_STRIP_W_R2_0/CTRL_OUT[6] A44_CDAC_CAP_BANK_ASSEMBLY_R8_M6_0/A44_CAP_CORE128_M6_R1_0/CAP_BOTTOM_011 GND nfet_03v3 ad=0 pd=0 as=0 ps=0 w=1.56u l=0.28u
X2364 VREFN A44_DCTRL_STRIP_W_R2_0/CTRL_OUT[6] A44_CDAC_CAP_BANK_ASSEMBLY_R8_M6_0/A44_CAP_CORE128_M6_R1_0/CAP_BOTTOM_011 GND nfet_03v3 ad=0 pd=0 as=0 ps=0 w=1.56u l=0.28u
X2365 VREFN A44_DCTRL_STRIP_W_R2_0/CTRL_OUT[6] A44_CDAC_CAP_BANK_ASSEMBLY_R8_M6_0/A44_CAP_CORE128_M6_R1_0/CAP_BOTTOM_011 GND nfet_03v3 ad=0 pd=0 as=0 ps=0 w=1.56u l=0.28u
X2366 VREFN A44_DCTRL_STRIP_W_R2_0/CTRL_OUT[6] A44_CDAC_CAP_BANK_ASSEMBLY_R8_M6_0/A44_CAP_CORE128_M6_R1_0/CAP_BOTTOM_011 GND nfet_03v3 ad=0 pd=0 as=0 ps=0 w=1.56u l=0.28u
X2367 VREFN A44_DCTRL_STRIP_W_R2_0/CTRL_OUT[6] A44_CDAC_CAP_BANK_ASSEMBLY_R8_M6_0/A44_CAP_CORE128_M6_R1_0/CAP_BOTTOM_011 GND nfet_03v3 ad=0 pd=0 as=0 ps=0 w=1.56u l=0.28u
X2368 VREFN A44_DCTRL_STRIP_W_R2_0/CTRL_OUT[6] A44_CDAC_CAP_BANK_ASSEMBLY_R8_M6_0/A44_CAP_CORE128_M6_R1_0/CAP_BOTTOM_011 GND nfet_03v3 ad=0 pd=0 as=0 ps=0 w=1.56u l=0.28u
X2369 VREFN A44_DCTRL_STRIP_W_R2_0/CTRL_OUT[6] A44_CDAC_CAP_BANK_ASSEMBLY_R8_M6_0/A44_CAP_CORE128_M6_R1_0/CAP_BOTTOM_011 GND nfet_03v3 ad=0 pd=0 as=0 ps=0 w=1.56u l=0.28u
X2370 VREFN A44_DCTRL_STRIP_W_R2_0/CTRL_OUT[6] A44_CDAC_CAP_BANK_ASSEMBLY_R8_M6_0/A44_CAP_CORE128_M6_R1_0/CAP_BOTTOM_011 GND nfet_03v3 ad=0 pd=0 as=0 ps=0 w=1.56u l=0.28u
X2371 VREFN A44_DCTRL_STRIP_W_R2_0/CTRL_OUT[6] A44_CDAC_CAP_BANK_ASSEMBLY_R8_M6_0/A44_CAP_CORE128_M6_R1_0/CAP_BOTTOM_011 GND nfet_03v3 ad=0 pd=0 as=0 ps=0 w=1.56u l=0.28u
X2372 VREFN A44_DCTRL_STRIP_W_R2_0/CTRL_OUT[6] A44_CDAC_CAP_BANK_ASSEMBLY_R8_M6_0/A44_CAP_CORE128_M6_R1_0/CAP_BOTTOM_011 GND nfet_03v3 ad=0 pd=0 as=0 ps=0 w=1.56u l=0.28u
X2373 VREFN A44_DCTRL_STRIP_W_R2_0/CTRL_OUT[6] A44_CDAC_CAP_BANK_ASSEMBLY_R8_M6_0/A44_CAP_CORE128_M6_R1_0/CAP_BOTTOM_011 GND nfet_03v3 ad=0 pd=0 as=0 ps=0 w=1.56u l=0.28u
X2374 VREFN A44_DCTRL_STRIP_W_R2_0/CTRL_OUT[6] A44_CDAC_CAP_BANK_ASSEMBLY_R8_M6_0/A44_CAP_CORE128_M6_R1_0/CAP_BOTTOM_011 GND nfet_03v3 ad=0 pd=0 as=0 ps=0 w=1.56u l=0.28u
X2375 VREFN A44_DCTRL_STRIP_W_R2_0/CTRL_OUT[6] A44_CDAC_CAP_BANK_ASSEMBLY_R8_M6_0/A44_CAP_CORE128_M6_R1_0/CAP_BOTTOM_011 GND nfet_03v3 ad=0 pd=0 as=0 ps=0 w=1.56u l=0.28u
X2376 VREFN A44_DCTRL_STRIP_W_R2_0/CTRL_OUT[6] A44_CDAC_CAP_BANK_ASSEMBLY_R8_M6_0/A44_CAP_CORE128_M6_R1_0/CAP_BOTTOM_011 GND nfet_03v3 ad=0 pd=0 as=0 ps=0 w=1.56u l=0.28u
X2377 VREFN A44_DCTRL_STRIP_W_R2_0/CTRL_OUT[6] A44_CDAC_CAP_BANK_ASSEMBLY_R8_M6_0/A44_CAP_CORE128_M6_R1_0/CAP_BOTTOM_011 GND nfet_03v3 ad=0 pd=0 as=0 ps=0 w=1.56u l=0.28u
X2378 VREFP A44_DCTRL_STRIP_W_R2_0/CTRL_OUT[7] A44_CDAC_CAP_BANK_ASSEMBLY_R8_M6_0/A44_CAP_CORE128_M6_R1_0/CAP_BOTTOM_095 VDD pfet_03v3 ad=0 pd=0 as=16.6842p ps=77.76u w=1.56u l=0.28u
X2379 VREFP A44_DCTRL_STRIP_W_R2_0/CTRL_OUT[7] A44_CDAC_CAP_BANK_ASSEMBLY_R8_M6_0/A44_CAP_CORE128_M6_R1_0/CAP_BOTTOM_095 VDD pfet_03v3 ad=0 pd=0 as=0 ps=0 w=1.56u l=0.28u
X2380 VREFP A44_DCTRL_STRIP_W_R2_0/CTRL_OUT[7] A44_CDAC_CAP_BANK_ASSEMBLY_R8_M6_0/A44_CAP_CORE128_M6_R1_0/CAP_BOTTOM_095 VDD pfet_03v3 ad=0 pd=0 as=0 ps=0 w=1.56u l=0.28u
X2381 VREFP A44_DCTRL_STRIP_W_R2_0/CTRL_OUT[7] A44_CDAC_CAP_BANK_ASSEMBLY_R8_M6_0/A44_CAP_CORE128_M6_R1_0/CAP_BOTTOM_095 VDD pfet_03v3 ad=0 pd=0 as=0 ps=0 w=1.56u l=0.28u
X2382 VREFP A44_DCTRL_STRIP_W_R2_0/CTRL_OUT[7] A44_CDAC_CAP_BANK_ASSEMBLY_R8_M6_0/A44_CAP_CORE128_M6_R1_0/CAP_BOTTOM_095 VDD pfet_03v3 ad=0 pd=0 as=0 ps=0 w=1.56u l=0.28u
X2383 VREFP A44_DCTRL_STRIP_W_R2_0/CTRL_OUT[7] A44_CDAC_CAP_BANK_ASSEMBLY_R8_M6_0/A44_CAP_CORE128_M6_R1_0/CAP_BOTTOM_095 VDD pfet_03v3 ad=0 pd=0 as=0 ps=0 w=1.56u l=0.28u
X2384 VREFP A44_DCTRL_STRIP_W_R2_0/CTRL_OUT[7] A44_CDAC_CAP_BANK_ASSEMBLY_R8_M6_0/A44_CAP_CORE128_M6_R1_0/CAP_BOTTOM_095 VDD pfet_03v3 ad=0 pd=0 as=0 ps=0 w=1.56u l=0.28u
X2385 VREFP A44_DCTRL_STRIP_W_R2_0/CTRL_OUT[7] A44_CDAC_CAP_BANK_ASSEMBLY_R8_M6_0/A44_CAP_CORE128_M6_R1_0/CAP_BOTTOM_095 VDD pfet_03v3 ad=0 pd=0 as=0 ps=0 w=1.56u l=0.28u
X2386 VREFP A44_DCTRL_STRIP_W_R2_0/CTRL_OUT[7] A44_CDAC_CAP_BANK_ASSEMBLY_R8_M6_0/A44_CAP_CORE128_M6_R1_0/CAP_BOTTOM_095 VDD pfet_03v3 ad=0 pd=0 as=0 ps=0 w=1.56u l=0.28u
X2387 VREFP A44_DCTRL_STRIP_W_R2_0/CTRL_OUT[7] A44_CDAC_CAP_BANK_ASSEMBLY_R8_M6_0/A44_CAP_CORE128_M6_R1_0/CAP_BOTTOM_095 VDD pfet_03v3 ad=0 pd=0 as=0 ps=0 w=1.56u l=0.28u
X2388 VREFP A44_DCTRL_STRIP_W_R2_0/CTRL_OUT[7] A44_CDAC_CAP_BANK_ASSEMBLY_R8_M6_0/A44_CAP_CORE128_M6_R1_0/CAP_BOTTOM_095 VDD pfet_03v3 ad=0 pd=0 as=0 ps=0 w=1.56u l=0.28u
X2389 VREFP A44_DCTRL_STRIP_W_R2_0/CTRL_OUT[7] A44_CDAC_CAP_BANK_ASSEMBLY_R8_M6_0/A44_CAP_CORE128_M6_R1_0/CAP_BOTTOM_095 VDD pfet_03v3 ad=0 pd=0 as=0 ps=0 w=1.56u l=0.28u
X2390 VREFP A44_DCTRL_STRIP_W_R2_0/CTRL_OUT[7] A44_CDAC_CAP_BANK_ASSEMBLY_R8_M6_0/A44_CAP_CORE128_M6_R1_0/CAP_BOTTOM_095 VDD pfet_03v3 ad=0 pd=0 as=0 ps=0 w=1.56u l=0.28u
X2391 VREFP A44_DCTRL_STRIP_W_R2_0/CTRL_OUT[7] A44_CDAC_CAP_BANK_ASSEMBLY_R8_M6_0/A44_CAP_CORE128_M6_R1_0/CAP_BOTTOM_095 VDD pfet_03v3 ad=0 pd=0 as=0 ps=0 w=1.56u l=0.28u
X2392 VREFP A44_DCTRL_STRIP_W_R2_0/CTRL_OUT[7] A44_CDAC_CAP_BANK_ASSEMBLY_R8_M6_0/A44_CAP_CORE128_M6_R1_0/CAP_BOTTOM_095 VDD pfet_03v3 ad=0 pd=0 as=0 ps=0 w=1.56u l=0.28u
X2393 VREFP A44_DCTRL_STRIP_W_R2_0/CTRL_OUT[7] A44_CDAC_CAP_BANK_ASSEMBLY_R8_M6_0/A44_CAP_CORE128_M6_R1_0/CAP_BOTTOM_095 VDD pfet_03v3 ad=0 pd=0 as=0 ps=0 w=1.56u l=0.28u
X2394 VREFP A44_DCTRL_STRIP_W_R2_0/CTRL_OUT[7] A44_CDAC_CAP_BANK_ASSEMBLY_R8_M6_0/A44_CAP_CORE128_M6_R1_0/CAP_BOTTOM_095 VDD pfet_03v3 ad=0 pd=0 as=0 ps=0 w=1.56u l=0.28u
X2395 VREFP A44_DCTRL_STRIP_W_R2_0/CTRL_OUT[7] A44_CDAC_CAP_BANK_ASSEMBLY_R8_M6_0/A44_CAP_CORE128_M6_R1_0/CAP_BOTTOM_095 VDD pfet_03v3 ad=0 pd=0 as=0 ps=0 w=1.56u l=0.28u
X2396 VREFN A44_DCTRL_STRIP_W_R2_0/CTRL_OUT[7] A44_CDAC_CAP_BANK_ASSEMBLY_R8_M6_0/A44_CAP_CORE128_M6_R1_0/CAP_BOTTOM_095 GND nfet_03v3 ad=0 pd=0 as=16.6842p ps=77.76u w=1.56u l=0.28u
X2397 VREFN A44_DCTRL_STRIP_W_R2_0/CTRL_OUT[7] A44_CDAC_CAP_BANK_ASSEMBLY_R8_M6_0/A44_CAP_CORE128_M6_R1_0/CAP_BOTTOM_095 GND nfet_03v3 ad=0 pd=0 as=0 ps=0 w=1.56u l=0.28u
X2398 VREFN A44_DCTRL_STRIP_W_R2_0/CTRL_OUT[7] A44_CDAC_CAP_BANK_ASSEMBLY_R8_M6_0/A44_CAP_CORE128_M6_R1_0/CAP_BOTTOM_095 GND nfet_03v3 ad=0 pd=0 as=0 ps=0 w=1.56u l=0.28u
X2399 VREFN A44_DCTRL_STRIP_W_R2_0/CTRL_OUT[7] A44_CDAC_CAP_BANK_ASSEMBLY_R8_M6_0/A44_CAP_CORE128_M6_R1_0/CAP_BOTTOM_095 GND nfet_03v3 ad=0 pd=0 as=0 ps=0 w=1.56u l=0.28u
X2400 VREFN A44_DCTRL_STRIP_W_R2_0/CTRL_OUT[7] A44_CDAC_CAP_BANK_ASSEMBLY_R8_M6_0/A44_CAP_CORE128_M6_R1_0/CAP_BOTTOM_095 GND nfet_03v3 ad=0 pd=0 as=0 ps=0 w=1.56u l=0.28u
X2401 VREFN A44_DCTRL_STRIP_W_R2_0/CTRL_OUT[7] A44_CDAC_CAP_BANK_ASSEMBLY_R8_M6_0/A44_CAP_CORE128_M6_R1_0/CAP_BOTTOM_095 GND nfet_03v3 ad=0 pd=0 as=0 ps=0 w=1.56u l=0.28u
X2402 VREFN A44_DCTRL_STRIP_W_R2_0/CTRL_OUT[7] A44_CDAC_CAP_BANK_ASSEMBLY_R8_M6_0/A44_CAP_CORE128_M6_R1_0/CAP_BOTTOM_095 GND nfet_03v3 ad=0 pd=0 as=0 ps=0 w=1.56u l=0.28u
X2403 VREFN A44_DCTRL_STRIP_W_R2_0/CTRL_OUT[7] A44_CDAC_CAP_BANK_ASSEMBLY_R8_M6_0/A44_CAP_CORE128_M6_R1_0/CAP_BOTTOM_095 GND nfet_03v3 ad=0 pd=0 as=0 ps=0 w=1.56u l=0.28u
X2404 VREFN A44_DCTRL_STRIP_W_R2_0/CTRL_OUT[7] A44_CDAC_CAP_BANK_ASSEMBLY_R8_M6_0/A44_CAP_CORE128_M6_R1_0/CAP_BOTTOM_095 GND nfet_03v3 ad=0 pd=0 as=0 ps=0 w=1.56u l=0.28u
X2405 VREFN A44_DCTRL_STRIP_W_R2_0/CTRL_OUT[7] A44_CDAC_CAP_BANK_ASSEMBLY_R8_M6_0/A44_CAP_CORE128_M6_R1_0/CAP_BOTTOM_095 GND nfet_03v3 ad=0 pd=0 as=0 ps=0 w=1.56u l=0.28u
X2406 VREFN A44_DCTRL_STRIP_W_R2_0/CTRL_OUT[7] A44_CDAC_CAP_BANK_ASSEMBLY_R8_M6_0/A44_CAP_CORE128_M6_R1_0/CAP_BOTTOM_095 GND nfet_03v3 ad=0 pd=0 as=0 ps=0 w=1.56u l=0.28u
X2407 VREFN A44_DCTRL_STRIP_W_R2_0/CTRL_OUT[7] A44_CDAC_CAP_BANK_ASSEMBLY_R8_M6_0/A44_CAP_CORE128_M6_R1_0/CAP_BOTTOM_095 GND nfet_03v3 ad=0 pd=0 as=0 ps=0 w=1.56u l=0.28u
X2408 VREFN A44_DCTRL_STRIP_W_R2_0/CTRL_OUT[7] A44_CDAC_CAP_BANK_ASSEMBLY_R8_M6_0/A44_CAP_CORE128_M6_R1_0/CAP_BOTTOM_095 GND nfet_03v3 ad=0 pd=0 as=0 ps=0 w=1.56u l=0.28u
X2409 VREFN A44_DCTRL_STRIP_W_R2_0/CTRL_OUT[7] A44_CDAC_CAP_BANK_ASSEMBLY_R8_M6_0/A44_CAP_CORE128_M6_R1_0/CAP_BOTTOM_095 GND nfet_03v3 ad=0 pd=0 as=0 ps=0 w=1.56u l=0.28u
X2410 VREFN A44_DCTRL_STRIP_W_R2_0/CTRL_OUT[7] A44_CDAC_CAP_BANK_ASSEMBLY_R8_M6_0/A44_CAP_CORE128_M6_R1_0/CAP_BOTTOM_095 GND nfet_03v3 ad=0 pd=0 as=0 ps=0 w=1.56u l=0.28u
X2411 VREFN A44_DCTRL_STRIP_W_R2_0/CTRL_OUT[7] A44_CDAC_CAP_BANK_ASSEMBLY_R8_M6_0/A44_CAP_CORE128_M6_R1_0/CAP_BOTTOM_095 GND nfet_03v3 ad=0 pd=0 as=0 ps=0 w=1.56u l=0.28u
X2412 VREFN A44_DCTRL_STRIP_W_R2_0/CTRL_OUT[7] A44_CDAC_CAP_BANK_ASSEMBLY_R8_M6_0/A44_CAP_CORE128_M6_R1_0/CAP_BOTTOM_095 GND nfet_03v3 ad=0 pd=0 as=0 ps=0 w=1.56u l=0.28u
X2413 VREFN A44_DCTRL_STRIP_W_R2_0/CTRL_OUT[7] A44_CDAC_CAP_BANK_ASSEMBLY_R8_M6_0/A44_CAP_CORE128_M6_R1_0/CAP_BOTTOM_095 GND nfet_03v3 ad=0 pd=0 as=0 ps=0 w=1.56u l=0.28u
X2414 VREFP A44_DCTRL_STRIP_W_R2_0/CTRL_OUT[7] A44_CDAC_CAP_BANK_ASSEMBLY_R8_M6_0/A44_CAP_CORE128_M6_R1_0/CAP_BOTTOM_079 VDD pfet_03v3 ad=0 pd=0 as=16.6842p ps=77.76u w=1.56u l=0.28u
X2415 VREFP A44_DCTRL_STRIP_W_R2_0/CTRL_OUT[7] A44_CDAC_CAP_BANK_ASSEMBLY_R8_M6_0/A44_CAP_CORE128_M6_R1_0/CAP_BOTTOM_079 VDD pfet_03v3 ad=0 pd=0 as=0 ps=0 w=1.56u l=0.28u
X2416 VREFP A44_DCTRL_STRIP_W_R2_0/CTRL_OUT[7] A44_CDAC_CAP_BANK_ASSEMBLY_R8_M6_0/A44_CAP_CORE128_M6_R1_0/CAP_BOTTOM_079 VDD pfet_03v3 ad=0 pd=0 as=0 ps=0 w=1.56u l=0.28u
X2417 VREFP A44_DCTRL_STRIP_W_R2_0/CTRL_OUT[7] A44_CDAC_CAP_BANK_ASSEMBLY_R8_M6_0/A44_CAP_CORE128_M6_R1_0/CAP_BOTTOM_079 VDD pfet_03v3 ad=0 pd=0 as=0 ps=0 w=1.56u l=0.28u
X2418 VREFP A44_DCTRL_STRIP_W_R2_0/CTRL_OUT[7] A44_CDAC_CAP_BANK_ASSEMBLY_R8_M6_0/A44_CAP_CORE128_M6_R1_0/CAP_BOTTOM_079 VDD pfet_03v3 ad=0 pd=0 as=0 ps=0 w=1.56u l=0.28u
X2419 VREFP A44_DCTRL_STRIP_W_R2_0/CTRL_OUT[7] A44_CDAC_CAP_BANK_ASSEMBLY_R8_M6_0/A44_CAP_CORE128_M6_R1_0/CAP_BOTTOM_079 VDD pfet_03v3 ad=0 pd=0 as=0 ps=0 w=1.56u l=0.28u
X2420 VREFP A44_DCTRL_STRIP_W_R2_0/CTRL_OUT[7] A44_CDAC_CAP_BANK_ASSEMBLY_R8_M6_0/A44_CAP_CORE128_M6_R1_0/CAP_BOTTOM_079 VDD pfet_03v3 ad=0 pd=0 as=0 ps=0 w=1.56u l=0.28u
X2421 VREFP A44_DCTRL_STRIP_W_R2_0/CTRL_OUT[7] A44_CDAC_CAP_BANK_ASSEMBLY_R8_M6_0/A44_CAP_CORE128_M6_R1_0/CAP_BOTTOM_079 VDD pfet_03v3 ad=0 pd=0 as=0 ps=0 w=1.56u l=0.28u
X2422 VREFP A44_DCTRL_STRIP_W_R2_0/CTRL_OUT[7] A44_CDAC_CAP_BANK_ASSEMBLY_R8_M6_0/A44_CAP_CORE128_M6_R1_0/CAP_BOTTOM_079 VDD pfet_03v3 ad=0 pd=0 as=0 ps=0 w=1.56u l=0.28u
X2423 VREFP A44_DCTRL_STRIP_W_R2_0/CTRL_OUT[7] A44_CDAC_CAP_BANK_ASSEMBLY_R8_M6_0/A44_CAP_CORE128_M6_R1_0/CAP_BOTTOM_079 VDD pfet_03v3 ad=0 pd=0 as=0 ps=0 w=1.56u l=0.28u
X2424 VREFP A44_DCTRL_STRIP_W_R2_0/CTRL_OUT[7] A44_CDAC_CAP_BANK_ASSEMBLY_R8_M6_0/A44_CAP_CORE128_M6_R1_0/CAP_BOTTOM_079 VDD pfet_03v3 ad=0 pd=0 as=0 ps=0 w=1.56u l=0.28u
X2425 VREFP A44_DCTRL_STRIP_W_R2_0/CTRL_OUT[7] A44_CDAC_CAP_BANK_ASSEMBLY_R8_M6_0/A44_CAP_CORE128_M6_R1_0/CAP_BOTTOM_079 VDD pfet_03v3 ad=0 pd=0 as=0 ps=0 w=1.56u l=0.28u
X2426 VREFP A44_DCTRL_STRIP_W_R2_0/CTRL_OUT[7] A44_CDAC_CAP_BANK_ASSEMBLY_R8_M6_0/A44_CAP_CORE128_M6_R1_0/CAP_BOTTOM_079 VDD pfet_03v3 ad=0 pd=0 as=0 ps=0 w=1.56u l=0.28u
X2427 VREFP A44_DCTRL_STRIP_W_R2_0/CTRL_OUT[7] A44_CDAC_CAP_BANK_ASSEMBLY_R8_M6_0/A44_CAP_CORE128_M6_R1_0/CAP_BOTTOM_079 VDD pfet_03v3 ad=0 pd=0 as=0 ps=0 w=1.56u l=0.28u
X2428 VREFP A44_DCTRL_STRIP_W_R2_0/CTRL_OUT[7] A44_CDAC_CAP_BANK_ASSEMBLY_R8_M6_0/A44_CAP_CORE128_M6_R1_0/CAP_BOTTOM_079 VDD pfet_03v3 ad=0 pd=0 as=0 ps=0 w=1.56u l=0.28u
X2429 VREFP A44_DCTRL_STRIP_W_R2_0/CTRL_OUT[7] A44_CDAC_CAP_BANK_ASSEMBLY_R8_M6_0/A44_CAP_CORE128_M6_R1_0/CAP_BOTTOM_079 VDD pfet_03v3 ad=0 pd=0 as=0 ps=0 w=1.56u l=0.28u
X2430 VREFP A44_DCTRL_STRIP_W_R2_0/CTRL_OUT[7] A44_CDAC_CAP_BANK_ASSEMBLY_R8_M6_0/A44_CAP_CORE128_M6_R1_0/CAP_BOTTOM_079 VDD pfet_03v3 ad=0 pd=0 as=0 ps=0 w=1.56u l=0.28u
X2431 VREFP A44_DCTRL_STRIP_W_R2_0/CTRL_OUT[7] A44_CDAC_CAP_BANK_ASSEMBLY_R8_M6_0/A44_CAP_CORE128_M6_R1_0/CAP_BOTTOM_079 VDD pfet_03v3 ad=0 pd=0 as=0 ps=0 w=1.56u l=0.28u
X2432 VREFN A44_DCTRL_STRIP_W_R2_0/CTRL_OUT[7] A44_CDAC_CAP_BANK_ASSEMBLY_R8_M6_0/A44_CAP_CORE128_M6_R1_0/CAP_BOTTOM_079 GND nfet_03v3 ad=0 pd=0 as=16.6842p ps=77.76u w=1.56u l=0.28u
X2433 VREFN A44_DCTRL_STRIP_W_R2_0/CTRL_OUT[7] A44_CDAC_CAP_BANK_ASSEMBLY_R8_M6_0/A44_CAP_CORE128_M6_R1_0/CAP_BOTTOM_079 GND nfet_03v3 ad=0 pd=0 as=0 ps=0 w=1.56u l=0.28u
X2434 VREFN A44_DCTRL_STRIP_W_R2_0/CTRL_OUT[7] A44_CDAC_CAP_BANK_ASSEMBLY_R8_M6_0/A44_CAP_CORE128_M6_R1_0/CAP_BOTTOM_079 GND nfet_03v3 ad=0 pd=0 as=0 ps=0 w=1.56u l=0.28u
X2435 VREFN A44_DCTRL_STRIP_W_R2_0/CTRL_OUT[7] A44_CDAC_CAP_BANK_ASSEMBLY_R8_M6_0/A44_CAP_CORE128_M6_R1_0/CAP_BOTTOM_079 GND nfet_03v3 ad=0 pd=0 as=0 ps=0 w=1.56u l=0.28u
X2436 VREFN A44_DCTRL_STRIP_W_R2_0/CTRL_OUT[7] A44_CDAC_CAP_BANK_ASSEMBLY_R8_M6_0/A44_CAP_CORE128_M6_R1_0/CAP_BOTTOM_079 GND nfet_03v3 ad=0 pd=0 as=0 ps=0 w=1.56u l=0.28u
X2437 VREFN A44_DCTRL_STRIP_W_R2_0/CTRL_OUT[7] A44_CDAC_CAP_BANK_ASSEMBLY_R8_M6_0/A44_CAP_CORE128_M6_R1_0/CAP_BOTTOM_079 GND nfet_03v3 ad=0 pd=0 as=0 ps=0 w=1.56u l=0.28u
X2438 VREFN A44_DCTRL_STRIP_W_R2_0/CTRL_OUT[7] A44_CDAC_CAP_BANK_ASSEMBLY_R8_M6_0/A44_CAP_CORE128_M6_R1_0/CAP_BOTTOM_079 GND nfet_03v3 ad=0 pd=0 as=0 ps=0 w=1.56u l=0.28u
X2439 VREFN A44_DCTRL_STRIP_W_R2_0/CTRL_OUT[7] A44_CDAC_CAP_BANK_ASSEMBLY_R8_M6_0/A44_CAP_CORE128_M6_R1_0/CAP_BOTTOM_079 GND nfet_03v3 ad=0 pd=0 as=0 ps=0 w=1.56u l=0.28u
X2440 VREFN A44_DCTRL_STRIP_W_R2_0/CTRL_OUT[7] A44_CDAC_CAP_BANK_ASSEMBLY_R8_M6_0/A44_CAP_CORE128_M6_R1_0/CAP_BOTTOM_079 GND nfet_03v3 ad=0 pd=0 as=0 ps=0 w=1.56u l=0.28u
X2441 VREFN A44_DCTRL_STRIP_W_R2_0/CTRL_OUT[7] A44_CDAC_CAP_BANK_ASSEMBLY_R8_M6_0/A44_CAP_CORE128_M6_R1_0/CAP_BOTTOM_079 GND nfet_03v3 ad=0 pd=0 as=0 ps=0 w=1.56u l=0.28u
X2442 VREFN A44_DCTRL_STRIP_W_R2_0/CTRL_OUT[7] A44_CDAC_CAP_BANK_ASSEMBLY_R8_M6_0/A44_CAP_CORE128_M6_R1_0/CAP_BOTTOM_079 GND nfet_03v3 ad=0 pd=0 as=0 ps=0 w=1.56u l=0.28u
X2443 VREFN A44_DCTRL_STRIP_W_R2_0/CTRL_OUT[7] A44_CDAC_CAP_BANK_ASSEMBLY_R8_M6_0/A44_CAP_CORE128_M6_R1_0/CAP_BOTTOM_079 GND nfet_03v3 ad=0 pd=0 as=0 ps=0 w=1.56u l=0.28u
X2444 VREFN A44_DCTRL_STRIP_W_R2_0/CTRL_OUT[7] A44_CDAC_CAP_BANK_ASSEMBLY_R8_M6_0/A44_CAP_CORE128_M6_R1_0/CAP_BOTTOM_079 GND nfet_03v3 ad=0 pd=0 as=0 ps=0 w=1.56u l=0.28u
X2445 VREFN A44_DCTRL_STRIP_W_R2_0/CTRL_OUT[7] A44_CDAC_CAP_BANK_ASSEMBLY_R8_M6_0/A44_CAP_CORE128_M6_R1_0/CAP_BOTTOM_079 GND nfet_03v3 ad=0 pd=0 as=0 ps=0 w=1.56u l=0.28u
X2446 VREFN A44_DCTRL_STRIP_W_R2_0/CTRL_OUT[7] A44_CDAC_CAP_BANK_ASSEMBLY_R8_M6_0/A44_CAP_CORE128_M6_R1_0/CAP_BOTTOM_079 GND nfet_03v3 ad=0 pd=0 as=0 ps=0 w=1.56u l=0.28u
X2447 VREFN A44_DCTRL_STRIP_W_R2_0/CTRL_OUT[7] A44_CDAC_CAP_BANK_ASSEMBLY_R8_M6_0/A44_CAP_CORE128_M6_R1_0/CAP_BOTTOM_079 GND nfet_03v3 ad=0 pd=0 as=0 ps=0 w=1.56u l=0.28u
X2448 VREFN A44_DCTRL_STRIP_W_R2_0/CTRL_OUT[7] A44_CDAC_CAP_BANK_ASSEMBLY_R8_M6_0/A44_CAP_CORE128_M6_R1_0/CAP_BOTTOM_079 GND nfet_03v3 ad=0 pd=0 as=0 ps=0 w=1.56u l=0.28u
X2449 VREFN A44_DCTRL_STRIP_W_R2_0/CTRL_OUT[7] A44_CDAC_CAP_BANK_ASSEMBLY_R8_M6_0/A44_CAP_CORE128_M6_R1_0/CAP_BOTTOM_079 GND nfet_03v3 ad=0 pd=0 as=0 ps=0 w=1.56u l=0.28u
X2450 VREFP A44_DCTRL_STRIP_W_R2_0/CTRL_OUT[7] A44_CDAC_CAP_BANK_ASSEMBLY_R8_M6_0/A44_CAP_CORE128_M6_R1_0/CAP_BOTTOM_067 VDD pfet_03v3 ad=0 pd=0 as=16.6842p ps=77.76u w=1.56u l=0.28u
X2451 VREFP A44_DCTRL_STRIP_W_R2_0/CTRL_OUT[7] A44_CDAC_CAP_BANK_ASSEMBLY_R8_M6_0/A44_CAP_CORE128_M6_R1_0/CAP_BOTTOM_067 VDD pfet_03v3 ad=0 pd=0 as=0 ps=0 w=1.56u l=0.28u
X2452 VREFP A44_DCTRL_STRIP_W_R2_0/CTRL_OUT[7] A44_CDAC_CAP_BANK_ASSEMBLY_R8_M6_0/A44_CAP_CORE128_M6_R1_0/CAP_BOTTOM_067 VDD pfet_03v3 ad=0 pd=0 as=0 ps=0 w=1.56u l=0.28u
X2453 VREFP A44_DCTRL_STRIP_W_R2_0/CTRL_OUT[7] A44_CDAC_CAP_BANK_ASSEMBLY_R8_M6_0/A44_CAP_CORE128_M6_R1_0/CAP_BOTTOM_067 VDD pfet_03v3 ad=0 pd=0 as=0 ps=0 w=1.56u l=0.28u
X2454 VREFP A44_DCTRL_STRIP_W_R2_0/CTRL_OUT[7] A44_CDAC_CAP_BANK_ASSEMBLY_R8_M6_0/A44_CAP_CORE128_M6_R1_0/CAP_BOTTOM_067 VDD pfet_03v3 ad=0 pd=0 as=0 ps=0 w=1.56u l=0.28u
X2455 VREFP A44_DCTRL_STRIP_W_R2_0/CTRL_OUT[7] A44_CDAC_CAP_BANK_ASSEMBLY_R8_M6_0/A44_CAP_CORE128_M6_R1_0/CAP_BOTTOM_067 VDD pfet_03v3 ad=0 pd=0 as=0 ps=0 w=1.56u l=0.28u
X2456 VREFP A44_DCTRL_STRIP_W_R2_0/CTRL_OUT[7] A44_CDAC_CAP_BANK_ASSEMBLY_R8_M6_0/A44_CAP_CORE128_M6_R1_0/CAP_BOTTOM_067 VDD pfet_03v3 ad=0 pd=0 as=0 ps=0 w=1.56u l=0.28u
X2457 VREFP A44_DCTRL_STRIP_W_R2_0/CTRL_OUT[7] A44_CDAC_CAP_BANK_ASSEMBLY_R8_M6_0/A44_CAP_CORE128_M6_R1_0/CAP_BOTTOM_067 VDD pfet_03v3 ad=0 pd=0 as=0 ps=0 w=1.56u l=0.28u
X2458 VREFP A44_DCTRL_STRIP_W_R2_0/CTRL_OUT[7] A44_CDAC_CAP_BANK_ASSEMBLY_R8_M6_0/A44_CAP_CORE128_M6_R1_0/CAP_BOTTOM_067 VDD pfet_03v3 ad=0 pd=0 as=0 ps=0 w=1.56u l=0.28u
X2459 VREFP A44_DCTRL_STRIP_W_R2_0/CTRL_OUT[7] A44_CDAC_CAP_BANK_ASSEMBLY_R8_M6_0/A44_CAP_CORE128_M6_R1_0/CAP_BOTTOM_067 VDD pfet_03v3 ad=0 pd=0 as=0 ps=0 w=1.56u l=0.28u
X2460 VREFP A44_DCTRL_STRIP_W_R2_0/CTRL_OUT[7] A44_CDAC_CAP_BANK_ASSEMBLY_R8_M6_0/A44_CAP_CORE128_M6_R1_0/CAP_BOTTOM_067 VDD pfet_03v3 ad=0 pd=0 as=0 ps=0 w=1.56u l=0.28u
X2461 VREFP A44_DCTRL_STRIP_W_R2_0/CTRL_OUT[7] A44_CDAC_CAP_BANK_ASSEMBLY_R8_M6_0/A44_CAP_CORE128_M6_R1_0/CAP_BOTTOM_067 VDD pfet_03v3 ad=0 pd=0 as=0 ps=0 w=1.56u l=0.28u
X2462 VREFP A44_DCTRL_STRIP_W_R2_0/CTRL_OUT[7] A44_CDAC_CAP_BANK_ASSEMBLY_R8_M6_0/A44_CAP_CORE128_M6_R1_0/CAP_BOTTOM_067 VDD pfet_03v3 ad=0 pd=0 as=0 ps=0 w=1.56u l=0.28u
X2463 VREFP A44_DCTRL_STRIP_W_R2_0/CTRL_OUT[7] A44_CDAC_CAP_BANK_ASSEMBLY_R8_M6_0/A44_CAP_CORE128_M6_R1_0/CAP_BOTTOM_067 VDD pfet_03v3 ad=0 pd=0 as=0 ps=0 w=1.56u l=0.28u
X2464 VREFP A44_DCTRL_STRIP_W_R2_0/CTRL_OUT[7] A44_CDAC_CAP_BANK_ASSEMBLY_R8_M6_0/A44_CAP_CORE128_M6_R1_0/CAP_BOTTOM_067 VDD pfet_03v3 ad=0 pd=0 as=0 ps=0 w=1.56u l=0.28u
X2465 VREFP A44_DCTRL_STRIP_W_R2_0/CTRL_OUT[7] A44_CDAC_CAP_BANK_ASSEMBLY_R8_M6_0/A44_CAP_CORE128_M6_R1_0/CAP_BOTTOM_067 VDD pfet_03v3 ad=0 pd=0 as=0 ps=0 w=1.56u l=0.28u
X2466 VREFP A44_DCTRL_STRIP_W_R2_0/CTRL_OUT[7] A44_CDAC_CAP_BANK_ASSEMBLY_R8_M6_0/A44_CAP_CORE128_M6_R1_0/CAP_BOTTOM_067 VDD pfet_03v3 ad=0 pd=0 as=0 ps=0 w=1.56u l=0.28u
X2467 VREFP A44_DCTRL_STRIP_W_R2_0/CTRL_OUT[7] A44_CDAC_CAP_BANK_ASSEMBLY_R8_M6_0/A44_CAP_CORE128_M6_R1_0/CAP_BOTTOM_067 VDD pfet_03v3 ad=0 pd=0 as=0 ps=0 w=1.56u l=0.28u
X2468 VREFN A44_DCTRL_STRIP_W_R2_0/CTRL_OUT[7] A44_CDAC_CAP_BANK_ASSEMBLY_R8_M6_0/A44_CAP_CORE128_M6_R1_0/CAP_BOTTOM_067 GND nfet_03v3 ad=0 pd=0 as=16.6842p ps=77.76u w=1.56u l=0.28u
X2469 VREFN A44_DCTRL_STRIP_W_R2_0/CTRL_OUT[7] A44_CDAC_CAP_BANK_ASSEMBLY_R8_M6_0/A44_CAP_CORE128_M6_R1_0/CAP_BOTTOM_067 GND nfet_03v3 ad=0 pd=0 as=0 ps=0 w=1.56u l=0.28u
X2470 VREFN A44_DCTRL_STRIP_W_R2_0/CTRL_OUT[7] A44_CDAC_CAP_BANK_ASSEMBLY_R8_M6_0/A44_CAP_CORE128_M6_R1_0/CAP_BOTTOM_067 GND nfet_03v3 ad=0 pd=0 as=0 ps=0 w=1.56u l=0.28u
X2471 VREFN A44_DCTRL_STRIP_W_R2_0/CTRL_OUT[7] A44_CDAC_CAP_BANK_ASSEMBLY_R8_M6_0/A44_CAP_CORE128_M6_R1_0/CAP_BOTTOM_067 GND nfet_03v3 ad=0 pd=0 as=0 ps=0 w=1.56u l=0.28u
X2472 VREFN A44_DCTRL_STRIP_W_R2_0/CTRL_OUT[7] A44_CDAC_CAP_BANK_ASSEMBLY_R8_M6_0/A44_CAP_CORE128_M6_R1_0/CAP_BOTTOM_067 GND nfet_03v3 ad=0 pd=0 as=0 ps=0 w=1.56u l=0.28u
X2473 VREFN A44_DCTRL_STRIP_W_R2_0/CTRL_OUT[7] A44_CDAC_CAP_BANK_ASSEMBLY_R8_M6_0/A44_CAP_CORE128_M6_R1_0/CAP_BOTTOM_067 GND nfet_03v3 ad=0 pd=0 as=0 ps=0 w=1.56u l=0.28u
X2474 VREFN A44_DCTRL_STRIP_W_R2_0/CTRL_OUT[7] A44_CDAC_CAP_BANK_ASSEMBLY_R8_M6_0/A44_CAP_CORE128_M6_R1_0/CAP_BOTTOM_067 GND nfet_03v3 ad=0 pd=0 as=0 ps=0 w=1.56u l=0.28u
X2475 VREFN A44_DCTRL_STRIP_W_R2_0/CTRL_OUT[7] A44_CDAC_CAP_BANK_ASSEMBLY_R8_M6_0/A44_CAP_CORE128_M6_R1_0/CAP_BOTTOM_067 GND nfet_03v3 ad=0 pd=0 as=0 ps=0 w=1.56u l=0.28u
X2476 VREFN A44_DCTRL_STRIP_W_R2_0/CTRL_OUT[7] A44_CDAC_CAP_BANK_ASSEMBLY_R8_M6_0/A44_CAP_CORE128_M6_R1_0/CAP_BOTTOM_067 GND nfet_03v3 ad=0 pd=0 as=0 ps=0 w=1.56u l=0.28u
X2477 VREFN A44_DCTRL_STRIP_W_R2_0/CTRL_OUT[7] A44_CDAC_CAP_BANK_ASSEMBLY_R8_M6_0/A44_CAP_CORE128_M6_R1_0/CAP_BOTTOM_067 GND nfet_03v3 ad=0 pd=0 as=0 ps=0 w=1.56u l=0.28u
X2478 VREFN A44_DCTRL_STRIP_W_R2_0/CTRL_OUT[7] A44_CDAC_CAP_BANK_ASSEMBLY_R8_M6_0/A44_CAP_CORE128_M6_R1_0/CAP_BOTTOM_067 GND nfet_03v3 ad=0 pd=0 as=0 ps=0 w=1.56u l=0.28u
X2479 VREFN A44_DCTRL_STRIP_W_R2_0/CTRL_OUT[7] A44_CDAC_CAP_BANK_ASSEMBLY_R8_M6_0/A44_CAP_CORE128_M6_R1_0/CAP_BOTTOM_067 GND nfet_03v3 ad=0 pd=0 as=0 ps=0 w=1.56u l=0.28u
X2480 VREFN A44_DCTRL_STRIP_W_R2_0/CTRL_OUT[7] A44_CDAC_CAP_BANK_ASSEMBLY_R8_M6_0/A44_CAP_CORE128_M6_R1_0/CAP_BOTTOM_067 GND nfet_03v3 ad=0 pd=0 as=0 ps=0 w=1.56u l=0.28u
X2481 VREFN A44_DCTRL_STRIP_W_R2_0/CTRL_OUT[7] A44_CDAC_CAP_BANK_ASSEMBLY_R8_M6_0/A44_CAP_CORE128_M6_R1_0/CAP_BOTTOM_067 GND nfet_03v3 ad=0 pd=0 as=0 ps=0 w=1.56u l=0.28u
X2482 VREFN A44_DCTRL_STRIP_W_R2_0/CTRL_OUT[7] A44_CDAC_CAP_BANK_ASSEMBLY_R8_M6_0/A44_CAP_CORE128_M6_R1_0/CAP_BOTTOM_067 GND nfet_03v3 ad=0 pd=0 as=0 ps=0 w=1.56u l=0.28u
X2483 VREFN A44_DCTRL_STRIP_W_R2_0/CTRL_OUT[7] A44_CDAC_CAP_BANK_ASSEMBLY_R8_M6_0/A44_CAP_CORE128_M6_R1_0/CAP_BOTTOM_067 GND nfet_03v3 ad=0 pd=0 as=0 ps=0 w=1.56u l=0.28u
X2484 VREFN A44_DCTRL_STRIP_W_R2_0/CTRL_OUT[7] A44_CDAC_CAP_BANK_ASSEMBLY_R8_M6_0/A44_CAP_CORE128_M6_R1_0/CAP_BOTTOM_067 GND nfet_03v3 ad=0 pd=0 as=0 ps=0 w=1.56u l=0.28u
X2485 VREFN A44_DCTRL_STRIP_W_R2_0/CTRL_OUT[7] A44_CDAC_CAP_BANK_ASSEMBLY_R8_M6_0/A44_CAP_CORE128_M6_R1_0/CAP_BOTTOM_067 GND nfet_03v3 ad=0 pd=0 as=0 ps=0 w=1.56u l=0.28u
X2486 VREFP A44_DCTRL_STRIP_W_R2_0/CTRL_OUT[5] A44_CDAC_CAP_BANK_ASSEMBLY_R8_M6_0/A44_CAP_CORE128_M6_R1_0/CAP_BOTTOM_113 VDD pfet_03v3 ad=0 pd=0 as=16.6842p ps=77.76u w=1.56u l=0.28u
X2487 VREFP A44_DCTRL_STRIP_W_R2_0/CTRL_OUT[5] A44_CDAC_CAP_BANK_ASSEMBLY_R8_M6_0/A44_CAP_CORE128_M6_R1_0/CAP_BOTTOM_113 VDD pfet_03v3 ad=0 pd=0 as=0 ps=0 w=1.56u l=0.28u
X2488 VREFP A44_DCTRL_STRIP_W_R2_0/CTRL_OUT[5] A44_CDAC_CAP_BANK_ASSEMBLY_R8_M6_0/A44_CAP_CORE128_M6_R1_0/CAP_BOTTOM_113 VDD pfet_03v3 ad=0 pd=0 as=0 ps=0 w=1.56u l=0.28u
X2489 VREFP A44_DCTRL_STRIP_W_R2_0/CTRL_OUT[5] A44_CDAC_CAP_BANK_ASSEMBLY_R8_M6_0/A44_CAP_CORE128_M6_R1_0/CAP_BOTTOM_113 VDD pfet_03v3 ad=0 pd=0 as=0 ps=0 w=1.56u l=0.28u
X2490 VREFP A44_DCTRL_STRIP_W_R2_0/CTRL_OUT[5] A44_CDAC_CAP_BANK_ASSEMBLY_R8_M6_0/A44_CAP_CORE128_M6_R1_0/CAP_BOTTOM_113 VDD pfet_03v3 ad=0 pd=0 as=0 ps=0 w=1.56u l=0.28u
X2491 VREFP A44_DCTRL_STRIP_W_R2_0/CTRL_OUT[5] A44_CDAC_CAP_BANK_ASSEMBLY_R8_M6_0/A44_CAP_CORE128_M6_R1_0/CAP_BOTTOM_113 VDD pfet_03v3 ad=0 pd=0 as=0 ps=0 w=1.56u l=0.28u
X2492 VREFP A44_DCTRL_STRIP_W_R2_0/CTRL_OUT[5] A44_CDAC_CAP_BANK_ASSEMBLY_R8_M6_0/A44_CAP_CORE128_M6_R1_0/CAP_BOTTOM_113 VDD pfet_03v3 ad=0 pd=0 as=0 ps=0 w=1.56u l=0.28u
X2493 VREFP A44_DCTRL_STRIP_W_R2_0/CTRL_OUT[5] A44_CDAC_CAP_BANK_ASSEMBLY_R8_M6_0/A44_CAP_CORE128_M6_R1_0/CAP_BOTTOM_113 VDD pfet_03v3 ad=0 pd=0 as=0 ps=0 w=1.56u l=0.28u
X2494 VREFP A44_DCTRL_STRIP_W_R2_0/CTRL_OUT[5] A44_CDAC_CAP_BANK_ASSEMBLY_R8_M6_0/A44_CAP_CORE128_M6_R1_0/CAP_BOTTOM_113 VDD pfet_03v3 ad=0 pd=0 as=0 ps=0 w=1.56u l=0.28u
X2495 VREFP A44_DCTRL_STRIP_W_R2_0/CTRL_OUT[5] A44_CDAC_CAP_BANK_ASSEMBLY_R8_M6_0/A44_CAP_CORE128_M6_R1_0/CAP_BOTTOM_113 VDD pfet_03v3 ad=0 pd=0 as=0 ps=0 w=1.56u l=0.28u
X2496 VREFP A44_DCTRL_STRIP_W_R2_0/CTRL_OUT[5] A44_CDAC_CAP_BANK_ASSEMBLY_R8_M6_0/A44_CAP_CORE128_M6_R1_0/CAP_BOTTOM_113 VDD pfet_03v3 ad=0 pd=0 as=0 ps=0 w=1.56u l=0.28u
X2497 VREFP A44_DCTRL_STRIP_W_R2_0/CTRL_OUT[5] A44_CDAC_CAP_BANK_ASSEMBLY_R8_M6_0/A44_CAP_CORE128_M6_R1_0/CAP_BOTTOM_113 VDD pfet_03v3 ad=0 pd=0 as=0 ps=0 w=1.56u l=0.28u
X2498 VREFP A44_DCTRL_STRIP_W_R2_0/CTRL_OUT[5] A44_CDAC_CAP_BANK_ASSEMBLY_R8_M6_0/A44_CAP_CORE128_M6_R1_0/CAP_BOTTOM_113 VDD pfet_03v3 ad=0 pd=0 as=0 ps=0 w=1.56u l=0.28u
X2499 VREFP A44_DCTRL_STRIP_W_R2_0/CTRL_OUT[5] A44_CDAC_CAP_BANK_ASSEMBLY_R8_M6_0/A44_CAP_CORE128_M6_R1_0/CAP_BOTTOM_113 VDD pfet_03v3 ad=0 pd=0 as=0 ps=0 w=1.56u l=0.28u
X2500 VREFP A44_DCTRL_STRIP_W_R2_0/CTRL_OUT[5] A44_CDAC_CAP_BANK_ASSEMBLY_R8_M6_0/A44_CAP_CORE128_M6_R1_0/CAP_BOTTOM_113 VDD pfet_03v3 ad=0 pd=0 as=0 ps=0 w=1.56u l=0.28u
X2501 VREFP A44_DCTRL_STRIP_W_R2_0/CTRL_OUT[5] A44_CDAC_CAP_BANK_ASSEMBLY_R8_M6_0/A44_CAP_CORE128_M6_R1_0/CAP_BOTTOM_113 VDD pfet_03v3 ad=0 pd=0 as=0 ps=0 w=1.56u l=0.28u
X2502 VREFP A44_DCTRL_STRIP_W_R2_0/CTRL_OUT[5] A44_CDAC_CAP_BANK_ASSEMBLY_R8_M6_0/A44_CAP_CORE128_M6_R1_0/CAP_BOTTOM_113 VDD pfet_03v3 ad=0 pd=0 as=0 ps=0 w=1.56u l=0.28u
X2503 VREFP A44_DCTRL_STRIP_W_R2_0/CTRL_OUT[5] A44_CDAC_CAP_BANK_ASSEMBLY_R8_M6_0/A44_CAP_CORE128_M6_R1_0/CAP_BOTTOM_113 VDD pfet_03v3 ad=0 pd=0 as=0 ps=0 w=1.56u l=0.28u
X2504 VREFN A44_DCTRL_STRIP_W_R2_0/CTRL_OUT[5] A44_CDAC_CAP_BANK_ASSEMBLY_R8_M6_0/A44_CAP_CORE128_M6_R1_0/CAP_BOTTOM_113 GND nfet_03v3 ad=0 pd=0 as=16.6842p ps=77.76u w=1.56u l=0.28u
X2505 VREFN A44_DCTRL_STRIP_W_R2_0/CTRL_OUT[5] A44_CDAC_CAP_BANK_ASSEMBLY_R8_M6_0/A44_CAP_CORE128_M6_R1_0/CAP_BOTTOM_113 GND nfet_03v3 ad=0 pd=0 as=0 ps=0 w=1.56u l=0.28u
X2506 VREFN A44_DCTRL_STRIP_W_R2_0/CTRL_OUT[5] A44_CDAC_CAP_BANK_ASSEMBLY_R8_M6_0/A44_CAP_CORE128_M6_R1_0/CAP_BOTTOM_113 GND nfet_03v3 ad=0 pd=0 as=0 ps=0 w=1.56u l=0.28u
X2507 VREFN A44_DCTRL_STRIP_W_R2_0/CTRL_OUT[5] A44_CDAC_CAP_BANK_ASSEMBLY_R8_M6_0/A44_CAP_CORE128_M6_R1_0/CAP_BOTTOM_113 GND nfet_03v3 ad=0 pd=0 as=0 ps=0 w=1.56u l=0.28u
X2508 VREFN A44_DCTRL_STRIP_W_R2_0/CTRL_OUT[5] A44_CDAC_CAP_BANK_ASSEMBLY_R8_M6_0/A44_CAP_CORE128_M6_R1_0/CAP_BOTTOM_113 GND nfet_03v3 ad=0 pd=0 as=0 ps=0 w=1.56u l=0.28u
X2509 VREFN A44_DCTRL_STRIP_W_R2_0/CTRL_OUT[5] A44_CDAC_CAP_BANK_ASSEMBLY_R8_M6_0/A44_CAP_CORE128_M6_R1_0/CAP_BOTTOM_113 GND nfet_03v3 ad=0 pd=0 as=0 ps=0 w=1.56u l=0.28u
X2510 VREFN A44_DCTRL_STRIP_W_R2_0/CTRL_OUT[5] A44_CDAC_CAP_BANK_ASSEMBLY_R8_M6_0/A44_CAP_CORE128_M6_R1_0/CAP_BOTTOM_113 GND nfet_03v3 ad=0 pd=0 as=0 ps=0 w=1.56u l=0.28u
X2511 VREFN A44_DCTRL_STRIP_W_R2_0/CTRL_OUT[5] A44_CDAC_CAP_BANK_ASSEMBLY_R8_M6_0/A44_CAP_CORE128_M6_R1_0/CAP_BOTTOM_113 GND nfet_03v3 ad=0 pd=0 as=0 ps=0 w=1.56u l=0.28u
X2512 VREFN A44_DCTRL_STRIP_W_R2_0/CTRL_OUT[5] A44_CDAC_CAP_BANK_ASSEMBLY_R8_M6_0/A44_CAP_CORE128_M6_R1_0/CAP_BOTTOM_113 GND nfet_03v3 ad=0 pd=0 as=0 ps=0 w=1.56u l=0.28u
X2513 VREFN A44_DCTRL_STRIP_W_R2_0/CTRL_OUT[5] A44_CDAC_CAP_BANK_ASSEMBLY_R8_M6_0/A44_CAP_CORE128_M6_R1_0/CAP_BOTTOM_113 GND nfet_03v3 ad=0 pd=0 as=0 ps=0 w=1.56u l=0.28u
X2514 VREFN A44_DCTRL_STRIP_W_R2_0/CTRL_OUT[5] A44_CDAC_CAP_BANK_ASSEMBLY_R8_M6_0/A44_CAP_CORE128_M6_R1_0/CAP_BOTTOM_113 GND nfet_03v3 ad=0 pd=0 as=0 ps=0 w=1.56u l=0.28u
X2515 VREFN A44_DCTRL_STRIP_W_R2_0/CTRL_OUT[5] A44_CDAC_CAP_BANK_ASSEMBLY_R8_M6_0/A44_CAP_CORE128_M6_R1_0/CAP_BOTTOM_113 GND nfet_03v3 ad=0 pd=0 as=0 ps=0 w=1.56u l=0.28u
X2516 VREFN A44_DCTRL_STRIP_W_R2_0/CTRL_OUT[5] A44_CDAC_CAP_BANK_ASSEMBLY_R8_M6_0/A44_CAP_CORE128_M6_R1_0/CAP_BOTTOM_113 GND nfet_03v3 ad=0 pd=0 as=0 ps=0 w=1.56u l=0.28u
X2517 VREFN A44_DCTRL_STRIP_W_R2_0/CTRL_OUT[5] A44_CDAC_CAP_BANK_ASSEMBLY_R8_M6_0/A44_CAP_CORE128_M6_R1_0/CAP_BOTTOM_113 GND nfet_03v3 ad=0 pd=0 as=0 ps=0 w=1.56u l=0.28u
X2518 VREFN A44_DCTRL_STRIP_W_R2_0/CTRL_OUT[5] A44_CDAC_CAP_BANK_ASSEMBLY_R8_M6_0/A44_CAP_CORE128_M6_R1_0/CAP_BOTTOM_113 GND nfet_03v3 ad=0 pd=0 as=0 ps=0 w=1.56u l=0.28u
X2519 VREFN A44_DCTRL_STRIP_W_R2_0/CTRL_OUT[5] A44_CDAC_CAP_BANK_ASSEMBLY_R8_M6_0/A44_CAP_CORE128_M6_R1_0/CAP_BOTTOM_113 GND nfet_03v3 ad=0 pd=0 as=0 ps=0 w=1.56u l=0.28u
X2520 VREFN A44_DCTRL_STRIP_W_R2_0/CTRL_OUT[5] A44_CDAC_CAP_BANK_ASSEMBLY_R8_M6_0/A44_CAP_CORE128_M6_R1_0/CAP_BOTTOM_113 GND nfet_03v3 ad=0 pd=0 as=0 ps=0 w=1.56u l=0.28u
X2521 VREFN A44_DCTRL_STRIP_W_R2_0/CTRL_OUT[5] A44_CDAC_CAP_BANK_ASSEMBLY_R8_M6_0/A44_CAP_CORE128_M6_R1_0/CAP_BOTTOM_113 GND nfet_03v3 ad=0 pd=0 as=0 ps=0 w=1.56u l=0.28u
X2522 VREFP A44_DCTRL_STRIP_W_R2_0/CTRL_OUT[2] A44_CDAC_CAP_BANK_ASSEMBLY_R8_M6_0/A44_CAP_CORE128_M6_R1_0/CAP_BOTTOM_100 VDD pfet_03v3 ad=0 pd=0 as=16.6842p ps=77.76u w=1.56u l=0.28u
X2523 VREFP A44_DCTRL_STRIP_W_R2_0/CTRL_OUT[2] A44_CDAC_CAP_BANK_ASSEMBLY_R8_M6_0/A44_CAP_CORE128_M6_R1_0/CAP_BOTTOM_100 VDD pfet_03v3 ad=0 pd=0 as=0 ps=0 w=1.56u l=0.28u
X2524 VREFP A44_DCTRL_STRIP_W_R2_0/CTRL_OUT[2] A44_CDAC_CAP_BANK_ASSEMBLY_R8_M6_0/A44_CAP_CORE128_M6_R1_0/CAP_BOTTOM_100 VDD pfet_03v3 ad=0 pd=0 as=0 ps=0 w=1.56u l=0.28u
X2525 VREFP A44_DCTRL_STRIP_W_R2_0/CTRL_OUT[2] A44_CDAC_CAP_BANK_ASSEMBLY_R8_M6_0/A44_CAP_CORE128_M6_R1_0/CAP_BOTTOM_100 VDD pfet_03v3 ad=0 pd=0 as=0 ps=0 w=1.56u l=0.28u
X2526 VREFP A44_DCTRL_STRIP_W_R2_0/CTRL_OUT[2] A44_CDAC_CAP_BANK_ASSEMBLY_R8_M6_0/A44_CAP_CORE128_M6_R1_0/CAP_BOTTOM_100 VDD pfet_03v3 ad=0 pd=0 as=0 ps=0 w=1.56u l=0.28u
X2527 VREFP A44_DCTRL_STRIP_W_R2_0/CTRL_OUT[2] A44_CDAC_CAP_BANK_ASSEMBLY_R8_M6_0/A44_CAP_CORE128_M6_R1_0/CAP_BOTTOM_100 VDD pfet_03v3 ad=0 pd=0 as=0 ps=0 w=1.56u l=0.28u
X2528 VREFP A44_DCTRL_STRIP_W_R2_0/CTRL_OUT[2] A44_CDAC_CAP_BANK_ASSEMBLY_R8_M6_0/A44_CAP_CORE128_M6_R1_0/CAP_BOTTOM_100 VDD pfet_03v3 ad=0 pd=0 as=0 ps=0 w=1.56u l=0.28u
X2529 VREFP A44_DCTRL_STRIP_W_R2_0/CTRL_OUT[2] A44_CDAC_CAP_BANK_ASSEMBLY_R8_M6_0/A44_CAP_CORE128_M6_R1_0/CAP_BOTTOM_100 VDD pfet_03v3 ad=0 pd=0 as=0 ps=0 w=1.56u l=0.28u
X2530 VREFP A44_DCTRL_STRIP_W_R2_0/CTRL_OUT[2] A44_CDAC_CAP_BANK_ASSEMBLY_R8_M6_0/A44_CAP_CORE128_M6_R1_0/CAP_BOTTOM_100 VDD pfet_03v3 ad=0 pd=0 as=0 ps=0 w=1.56u l=0.28u
X2531 VREFP A44_DCTRL_STRIP_W_R2_0/CTRL_OUT[2] A44_CDAC_CAP_BANK_ASSEMBLY_R8_M6_0/A44_CAP_CORE128_M6_R1_0/CAP_BOTTOM_100 VDD pfet_03v3 ad=0 pd=0 as=0 ps=0 w=1.56u l=0.28u
X2532 VREFP A44_DCTRL_STRIP_W_R2_0/CTRL_OUT[2] A44_CDAC_CAP_BANK_ASSEMBLY_R8_M6_0/A44_CAP_CORE128_M6_R1_0/CAP_BOTTOM_100 VDD pfet_03v3 ad=0 pd=0 as=0 ps=0 w=1.56u l=0.28u
X2533 VREFP A44_DCTRL_STRIP_W_R2_0/CTRL_OUT[2] A44_CDAC_CAP_BANK_ASSEMBLY_R8_M6_0/A44_CAP_CORE128_M6_R1_0/CAP_BOTTOM_100 VDD pfet_03v3 ad=0 pd=0 as=0 ps=0 w=1.56u l=0.28u
X2534 VREFP A44_DCTRL_STRIP_W_R2_0/CTRL_OUT[2] A44_CDAC_CAP_BANK_ASSEMBLY_R8_M6_0/A44_CAP_CORE128_M6_R1_0/CAP_BOTTOM_100 VDD pfet_03v3 ad=0 pd=0 as=0 ps=0 w=1.56u l=0.28u
X2535 VREFP A44_DCTRL_STRIP_W_R2_0/CTRL_OUT[2] A44_CDAC_CAP_BANK_ASSEMBLY_R8_M6_0/A44_CAP_CORE128_M6_R1_0/CAP_BOTTOM_100 VDD pfet_03v3 ad=0 pd=0 as=0 ps=0 w=1.56u l=0.28u
X2536 VREFP A44_DCTRL_STRIP_W_R2_0/CTRL_OUT[2] A44_CDAC_CAP_BANK_ASSEMBLY_R8_M6_0/A44_CAP_CORE128_M6_R1_0/CAP_BOTTOM_100 VDD pfet_03v3 ad=0 pd=0 as=0 ps=0 w=1.56u l=0.28u
X2537 VREFP A44_DCTRL_STRIP_W_R2_0/CTRL_OUT[2] A44_CDAC_CAP_BANK_ASSEMBLY_R8_M6_0/A44_CAP_CORE128_M6_R1_0/CAP_BOTTOM_100 VDD pfet_03v3 ad=0 pd=0 as=0 ps=0 w=1.56u l=0.28u
X2538 VREFP A44_DCTRL_STRIP_W_R2_0/CTRL_OUT[2] A44_CDAC_CAP_BANK_ASSEMBLY_R8_M6_0/A44_CAP_CORE128_M6_R1_0/CAP_BOTTOM_100 VDD pfet_03v3 ad=0 pd=0 as=0 ps=0 w=1.56u l=0.28u
X2539 VREFP A44_DCTRL_STRIP_W_R2_0/CTRL_OUT[2] A44_CDAC_CAP_BANK_ASSEMBLY_R8_M6_0/A44_CAP_CORE128_M6_R1_0/CAP_BOTTOM_100 VDD pfet_03v3 ad=0 pd=0 as=0 ps=0 w=1.56u l=0.28u
X2540 VREFN A44_DCTRL_STRIP_W_R2_0/CTRL_OUT[2] A44_CDAC_CAP_BANK_ASSEMBLY_R8_M6_0/A44_CAP_CORE128_M6_R1_0/CAP_BOTTOM_100 GND nfet_03v3 ad=0 pd=0 as=16.6842p ps=77.76u w=1.56u l=0.28u
X2541 VREFN A44_DCTRL_STRIP_W_R2_0/CTRL_OUT[2] A44_CDAC_CAP_BANK_ASSEMBLY_R8_M6_0/A44_CAP_CORE128_M6_R1_0/CAP_BOTTOM_100 GND nfet_03v3 ad=0 pd=0 as=0 ps=0 w=1.56u l=0.28u
X2542 VREFN A44_DCTRL_STRIP_W_R2_0/CTRL_OUT[2] A44_CDAC_CAP_BANK_ASSEMBLY_R8_M6_0/A44_CAP_CORE128_M6_R1_0/CAP_BOTTOM_100 GND nfet_03v3 ad=0 pd=0 as=0 ps=0 w=1.56u l=0.28u
X2543 VREFN A44_DCTRL_STRIP_W_R2_0/CTRL_OUT[2] A44_CDAC_CAP_BANK_ASSEMBLY_R8_M6_0/A44_CAP_CORE128_M6_R1_0/CAP_BOTTOM_100 GND nfet_03v3 ad=0 pd=0 as=0 ps=0 w=1.56u l=0.28u
X2544 VREFN A44_DCTRL_STRIP_W_R2_0/CTRL_OUT[2] A44_CDAC_CAP_BANK_ASSEMBLY_R8_M6_0/A44_CAP_CORE128_M6_R1_0/CAP_BOTTOM_100 GND nfet_03v3 ad=0 pd=0 as=0 ps=0 w=1.56u l=0.28u
X2545 VREFN A44_DCTRL_STRIP_W_R2_0/CTRL_OUT[2] A44_CDAC_CAP_BANK_ASSEMBLY_R8_M6_0/A44_CAP_CORE128_M6_R1_0/CAP_BOTTOM_100 GND nfet_03v3 ad=0 pd=0 as=0 ps=0 w=1.56u l=0.28u
X2546 VREFN A44_DCTRL_STRIP_W_R2_0/CTRL_OUT[2] A44_CDAC_CAP_BANK_ASSEMBLY_R8_M6_0/A44_CAP_CORE128_M6_R1_0/CAP_BOTTOM_100 GND nfet_03v3 ad=0 pd=0 as=0 ps=0 w=1.56u l=0.28u
X2547 VREFN A44_DCTRL_STRIP_W_R2_0/CTRL_OUT[2] A44_CDAC_CAP_BANK_ASSEMBLY_R8_M6_0/A44_CAP_CORE128_M6_R1_0/CAP_BOTTOM_100 GND nfet_03v3 ad=0 pd=0 as=0 ps=0 w=1.56u l=0.28u
X2548 VREFN A44_DCTRL_STRIP_W_R2_0/CTRL_OUT[2] A44_CDAC_CAP_BANK_ASSEMBLY_R8_M6_0/A44_CAP_CORE128_M6_R1_0/CAP_BOTTOM_100 GND nfet_03v3 ad=0 pd=0 as=0 ps=0 w=1.56u l=0.28u
X2549 VREFN A44_DCTRL_STRIP_W_R2_0/CTRL_OUT[2] A44_CDAC_CAP_BANK_ASSEMBLY_R8_M6_0/A44_CAP_CORE128_M6_R1_0/CAP_BOTTOM_100 GND nfet_03v3 ad=0 pd=0 as=0 ps=0 w=1.56u l=0.28u
X2550 VREFN A44_DCTRL_STRIP_W_R2_0/CTRL_OUT[2] A44_CDAC_CAP_BANK_ASSEMBLY_R8_M6_0/A44_CAP_CORE128_M6_R1_0/CAP_BOTTOM_100 GND nfet_03v3 ad=0 pd=0 as=0 ps=0 w=1.56u l=0.28u
X2551 VREFN A44_DCTRL_STRIP_W_R2_0/CTRL_OUT[2] A44_CDAC_CAP_BANK_ASSEMBLY_R8_M6_0/A44_CAP_CORE128_M6_R1_0/CAP_BOTTOM_100 GND nfet_03v3 ad=0 pd=0 as=0 ps=0 w=1.56u l=0.28u
X2552 VREFN A44_DCTRL_STRIP_W_R2_0/CTRL_OUT[2] A44_CDAC_CAP_BANK_ASSEMBLY_R8_M6_0/A44_CAP_CORE128_M6_R1_0/CAP_BOTTOM_100 GND nfet_03v3 ad=0 pd=0 as=0 ps=0 w=1.56u l=0.28u
X2553 VREFN A44_DCTRL_STRIP_W_R2_0/CTRL_OUT[2] A44_CDAC_CAP_BANK_ASSEMBLY_R8_M6_0/A44_CAP_CORE128_M6_R1_0/CAP_BOTTOM_100 GND nfet_03v3 ad=0 pd=0 as=0 ps=0 w=1.56u l=0.28u
X2554 VREFN A44_DCTRL_STRIP_W_R2_0/CTRL_OUT[2] A44_CDAC_CAP_BANK_ASSEMBLY_R8_M6_0/A44_CAP_CORE128_M6_R1_0/CAP_BOTTOM_100 GND nfet_03v3 ad=0 pd=0 as=0 ps=0 w=1.56u l=0.28u
X2555 VREFN A44_DCTRL_STRIP_W_R2_0/CTRL_OUT[2] A44_CDAC_CAP_BANK_ASSEMBLY_R8_M6_0/A44_CAP_CORE128_M6_R1_0/CAP_BOTTOM_100 GND nfet_03v3 ad=0 pd=0 as=0 ps=0 w=1.56u l=0.28u
X2556 VREFN A44_DCTRL_STRIP_W_R2_0/CTRL_OUT[2] A44_CDAC_CAP_BANK_ASSEMBLY_R8_M6_0/A44_CAP_CORE128_M6_R1_0/CAP_BOTTOM_100 GND nfet_03v3 ad=0 pd=0 as=0 ps=0 w=1.56u l=0.28u
X2557 VREFN A44_DCTRL_STRIP_W_R2_0/CTRL_OUT[2] A44_CDAC_CAP_BANK_ASSEMBLY_R8_M6_0/A44_CAP_CORE128_M6_R1_0/CAP_BOTTOM_100 GND nfet_03v3 ad=0 pd=0 as=0 ps=0 w=1.56u l=0.28u
X2558 VREFP A44_DCTRL_STRIP_W_R2_0/CTRL_OUT[5] A44_CDAC_CAP_BANK_ASSEMBLY_R8_M6_0/A44_CAP_CORE128_M6_R1_0/CAP_BOTTOM_064 VDD pfet_03v3 ad=0 pd=0 as=16.6842p ps=77.76u w=1.56u l=0.28u
X2559 VREFP A44_DCTRL_STRIP_W_R2_0/CTRL_OUT[5] A44_CDAC_CAP_BANK_ASSEMBLY_R8_M6_0/A44_CAP_CORE128_M6_R1_0/CAP_BOTTOM_064 VDD pfet_03v3 ad=0 pd=0 as=0 ps=0 w=1.56u l=0.28u
X2560 VREFP A44_DCTRL_STRIP_W_R2_0/CTRL_OUT[5] A44_CDAC_CAP_BANK_ASSEMBLY_R8_M6_0/A44_CAP_CORE128_M6_R1_0/CAP_BOTTOM_064 VDD pfet_03v3 ad=0 pd=0 as=0 ps=0 w=1.56u l=0.28u
X2561 VREFP A44_DCTRL_STRIP_W_R2_0/CTRL_OUT[5] A44_CDAC_CAP_BANK_ASSEMBLY_R8_M6_0/A44_CAP_CORE128_M6_R1_0/CAP_BOTTOM_064 VDD pfet_03v3 ad=0 pd=0 as=0 ps=0 w=1.56u l=0.28u
X2562 VREFP A44_DCTRL_STRIP_W_R2_0/CTRL_OUT[5] A44_CDAC_CAP_BANK_ASSEMBLY_R8_M6_0/A44_CAP_CORE128_M6_R1_0/CAP_BOTTOM_064 VDD pfet_03v3 ad=0 pd=0 as=0 ps=0 w=1.56u l=0.28u
X2563 VREFP A44_DCTRL_STRIP_W_R2_0/CTRL_OUT[5] A44_CDAC_CAP_BANK_ASSEMBLY_R8_M6_0/A44_CAP_CORE128_M6_R1_0/CAP_BOTTOM_064 VDD pfet_03v3 ad=0 pd=0 as=0 ps=0 w=1.56u l=0.28u
X2564 VREFP A44_DCTRL_STRIP_W_R2_0/CTRL_OUT[5] A44_CDAC_CAP_BANK_ASSEMBLY_R8_M6_0/A44_CAP_CORE128_M6_R1_0/CAP_BOTTOM_064 VDD pfet_03v3 ad=0 pd=0 as=0 ps=0 w=1.56u l=0.28u
X2565 VREFP A44_DCTRL_STRIP_W_R2_0/CTRL_OUT[5] A44_CDAC_CAP_BANK_ASSEMBLY_R8_M6_0/A44_CAP_CORE128_M6_R1_0/CAP_BOTTOM_064 VDD pfet_03v3 ad=0 pd=0 as=0 ps=0 w=1.56u l=0.28u
X2566 VREFP A44_DCTRL_STRIP_W_R2_0/CTRL_OUT[5] A44_CDAC_CAP_BANK_ASSEMBLY_R8_M6_0/A44_CAP_CORE128_M6_R1_0/CAP_BOTTOM_064 VDD pfet_03v3 ad=0 pd=0 as=0 ps=0 w=1.56u l=0.28u
X2567 VREFP A44_DCTRL_STRIP_W_R2_0/CTRL_OUT[5] A44_CDAC_CAP_BANK_ASSEMBLY_R8_M6_0/A44_CAP_CORE128_M6_R1_0/CAP_BOTTOM_064 VDD pfet_03v3 ad=0 pd=0 as=0 ps=0 w=1.56u l=0.28u
X2568 VREFP A44_DCTRL_STRIP_W_R2_0/CTRL_OUT[5] A44_CDAC_CAP_BANK_ASSEMBLY_R8_M6_0/A44_CAP_CORE128_M6_R1_0/CAP_BOTTOM_064 VDD pfet_03v3 ad=0 pd=0 as=0 ps=0 w=1.56u l=0.28u
X2569 VREFP A44_DCTRL_STRIP_W_R2_0/CTRL_OUT[5] A44_CDAC_CAP_BANK_ASSEMBLY_R8_M6_0/A44_CAP_CORE128_M6_R1_0/CAP_BOTTOM_064 VDD pfet_03v3 ad=0 pd=0 as=0 ps=0 w=1.56u l=0.28u
X2570 VREFP A44_DCTRL_STRIP_W_R2_0/CTRL_OUT[5] A44_CDAC_CAP_BANK_ASSEMBLY_R8_M6_0/A44_CAP_CORE128_M6_R1_0/CAP_BOTTOM_064 VDD pfet_03v3 ad=0 pd=0 as=0 ps=0 w=1.56u l=0.28u
X2571 VREFP A44_DCTRL_STRIP_W_R2_0/CTRL_OUT[5] A44_CDAC_CAP_BANK_ASSEMBLY_R8_M6_0/A44_CAP_CORE128_M6_R1_0/CAP_BOTTOM_064 VDD pfet_03v3 ad=0 pd=0 as=0 ps=0 w=1.56u l=0.28u
X2572 VREFP A44_DCTRL_STRIP_W_R2_0/CTRL_OUT[5] A44_CDAC_CAP_BANK_ASSEMBLY_R8_M6_0/A44_CAP_CORE128_M6_R1_0/CAP_BOTTOM_064 VDD pfet_03v3 ad=0 pd=0 as=0 ps=0 w=1.56u l=0.28u
X2573 VREFP A44_DCTRL_STRIP_W_R2_0/CTRL_OUT[5] A44_CDAC_CAP_BANK_ASSEMBLY_R8_M6_0/A44_CAP_CORE128_M6_R1_0/CAP_BOTTOM_064 VDD pfet_03v3 ad=0 pd=0 as=0 ps=0 w=1.56u l=0.28u
X2574 VREFP A44_DCTRL_STRIP_W_R2_0/CTRL_OUT[5] A44_CDAC_CAP_BANK_ASSEMBLY_R8_M6_0/A44_CAP_CORE128_M6_R1_0/CAP_BOTTOM_064 VDD pfet_03v3 ad=0 pd=0 as=0 ps=0 w=1.56u l=0.28u
X2575 VREFP A44_DCTRL_STRIP_W_R2_0/CTRL_OUT[5] A44_CDAC_CAP_BANK_ASSEMBLY_R8_M6_0/A44_CAP_CORE128_M6_R1_0/CAP_BOTTOM_064 VDD pfet_03v3 ad=0 pd=0 as=0 ps=0 w=1.56u l=0.28u
X2576 VREFN A44_DCTRL_STRIP_W_R2_0/CTRL_OUT[5] A44_CDAC_CAP_BANK_ASSEMBLY_R8_M6_0/A44_CAP_CORE128_M6_R1_0/CAP_BOTTOM_064 GND nfet_03v3 ad=0 pd=0 as=16.6842p ps=77.76u w=1.56u l=0.28u
X2577 VREFN A44_DCTRL_STRIP_W_R2_0/CTRL_OUT[5] A44_CDAC_CAP_BANK_ASSEMBLY_R8_M6_0/A44_CAP_CORE128_M6_R1_0/CAP_BOTTOM_064 GND nfet_03v3 ad=0 pd=0 as=0 ps=0 w=1.56u l=0.28u
X2578 VREFN A44_DCTRL_STRIP_W_R2_0/CTRL_OUT[5] A44_CDAC_CAP_BANK_ASSEMBLY_R8_M6_0/A44_CAP_CORE128_M6_R1_0/CAP_BOTTOM_064 GND nfet_03v3 ad=0 pd=0 as=0 ps=0 w=1.56u l=0.28u
X2579 VREFN A44_DCTRL_STRIP_W_R2_0/CTRL_OUT[5] A44_CDAC_CAP_BANK_ASSEMBLY_R8_M6_0/A44_CAP_CORE128_M6_R1_0/CAP_BOTTOM_064 GND nfet_03v3 ad=0 pd=0 as=0 ps=0 w=1.56u l=0.28u
X2580 VREFN A44_DCTRL_STRIP_W_R2_0/CTRL_OUT[5] A44_CDAC_CAP_BANK_ASSEMBLY_R8_M6_0/A44_CAP_CORE128_M6_R1_0/CAP_BOTTOM_064 GND nfet_03v3 ad=0 pd=0 as=0 ps=0 w=1.56u l=0.28u
X2581 VREFN A44_DCTRL_STRIP_W_R2_0/CTRL_OUT[5] A44_CDAC_CAP_BANK_ASSEMBLY_R8_M6_0/A44_CAP_CORE128_M6_R1_0/CAP_BOTTOM_064 GND nfet_03v3 ad=0 pd=0 as=0 ps=0 w=1.56u l=0.28u
X2582 VREFN A44_DCTRL_STRIP_W_R2_0/CTRL_OUT[5] A44_CDAC_CAP_BANK_ASSEMBLY_R8_M6_0/A44_CAP_CORE128_M6_R1_0/CAP_BOTTOM_064 GND nfet_03v3 ad=0 pd=0 as=0 ps=0 w=1.56u l=0.28u
X2583 VREFN A44_DCTRL_STRIP_W_R2_0/CTRL_OUT[5] A44_CDAC_CAP_BANK_ASSEMBLY_R8_M6_0/A44_CAP_CORE128_M6_R1_0/CAP_BOTTOM_064 GND nfet_03v3 ad=0 pd=0 as=0 ps=0 w=1.56u l=0.28u
X2584 VREFN A44_DCTRL_STRIP_W_R2_0/CTRL_OUT[5] A44_CDAC_CAP_BANK_ASSEMBLY_R8_M6_0/A44_CAP_CORE128_M6_R1_0/CAP_BOTTOM_064 GND nfet_03v3 ad=0 pd=0 as=0 ps=0 w=1.56u l=0.28u
X2585 VREFN A44_DCTRL_STRIP_W_R2_0/CTRL_OUT[5] A44_CDAC_CAP_BANK_ASSEMBLY_R8_M6_0/A44_CAP_CORE128_M6_R1_0/CAP_BOTTOM_064 GND nfet_03v3 ad=0 pd=0 as=0 ps=0 w=1.56u l=0.28u
X2586 VREFN A44_DCTRL_STRIP_W_R2_0/CTRL_OUT[5] A44_CDAC_CAP_BANK_ASSEMBLY_R8_M6_0/A44_CAP_CORE128_M6_R1_0/CAP_BOTTOM_064 GND nfet_03v3 ad=0 pd=0 as=0 ps=0 w=1.56u l=0.28u
X2587 VREFN A44_DCTRL_STRIP_W_R2_0/CTRL_OUT[5] A44_CDAC_CAP_BANK_ASSEMBLY_R8_M6_0/A44_CAP_CORE128_M6_R1_0/CAP_BOTTOM_064 GND nfet_03v3 ad=0 pd=0 as=0 ps=0 w=1.56u l=0.28u
X2588 VREFN A44_DCTRL_STRIP_W_R2_0/CTRL_OUT[5] A44_CDAC_CAP_BANK_ASSEMBLY_R8_M6_0/A44_CAP_CORE128_M6_R1_0/CAP_BOTTOM_064 GND nfet_03v3 ad=0 pd=0 as=0 ps=0 w=1.56u l=0.28u
X2589 VREFN A44_DCTRL_STRIP_W_R2_0/CTRL_OUT[5] A44_CDAC_CAP_BANK_ASSEMBLY_R8_M6_0/A44_CAP_CORE128_M6_R1_0/CAP_BOTTOM_064 GND nfet_03v3 ad=0 pd=0 as=0 ps=0 w=1.56u l=0.28u
X2590 VREFN A44_DCTRL_STRIP_W_R2_0/CTRL_OUT[5] A44_CDAC_CAP_BANK_ASSEMBLY_R8_M6_0/A44_CAP_CORE128_M6_R1_0/CAP_BOTTOM_064 GND nfet_03v3 ad=0 pd=0 as=0 ps=0 w=1.56u l=0.28u
X2591 VREFN A44_DCTRL_STRIP_W_R2_0/CTRL_OUT[5] A44_CDAC_CAP_BANK_ASSEMBLY_R8_M6_0/A44_CAP_CORE128_M6_R1_0/CAP_BOTTOM_064 GND nfet_03v3 ad=0 pd=0 as=0 ps=0 w=1.56u l=0.28u
X2592 VREFN A44_DCTRL_STRIP_W_R2_0/CTRL_OUT[5] A44_CDAC_CAP_BANK_ASSEMBLY_R8_M6_0/A44_CAP_CORE128_M6_R1_0/CAP_BOTTOM_064 GND nfet_03v3 ad=0 pd=0 as=0 ps=0 w=1.56u l=0.28u
X2593 VREFN A44_DCTRL_STRIP_W_R2_0/CTRL_OUT[5] A44_CDAC_CAP_BANK_ASSEMBLY_R8_M6_0/A44_CAP_CORE128_M6_R1_0/CAP_BOTTOM_064 GND nfet_03v3 ad=0 pd=0 as=0 ps=0 w=1.56u l=0.28u
X2594 VREFP A44_DCTRL_STRIP_W_R2_0/CTRL_OUT[7] A44_CDAC_CAP_BANK_ASSEMBLY_R8_M6_0/A44_CAP_CORE128_M6_R1_0/CAP_BOTTOM_126 VDD pfet_03v3 ad=0 pd=0 as=16.6842p ps=77.76u w=1.56u l=0.28u
X2595 VREFP A44_DCTRL_STRIP_W_R2_0/CTRL_OUT[7] A44_CDAC_CAP_BANK_ASSEMBLY_R8_M6_0/A44_CAP_CORE128_M6_R1_0/CAP_BOTTOM_126 VDD pfet_03v3 ad=0 pd=0 as=0 ps=0 w=1.56u l=0.28u
X2596 VREFP A44_DCTRL_STRIP_W_R2_0/CTRL_OUT[7] A44_CDAC_CAP_BANK_ASSEMBLY_R8_M6_0/A44_CAP_CORE128_M6_R1_0/CAP_BOTTOM_126 VDD pfet_03v3 ad=0 pd=0 as=0 ps=0 w=1.56u l=0.28u
X2597 VREFP A44_DCTRL_STRIP_W_R2_0/CTRL_OUT[7] A44_CDAC_CAP_BANK_ASSEMBLY_R8_M6_0/A44_CAP_CORE128_M6_R1_0/CAP_BOTTOM_126 VDD pfet_03v3 ad=0 pd=0 as=0 ps=0 w=1.56u l=0.28u
X2598 VREFP A44_DCTRL_STRIP_W_R2_0/CTRL_OUT[7] A44_CDAC_CAP_BANK_ASSEMBLY_R8_M6_0/A44_CAP_CORE128_M6_R1_0/CAP_BOTTOM_126 VDD pfet_03v3 ad=0 pd=0 as=0 ps=0 w=1.56u l=0.28u
X2599 VREFP A44_DCTRL_STRIP_W_R2_0/CTRL_OUT[7] A44_CDAC_CAP_BANK_ASSEMBLY_R8_M6_0/A44_CAP_CORE128_M6_R1_0/CAP_BOTTOM_126 VDD pfet_03v3 ad=0 pd=0 as=0 ps=0 w=1.56u l=0.28u
X2600 VREFP A44_DCTRL_STRIP_W_R2_0/CTRL_OUT[7] A44_CDAC_CAP_BANK_ASSEMBLY_R8_M6_0/A44_CAP_CORE128_M6_R1_0/CAP_BOTTOM_126 VDD pfet_03v3 ad=0 pd=0 as=0 ps=0 w=1.56u l=0.28u
X2601 VREFP A44_DCTRL_STRIP_W_R2_0/CTRL_OUT[7] A44_CDAC_CAP_BANK_ASSEMBLY_R8_M6_0/A44_CAP_CORE128_M6_R1_0/CAP_BOTTOM_126 VDD pfet_03v3 ad=0 pd=0 as=0 ps=0 w=1.56u l=0.28u
X2602 VREFP A44_DCTRL_STRIP_W_R2_0/CTRL_OUT[7] A44_CDAC_CAP_BANK_ASSEMBLY_R8_M6_0/A44_CAP_CORE128_M6_R1_0/CAP_BOTTOM_126 VDD pfet_03v3 ad=0 pd=0 as=0 ps=0 w=1.56u l=0.28u
X2603 VREFP A44_DCTRL_STRIP_W_R2_0/CTRL_OUT[7] A44_CDAC_CAP_BANK_ASSEMBLY_R8_M6_0/A44_CAP_CORE128_M6_R1_0/CAP_BOTTOM_126 VDD pfet_03v3 ad=0 pd=0 as=0 ps=0 w=1.56u l=0.28u
X2604 VREFP A44_DCTRL_STRIP_W_R2_0/CTRL_OUT[7] A44_CDAC_CAP_BANK_ASSEMBLY_R8_M6_0/A44_CAP_CORE128_M6_R1_0/CAP_BOTTOM_126 VDD pfet_03v3 ad=0 pd=0 as=0 ps=0 w=1.56u l=0.28u
X2605 VREFP A44_DCTRL_STRIP_W_R2_0/CTRL_OUT[7] A44_CDAC_CAP_BANK_ASSEMBLY_R8_M6_0/A44_CAP_CORE128_M6_R1_0/CAP_BOTTOM_126 VDD pfet_03v3 ad=0 pd=0 as=0 ps=0 w=1.56u l=0.28u
X2606 VREFP A44_DCTRL_STRIP_W_R2_0/CTRL_OUT[7] A44_CDAC_CAP_BANK_ASSEMBLY_R8_M6_0/A44_CAP_CORE128_M6_R1_0/CAP_BOTTOM_126 VDD pfet_03v3 ad=0 pd=0 as=0 ps=0 w=1.56u l=0.28u
X2607 VREFP A44_DCTRL_STRIP_W_R2_0/CTRL_OUT[7] A44_CDAC_CAP_BANK_ASSEMBLY_R8_M6_0/A44_CAP_CORE128_M6_R1_0/CAP_BOTTOM_126 VDD pfet_03v3 ad=0 pd=0 as=0 ps=0 w=1.56u l=0.28u
X2608 VREFP A44_DCTRL_STRIP_W_R2_0/CTRL_OUT[7] A44_CDAC_CAP_BANK_ASSEMBLY_R8_M6_0/A44_CAP_CORE128_M6_R1_0/CAP_BOTTOM_126 VDD pfet_03v3 ad=0 pd=0 as=0 ps=0 w=1.56u l=0.28u
X2609 VREFP A44_DCTRL_STRIP_W_R2_0/CTRL_OUT[7] A44_CDAC_CAP_BANK_ASSEMBLY_R8_M6_0/A44_CAP_CORE128_M6_R1_0/CAP_BOTTOM_126 VDD pfet_03v3 ad=0 pd=0 as=0 ps=0 w=1.56u l=0.28u
X2610 VREFP A44_DCTRL_STRIP_W_R2_0/CTRL_OUT[7] A44_CDAC_CAP_BANK_ASSEMBLY_R8_M6_0/A44_CAP_CORE128_M6_R1_0/CAP_BOTTOM_126 VDD pfet_03v3 ad=0 pd=0 as=0 ps=0 w=1.56u l=0.28u
X2611 VREFP A44_DCTRL_STRIP_W_R2_0/CTRL_OUT[7] A44_CDAC_CAP_BANK_ASSEMBLY_R8_M6_0/A44_CAP_CORE128_M6_R1_0/CAP_BOTTOM_126 VDD pfet_03v3 ad=0 pd=0 as=0 ps=0 w=1.56u l=0.28u
X2612 VREFN A44_DCTRL_STRIP_W_R2_0/CTRL_OUT[7] A44_CDAC_CAP_BANK_ASSEMBLY_R8_M6_0/A44_CAP_CORE128_M6_R1_0/CAP_BOTTOM_126 GND nfet_03v3 ad=0 pd=0 as=16.6842p ps=77.76u w=1.56u l=0.28u
X2613 VREFN A44_DCTRL_STRIP_W_R2_0/CTRL_OUT[7] A44_CDAC_CAP_BANK_ASSEMBLY_R8_M6_0/A44_CAP_CORE128_M6_R1_0/CAP_BOTTOM_126 GND nfet_03v3 ad=0 pd=0 as=0 ps=0 w=1.56u l=0.28u
X2614 VREFN A44_DCTRL_STRIP_W_R2_0/CTRL_OUT[7] A44_CDAC_CAP_BANK_ASSEMBLY_R8_M6_0/A44_CAP_CORE128_M6_R1_0/CAP_BOTTOM_126 GND nfet_03v3 ad=0 pd=0 as=0 ps=0 w=1.56u l=0.28u
X2615 VREFN A44_DCTRL_STRIP_W_R2_0/CTRL_OUT[7] A44_CDAC_CAP_BANK_ASSEMBLY_R8_M6_0/A44_CAP_CORE128_M6_R1_0/CAP_BOTTOM_126 GND nfet_03v3 ad=0 pd=0 as=0 ps=0 w=1.56u l=0.28u
X2616 VREFN A44_DCTRL_STRIP_W_R2_0/CTRL_OUT[7] A44_CDAC_CAP_BANK_ASSEMBLY_R8_M6_0/A44_CAP_CORE128_M6_R1_0/CAP_BOTTOM_126 GND nfet_03v3 ad=0 pd=0 as=0 ps=0 w=1.56u l=0.28u
X2617 VREFN A44_DCTRL_STRIP_W_R2_0/CTRL_OUT[7] A44_CDAC_CAP_BANK_ASSEMBLY_R8_M6_0/A44_CAP_CORE128_M6_R1_0/CAP_BOTTOM_126 GND nfet_03v3 ad=0 pd=0 as=0 ps=0 w=1.56u l=0.28u
X2618 VREFN A44_DCTRL_STRIP_W_R2_0/CTRL_OUT[7] A44_CDAC_CAP_BANK_ASSEMBLY_R8_M6_0/A44_CAP_CORE128_M6_R1_0/CAP_BOTTOM_126 GND nfet_03v3 ad=0 pd=0 as=0 ps=0 w=1.56u l=0.28u
X2619 VREFN A44_DCTRL_STRIP_W_R2_0/CTRL_OUT[7] A44_CDAC_CAP_BANK_ASSEMBLY_R8_M6_0/A44_CAP_CORE128_M6_R1_0/CAP_BOTTOM_126 GND nfet_03v3 ad=0 pd=0 as=0 ps=0 w=1.56u l=0.28u
X2620 VREFN A44_DCTRL_STRIP_W_R2_0/CTRL_OUT[7] A44_CDAC_CAP_BANK_ASSEMBLY_R8_M6_0/A44_CAP_CORE128_M6_R1_0/CAP_BOTTOM_126 GND nfet_03v3 ad=0 pd=0 as=0 ps=0 w=1.56u l=0.28u
X2621 VREFN A44_DCTRL_STRIP_W_R2_0/CTRL_OUT[7] A44_CDAC_CAP_BANK_ASSEMBLY_R8_M6_0/A44_CAP_CORE128_M6_R1_0/CAP_BOTTOM_126 GND nfet_03v3 ad=0 pd=0 as=0 ps=0 w=1.56u l=0.28u
X2622 VREFN A44_DCTRL_STRIP_W_R2_0/CTRL_OUT[7] A44_CDAC_CAP_BANK_ASSEMBLY_R8_M6_0/A44_CAP_CORE128_M6_R1_0/CAP_BOTTOM_126 GND nfet_03v3 ad=0 pd=0 as=0 ps=0 w=1.56u l=0.28u
X2623 VREFN A44_DCTRL_STRIP_W_R2_0/CTRL_OUT[7] A44_CDAC_CAP_BANK_ASSEMBLY_R8_M6_0/A44_CAP_CORE128_M6_R1_0/CAP_BOTTOM_126 GND nfet_03v3 ad=0 pd=0 as=0 ps=0 w=1.56u l=0.28u
X2624 VREFN A44_DCTRL_STRIP_W_R2_0/CTRL_OUT[7] A44_CDAC_CAP_BANK_ASSEMBLY_R8_M6_0/A44_CAP_CORE128_M6_R1_0/CAP_BOTTOM_126 GND nfet_03v3 ad=0 pd=0 as=0 ps=0 w=1.56u l=0.28u
X2625 VREFN A44_DCTRL_STRIP_W_R2_0/CTRL_OUT[7] A44_CDAC_CAP_BANK_ASSEMBLY_R8_M6_0/A44_CAP_CORE128_M6_R1_0/CAP_BOTTOM_126 GND nfet_03v3 ad=0 pd=0 as=0 ps=0 w=1.56u l=0.28u
X2626 VREFN A44_DCTRL_STRIP_W_R2_0/CTRL_OUT[7] A44_CDAC_CAP_BANK_ASSEMBLY_R8_M6_0/A44_CAP_CORE128_M6_R1_0/CAP_BOTTOM_126 GND nfet_03v3 ad=0 pd=0 as=0 ps=0 w=1.56u l=0.28u
X2627 VREFN A44_DCTRL_STRIP_W_R2_0/CTRL_OUT[7] A44_CDAC_CAP_BANK_ASSEMBLY_R8_M6_0/A44_CAP_CORE128_M6_R1_0/CAP_BOTTOM_126 GND nfet_03v3 ad=0 pd=0 as=0 ps=0 w=1.56u l=0.28u
X2628 VREFN A44_DCTRL_STRIP_W_R2_0/CTRL_OUT[7] A44_CDAC_CAP_BANK_ASSEMBLY_R8_M6_0/A44_CAP_CORE128_M6_R1_0/CAP_BOTTOM_126 GND nfet_03v3 ad=0 pd=0 as=0 ps=0 w=1.56u l=0.28u
X2629 VREFN A44_DCTRL_STRIP_W_R2_0/CTRL_OUT[7] A44_CDAC_CAP_BANK_ASSEMBLY_R8_M6_0/A44_CAP_CORE128_M6_R1_0/CAP_BOTTOM_126 GND nfet_03v3 ad=0 pd=0 as=0 ps=0 w=1.56u l=0.28u
X2630 VREFP A44_DCTRL_STRIP_W_R2_0/CTRL_OUT[7] A44_CDAC_CAP_BANK_ASSEMBLY_R8_M6_0/A44_CAP_CORE128_M6_R1_0/CAP_BOTTOM_087 VDD pfet_03v3 ad=0 pd=0 as=16.6842p ps=77.76u w=1.56u l=0.28u
X2631 VREFP A44_DCTRL_STRIP_W_R2_0/CTRL_OUT[7] A44_CDAC_CAP_BANK_ASSEMBLY_R8_M6_0/A44_CAP_CORE128_M6_R1_0/CAP_BOTTOM_087 VDD pfet_03v3 ad=0 pd=0 as=0 ps=0 w=1.56u l=0.28u
X2632 VREFP A44_DCTRL_STRIP_W_R2_0/CTRL_OUT[7] A44_CDAC_CAP_BANK_ASSEMBLY_R8_M6_0/A44_CAP_CORE128_M6_R1_0/CAP_BOTTOM_087 VDD pfet_03v3 ad=0 pd=0 as=0 ps=0 w=1.56u l=0.28u
X2633 VREFP A44_DCTRL_STRIP_W_R2_0/CTRL_OUT[7] A44_CDAC_CAP_BANK_ASSEMBLY_R8_M6_0/A44_CAP_CORE128_M6_R1_0/CAP_BOTTOM_087 VDD pfet_03v3 ad=0 pd=0 as=0 ps=0 w=1.56u l=0.28u
X2634 VREFP A44_DCTRL_STRIP_W_R2_0/CTRL_OUT[7] A44_CDAC_CAP_BANK_ASSEMBLY_R8_M6_0/A44_CAP_CORE128_M6_R1_0/CAP_BOTTOM_087 VDD pfet_03v3 ad=0 pd=0 as=0 ps=0 w=1.56u l=0.28u
X2635 VREFP A44_DCTRL_STRIP_W_R2_0/CTRL_OUT[7] A44_CDAC_CAP_BANK_ASSEMBLY_R8_M6_0/A44_CAP_CORE128_M6_R1_0/CAP_BOTTOM_087 VDD pfet_03v3 ad=0 pd=0 as=0 ps=0 w=1.56u l=0.28u
X2636 VREFP A44_DCTRL_STRIP_W_R2_0/CTRL_OUT[7] A44_CDAC_CAP_BANK_ASSEMBLY_R8_M6_0/A44_CAP_CORE128_M6_R1_0/CAP_BOTTOM_087 VDD pfet_03v3 ad=0 pd=0 as=0 ps=0 w=1.56u l=0.28u
X2637 VREFP A44_DCTRL_STRIP_W_R2_0/CTRL_OUT[7] A44_CDAC_CAP_BANK_ASSEMBLY_R8_M6_0/A44_CAP_CORE128_M6_R1_0/CAP_BOTTOM_087 VDD pfet_03v3 ad=0 pd=0 as=0 ps=0 w=1.56u l=0.28u
X2638 VREFP A44_DCTRL_STRIP_W_R2_0/CTRL_OUT[7] A44_CDAC_CAP_BANK_ASSEMBLY_R8_M6_0/A44_CAP_CORE128_M6_R1_0/CAP_BOTTOM_087 VDD pfet_03v3 ad=0 pd=0 as=0 ps=0 w=1.56u l=0.28u
X2639 VREFP A44_DCTRL_STRIP_W_R2_0/CTRL_OUT[7] A44_CDAC_CAP_BANK_ASSEMBLY_R8_M6_0/A44_CAP_CORE128_M6_R1_0/CAP_BOTTOM_087 VDD pfet_03v3 ad=0 pd=0 as=0 ps=0 w=1.56u l=0.28u
X2640 VREFP A44_DCTRL_STRIP_W_R2_0/CTRL_OUT[7] A44_CDAC_CAP_BANK_ASSEMBLY_R8_M6_0/A44_CAP_CORE128_M6_R1_0/CAP_BOTTOM_087 VDD pfet_03v3 ad=0 pd=0 as=0 ps=0 w=1.56u l=0.28u
X2641 VREFP A44_DCTRL_STRIP_W_R2_0/CTRL_OUT[7] A44_CDAC_CAP_BANK_ASSEMBLY_R8_M6_0/A44_CAP_CORE128_M6_R1_0/CAP_BOTTOM_087 VDD pfet_03v3 ad=0 pd=0 as=0 ps=0 w=1.56u l=0.28u
X2642 VREFP A44_DCTRL_STRIP_W_R2_0/CTRL_OUT[7] A44_CDAC_CAP_BANK_ASSEMBLY_R8_M6_0/A44_CAP_CORE128_M6_R1_0/CAP_BOTTOM_087 VDD pfet_03v3 ad=0 pd=0 as=0 ps=0 w=1.56u l=0.28u
X2643 VREFP A44_DCTRL_STRIP_W_R2_0/CTRL_OUT[7] A44_CDAC_CAP_BANK_ASSEMBLY_R8_M6_0/A44_CAP_CORE128_M6_R1_0/CAP_BOTTOM_087 VDD pfet_03v3 ad=0 pd=0 as=0 ps=0 w=1.56u l=0.28u
X2644 VREFP A44_DCTRL_STRIP_W_R2_0/CTRL_OUT[7] A44_CDAC_CAP_BANK_ASSEMBLY_R8_M6_0/A44_CAP_CORE128_M6_R1_0/CAP_BOTTOM_087 VDD pfet_03v3 ad=0 pd=0 as=0 ps=0 w=1.56u l=0.28u
X2645 VREFP A44_DCTRL_STRIP_W_R2_0/CTRL_OUT[7] A44_CDAC_CAP_BANK_ASSEMBLY_R8_M6_0/A44_CAP_CORE128_M6_R1_0/CAP_BOTTOM_087 VDD pfet_03v3 ad=0 pd=0 as=0 ps=0 w=1.56u l=0.28u
X2646 VREFP A44_DCTRL_STRIP_W_R2_0/CTRL_OUT[7] A44_CDAC_CAP_BANK_ASSEMBLY_R8_M6_0/A44_CAP_CORE128_M6_R1_0/CAP_BOTTOM_087 VDD pfet_03v3 ad=0 pd=0 as=0 ps=0 w=1.56u l=0.28u
X2647 VREFP A44_DCTRL_STRIP_W_R2_0/CTRL_OUT[7] A44_CDAC_CAP_BANK_ASSEMBLY_R8_M6_0/A44_CAP_CORE128_M6_R1_0/CAP_BOTTOM_087 VDD pfet_03v3 ad=0 pd=0 as=0 ps=0 w=1.56u l=0.28u
X2648 VREFN A44_DCTRL_STRIP_W_R2_0/CTRL_OUT[7] A44_CDAC_CAP_BANK_ASSEMBLY_R8_M6_0/A44_CAP_CORE128_M6_R1_0/CAP_BOTTOM_087 GND nfet_03v3 ad=0 pd=0 as=16.6842p ps=77.76u w=1.56u l=0.28u
X2649 VREFN A44_DCTRL_STRIP_W_R2_0/CTRL_OUT[7] A44_CDAC_CAP_BANK_ASSEMBLY_R8_M6_0/A44_CAP_CORE128_M6_R1_0/CAP_BOTTOM_087 GND nfet_03v3 ad=0 pd=0 as=0 ps=0 w=1.56u l=0.28u
X2650 VREFN A44_DCTRL_STRIP_W_R2_0/CTRL_OUT[7] A44_CDAC_CAP_BANK_ASSEMBLY_R8_M6_0/A44_CAP_CORE128_M6_R1_0/CAP_BOTTOM_087 GND nfet_03v3 ad=0 pd=0 as=0 ps=0 w=1.56u l=0.28u
X2651 VREFN A44_DCTRL_STRIP_W_R2_0/CTRL_OUT[7] A44_CDAC_CAP_BANK_ASSEMBLY_R8_M6_0/A44_CAP_CORE128_M6_R1_0/CAP_BOTTOM_087 GND nfet_03v3 ad=0 pd=0 as=0 ps=0 w=1.56u l=0.28u
X2652 VREFN A44_DCTRL_STRIP_W_R2_0/CTRL_OUT[7] A44_CDAC_CAP_BANK_ASSEMBLY_R8_M6_0/A44_CAP_CORE128_M6_R1_0/CAP_BOTTOM_087 GND nfet_03v3 ad=0 pd=0 as=0 ps=0 w=1.56u l=0.28u
X2653 VREFN A44_DCTRL_STRIP_W_R2_0/CTRL_OUT[7] A44_CDAC_CAP_BANK_ASSEMBLY_R8_M6_0/A44_CAP_CORE128_M6_R1_0/CAP_BOTTOM_087 GND nfet_03v3 ad=0 pd=0 as=0 ps=0 w=1.56u l=0.28u
X2654 VREFN A44_DCTRL_STRIP_W_R2_0/CTRL_OUT[7] A44_CDAC_CAP_BANK_ASSEMBLY_R8_M6_0/A44_CAP_CORE128_M6_R1_0/CAP_BOTTOM_087 GND nfet_03v3 ad=0 pd=0 as=0 ps=0 w=1.56u l=0.28u
X2655 VREFN A44_DCTRL_STRIP_W_R2_0/CTRL_OUT[7] A44_CDAC_CAP_BANK_ASSEMBLY_R8_M6_0/A44_CAP_CORE128_M6_R1_0/CAP_BOTTOM_087 GND nfet_03v3 ad=0 pd=0 as=0 ps=0 w=1.56u l=0.28u
X2656 VREFN A44_DCTRL_STRIP_W_R2_0/CTRL_OUT[7] A44_CDAC_CAP_BANK_ASSEMBLY_R8_M6_0/A44_CAP_CORE128_M6_R1_0/CAP_BOTTOM_087 GND nfet_03v3 ad=0 pd=0 as=0 ps=0 w=1.56u l=0.28u
X2657 VREFN A44_DCTRL_STRIP_W_R2_0/CTRL_OUT[7] A44_CDAC_CAP_BANK_ASSEMBLY_R8_M6_0/A44_CAP_CORE128_M6_R1_0/CAP_BOTTOM_087 GND nfet_03v3 ad=0 pd=0 as=0 ps=0 w=1.56u l=0.28u
X2658 VREFN A44_DCTRL_STRIP_W_R2_0/CTRL_OUT[7] A44_CDAC_CAP_BANK_ASSEMBLY_R8_M6_0/A44_CAP_CORE128_M6_R1_0/CAP_BOTTOM_087 GND nfet_03v3 ad=0 pd=0 as=0 ps=0 w=1.56u l=0.28u
X2659 VREFN A44_DCTRL_STRIP_W_R2_0/CTRL_OUT[7] A44_CDAC_CAP_BANK_ASSEMBLY_R8_M6_0/A44_CAP_CORE128_M6_R1_0/CAP_BOTTOM_087 GND nfet_03v3 ad=0 pd=0 as=0 ps=0 w=1.56u l=0.28u
X2660 VREFN A44_DCTRL_STRIP_W_R2_0/CTRL_OUT[7] A44_CDAC_CAP_BANK_ASSEMBLY_R8_M6_0/A44_CAP_CORE128_M6_R1_0/CAP_BOTTOM_087 GND nfet_03v3 ad=0 pd=0 as=0 ps=0 w=1.56u l=0.28u
X2661 VREFN A44_DCTRL_STRIP_W_R2_0/CTRL_OUT[7] A44_CDAC_CAP_BANK_ASSEMBLY_R8_M6_0/A44_CAP_CORE128_M6_R1_0/CAP_BOTTOM_087 GND nfet_03v3 ad=0 pd=0 as=0 ps=0 w=1.56u l=0.28u
X2662 VREFN A44_DCTRL_STRIP_W_R2_0/CTRL_OUT[7] A44_CDAC_CAP_BANK_ASSEMBLY_R8_M6_0/A44_CAP_CORE128_M6_R1_0/CAP_BOTTOM_087 GND nfet_03v3 ad=0 pd=0 as=0 ps=0 w=1.56u l=0.28u
X2663 VREFN A44_DCTRL_STRIP_W_R2_0/CTRL_OUT[7] A44_CDAC_CAP_BANK_ASSEMBLY_R8_M6_0/A44_CAP_CORE128_M6_R1_0/CAP_BOTTOM_087 GND nfet_03v3 ad=0 pd=0 as=0 ps=0 w=1.56u l=0.28u
X2664 VREFN A44_DCTRL_STRIP_W_R2_0/CTRL_OUT[7] A44_CDAC_CAP_BANK_ASSEMBLY_R8_M6_0/A44_CAP_CORE128_M6_R1_0/CAP_BOTTOM_087 GND nfet_03v3 ad=0 pd=0 as=0 ps=0 w=1.56u l=0.28u
X2665 VREFN A44_DCTRL_STRIP_W_R2_0/CTRL_OUT[7] A44_CDAC_CAP_BANK_ASSEMBLY_R8_M6_0/A44_CAP_CORE128_M6_R1_0/CAP_BOTTOM_087 GND nfet_03v3 ad=0 pd=0 as=0 ps=0 w=1.56u l=0.28u
X2666 VREFP A44_DCTRL_STRIP_W_R2_0/CTRL_OUT[6] A44_CDAC_CAP_BANK_ASSEMBLY_R8_M6_0/A44_CAP_CORE128_M6_R1_0/CAP_BOTTOM_084 VDD pfet_03v3 ad=0 pd=0 as=16.6842p ps=77.76u w=1.56u l=0.28u
X2667 VREFP A44_DCTRL_STRIP_W_R2_0/CTRL_OUT[6] A44_CDAC_CAP_BANK_ASSEMBLY_R8_M6_0/A44_CAP_CORE128_M6_R1_0/CAP_BOTTOM_084 VDD pfet_03v3 ad=0 pd=0 as=0 ps=0 w=1.56u l=0.28u
X2668 VREFP A44_DCTRL_STRIP_W_R2_0/CTRL_OUT[6] A44_CDAC_CAP_BANK_ASSEMBLY_R8_M6_0/A44_CAP_CORE128_M6_R1_0/CAP_BOTTOM_084 VDD pfet_03v3 ad=0 pd=0 as=0 ps=0 w=1.56u l=0.28u
X2669 VREFP A44_DCTRL_STRIP_W_R2_0/CTRL_OUT[6] A44_CDAC_CAP_BANK_ASSEMBLY_R8_M6_0/A44_CAP_CORE128_M6_R1_0/CAP_BOTTOM_084 VDD pfet_03v3 ad=0 pd=0 as=0 ps=0 w=1.56u l=0.28u
X2670 VREFP A44_DCTRL_STRIP_W_R2_0/CTRL_OUT[6] A44_CDAC_CAP_BANK_ASSEMBLY_R8_M6_0/A44_CAP_CORE128_M6_R1_0/CAP_BOTTOM_084 VDD pfet_03v3 ad=0 pd=0 as=0 ps=0 w=1.56u l=0.28u
X2671 VREFP A44_DCTRL_STRIP_W_R2_0/CTRL_OUT[6] A44_CDAC_CAP_BANK_ASSEMBLY_R8_M6_0/A44_CAP_CORE128_M6_R1_0/CAP_BOTTOM_084 VDD pfet_03v3 ad=0 pd=0 as=0 ps=0 w=1.56u l=0.28u
X2672 VREFP A44_DCTRL_STRIP_W_R2_0/CTRL_OUT[6] A44_CDAC_CAP_BANK_ASSEMBLY_R8_M6_0/A44_CAP_CORE128_M6_R1_0/CAP_BOTTOM_084 VDD pfet_03v3 ad=0 pd=0 as=0 ps=0 w=1.56u l=0.28u
X2673 VREFP A44_DCTRL_STRIP_W_R2_0/CTRL_OUT[6] A44_CDAC_CAP_BANK_ASSEMBLY_R8_M6_0/A44_CAP_CORE128_M6_R1_0/CAP_BOTTOM_084 VDD pfet_03v3 ad=0 pd=0 as=0 ps=0 w=1.56u l=0.28u
X2674 VREFP A44_DCTRL_STRIP_W_R2_0/CTRL_OUT[6] A44_CDAC_CAP_BANK_ASSEMBLY_R8_M6_0/A44_CAP_CORE128_M6_R1_0/CAP_BOTTOM_084 VDD pfet_03v3 ad=0 pd=0 as=0 ps=0 w=1.56u l=0.28u
X2675 VREFP A44_DCTRL_STRIP_W_R2_0/CTRL_OUT[6] A44_CDAC_CAP_BANK_ASSEMBLY_R8_M6_0/A44_CAP_CORE128_M6_R1_0/CAP_BOTTOM_084 VDD pfet_03v3 ad=0 pd=0 as=0 ps=0 w=1.56u l=0.28u
X2676 VREFP A44_DCTRL_STRIP_W_R2_0/CTRL_OUT[6] A44_CDAC_CAP_BANK_ASSEMBLY_R8_M6_0/A44_CAP_CORE128_M6_R1_0/CAP_BOTTOM_084 VDD pfet_03v3 ad=0 pd=0 as=0 ps=0 w=1.56u l=0.28u
X2677 VREFP A44_DCTRL_STRIP_W_R2_0/CTRL_OUT[6] A44_CDAC_CAP_BANK_ASSEMBLY_R8_M6_0/A44_CAP_CORE128_M6_R1_0/CAP_BOTTOM_084 VDD pfet_03v3 ad=0 pd=0 as=0 ps=0 w=1.56u l=0.28u
X2678 VREFP A44_DCTRL_STRIP_W_R2_0/CTRL_OUT[6] A44_CDAC_CAP_BANK_ASSEMBLY_R8_M6_0/A44_CAP_CORE128_M6_R1_0/CAP_BOTTOM_084 VDD pfet_03v3 ad=0 pd=0 as=0 ps=0 w=1.56u l=0.28u
X2679 VREFP A44_DCTRL_STRIP_W_R2_0/CTRL_OUT[6] A44_CDAC_CAP_BANK_ASSEMBLY_R8_M6_0/A44_CAP_CORE128_M6_R1_0/CAP_BOTTOM_084 VDD pfet_03v3 ad=0 pd=0 as=0 ps=0 w=1.56u l=0.28u
X2680 VREFP A44_DCTRL_STRIP_W_R2_0/CTRL_OUT[6] A44_CDAC_CAP_BANK_ASSEMBLY_R8_M6_0/A44_CAP_CORE128_M6_R1_0/CAP_BOTTOM_084 VDD pfet_03v3 ad=0 pd=0 as=0 ps=0 w=1.56u l=0.28u
X2681 VREFP A44_DCTRL_STRIP_W_R2_0/CTRL_OUT[6] A44_CDAC_CAP_BANK_ASSEMBLY_R8_M6_0/A44_CAP_CORE128_M6_R1_0/CAP_BOTTOM_084 VDD pfet_03v3 ad=0 pd=0 as=0 ps=0 w=1.56u l=0.28u
X2682 VREFP A44_DCTRL_STRIP_W_R2_0/CTRL_OUT[6] A44_CDAC_CAP_BANK_ASSEMBLY_R8_M6_0/A44_CAP_CORE128_M6_R1_0/CAP_BOTTOM_084 VDD pfet_03v3 ad=0 pd=0 as=0 ps=0 w=1.56u l=0.28u
X2683 VREFP A44_DCTRL_STRIP_W_R2_0/CTRL_OUT[6] A44_CDAC_CAP_BANK_ASSEMBLY_R8_M6_0/A44_CAP_CORE128_M6_R1_0/CAP_BOTTOM_084 VDD pfet_03v3 ad=0 pd=0 as=0 ps=0 w=1.56u l=0.28u
X2684 VREFN A44_DCTRL_STRIP_W_R2_0/CTRL_OUT[6] A44_CDAC_CAP_BANK_ASSEMBLY_R8_M6_0/A44_CAP_CORE128_M6_R1_0/CAP_BOTTOM_084 GND nfet_03v3 ad=0 pd=0 as=16.6842p ps=77.76u w=1.56u l=0.28u
X2685 VREFN A44_DCTRL_STRIP_W_R2_0/CTRL_OUT[6] A44_CDAC_CAP_BANK_ASSEMBLY_R8_M6_0/A44_CAP_CORE128_M6_R1_0/CAP_BOTTOM_084 GND nfet_03v3 ad=0 pd=0 as=0 ps=0 w=1.56u l=0.28u
X2686 VREFN A44_DCTRL_STRIP_W_R2_0/CTRL_OUT[6] A44_CDAC_CAP_BANK_ASSEMBLY_R8_M6_0/A44_CAP_CORE128_M6_R1_0/CAP_BOTTOM_084 GND nfet_03v3 ad=0 pd=0 as=0 ps=0 w=1.56u l=0.28u
X2687 VREFN A44_DCTRL_STRIP_W_R2_0/CTRL_OUT[6] A44_CDAC_CAP_BANK_ASSEMBLY_R8_M6_0/A44_CAP_CORE128_M6_R1_0/CAP_BOTTOM_084 GND nfet_03v3 ad=0 pd=0 as=0 ps=0 w=1.56u l=0.28u
X2688 VREFN A44_DCTRL_STRIP_W_R2_0/CTRL_OUT[6] A44_CDAC_CAP_BANK_ASSEMBLY_R8_M6_0/A44_CAP_CORE128_M6_R1_0/CAP_BOTTOM_084 GND nfet_03v3 ad=0 pd=0 as=0 ps=0 w=1.56u l=0.28u
X2689 VREFN A44_DCTRL_STRIP_W_R2_0/CTRL_OUT[6] A44_CDAC_CAP_BANK_ASSEMBLY_R8_M6_0/A44_CAP_CORE128_M6_R1_0/CAP_BOTTOM_084 GND nfet_03v3 ad=0 pd=0 as=0 ps=0 w=1.56u l=0.28u
X2690 VREFN A44_DCTRL_STRIP_W_R2_0/CTRL_OUT[6] A44_CDAC_CAP_BANK_ASSEMBLY_R8_M6_0/A44_CAP_CORE128_M6_R1_0/CAP_BOTTOM_084 GND nfet_03v3 ad=0 pd=0 as=0 ps=0 w=1.56u l=0.28u
X2691 VREFN A44_DCTRL_STRIP_W_R2_0/CTRL_OUT[6] A44_CDAC_CAP_BANK_ASSEMBLY_R8_M6_0/A44_CAP_CORE128_M6_R1_0/CAP_BOTTOM_084 GND nfet_03v3 ad=0 pd=0 as=0 ps=0 w=1.56u l=0.28u
X2692 VREFN A44_DCTRL_STRIP_W_R2_0/CTRL_OUT[6] A44_CDAC_CAP_BANK_ASSEMBLY_R8_M6_0/A44_CAP_CORE128_M6_R1_0/CAP_BOTTOM_084 GND nfet_03v3 ad=0 pd=0 as=0 ps=0 w=1.56u l=0.28u
X2693 VREFN A44_DCTRL_STRIP_W_R2_0/CTRL_OUT[6] A44_CDAC_CAP_BANK_ASSEMBLY_R8_M6_0/A44_CAP_CORE128_M6_R1_0/CAP_BOTTOM_084 GND nfet_03v3 ad=0 pd=0 as=0 ps=0 w=1.56u l=0.28u
X2694 VREFN A44_DCTRL_STRIP_W_R2_0/CTRL_OUT[6] A44_CDAC_CAP_BANK_ASSEMBLY_R8_M6_0/A44_CAP_CORE128_M6_R1_0/CAP_BOTTOM_084 GND nfet_03v3 ad=0 pd=0 as=0 ps=0 w=1.56u l=0.28u
X2695 VREFN A44_DCTRL_STRIP_W_R2_0/CTRL_OUT[6] A44_CDAC_CAP_BANK_ASSEMBLY_R8_M6_0/A44_CAP_CORE128_M6_R1_0/CAP_BOTTOM_084 GND nfet_03v3 ad=0 pd=0 as=0 ps=0 w=1.56u l=0.28u
X2696 VREFN A44_DCTRL_STRIP_W_R2_0/CTRL_OUT[6] A44_CDAC_CAP_BANK_ASSEMBLY_R8_M6_0/A44_CAP_CORE128_M6_R1_0/CAP_BOTTOM_084 GND nfet_03v3 ad=0 pd=0 as=0 ps=0 w=1.56u l=0.28u
X2697 VREFN A44_DCTRL_STRIP_W_R2_0/CTRL_OUT[6] A44_CDAC_CAP_BANK_ASSEMBLY_R8_M6_0/A44_CAP_CORE128_M6_R1_0/CAP_BOTTOM_084 GND nfet_03v3 ad=0 pd=0 as=0 ps=0 w=1.56u l=0.28u
X2698 VREFN A44_DCTRL_STRIP_W_R2_0/CTRL_OUT[6] A44_CDAC_CAP_BANK_ASSEMBLY_R8_M6_0/A44_CAP_CORE128_M6_R1_0/CAP_BOTTOM_084 GND nfet_03v3 ad=0 pd=0 as=0 ps=0 w=1.56u l=0.28u
X2699 VREFN A44_DCTRL_STRIP_W_R2_0/CTRL_OUT[6] A44_CDAC_CAP_BANK_ASSEMBLY_R8_M6_0/A44_CAP_CORE128_M6_R1_0/CAP_BOTTOM_084 GND nfet_03v3 ad=0 pd=0 as=0 ps=0 w=1.56u l=0.28u
X2700 VREFN A44_DCTRL_STRIP_W_R2_0/CTRL_OUT[6] A44_CDAC_CAP_BANK_ASSEMBLY_R8_M6_0/A44_CAP_CORE128_M6_R1_0/CAP_BOTTOM_084 GND nfet_03v3 ad=0 pd=0 as=0 ps=0 w=1.56u l=0.28u
X2701 VREFN A44_DCTRL_STRIP_W_R2_0/CTRL_OUT[6] A44_CDAC_CAP_BANK_ASSEMBLY_R8_M6_0/A44_CAP_CORE128_M6_R1_0/CAP_BOTTOM_084 GND nfet_03v3 ad=0 pd=0 as=0 ps=0 w=1.56u l=0.28u
X2702 VREFP A44_DCTRL_STRIP_W_R2_0/CTRL_OUT[7] A44_CDAC_CAP_BANK_ASSEMBLY_R8_M6_0/A44_CAP_CORE128_M6_R1_0/CAP_BOTTOM_097 VDD pfet_03v3 ad=0 pd=0 as=16.6842p ps=77.76u w=1.56u l=0.28u
X2703 VREFP A44_DCTRL_STRIP_W_R2_0/CTRL_OUT[7] A44_CDAC_CAP_BANK_ASSEMBLY_R8_M6_0/A44_CAP_CORE128_M6_R1_0/CAP_BOTTOM_097 VDD pfet_03v3 ad=0 pd=0 as=0 ps=0 w=1.56u l=0.28u
X2704 VREFP A44_DCTRL_STRIP_W_R2_0/CTRL_OUT[7] A44_CDAC_CAP_BANK_ASSEMBLY_R8_M6_0/A44_CAP_CORE128_M6_R1_0/CAP_BOTTOM_097 VDD pfet_03v3 ad=0 pd=0 as=0 ps=0 w=1.56u l=0.28u
X2705 VREFP A44_DCTRL_STRIP_W_R2_0/CTRL_OUT[7] A44_CDAC_CAP_BANK_ASSEMBLY_R8_M6_0/A44_CAP_CORE128_M6_R1_0/CAP_BOTTOM_097 VDD pfet_03v3 ad=0 pd=0 as=0 ps=0 w=1.56u l=0.28u
X2706 VREFP A44_DCTRL_STRIP_W_R2_0/CTRL_OUT[7] A44_CDAC_CAP_BANK_ASSEMBLY_R8_M6_0/A44_CAP_CORE128_M6_R1_0/CAP_BOTTOM_097 VDD pfet_03v3 ad=0 pd=0 as=0 ps=0 w=1.56u l=0.28u
X2707 VREFP A44_DCTRL_STRIP_W_R2_0/CTRL_OUT[7] A44_CDAC_CAP_BANK_ASSEMBLY_R8_M6_0/A44_CAP_CORE128_M6_R1_0/CAP_BOTTOM_097 VDD pfet_03v3 ad=0 pd=0 as=0 ps=0 w=1.56u l=0.28u
X2708 VREFP A44_DCTRL_STRIP_W_R2_0/CTRL_OUT[7] A44_CDAC_CAP_BANK_ASSEMBLY_R8_M6_0/A44_CAP_CORE128_M6_R1_0/CAP_BOTTOM_097 VDD pfet_03v3 ad=0 pd=0 as=0 ps=0 w=1.56u l=0.28u
X2709 VREFP A44_DCTRL_STRIP_W_R2_0/CTRL_OUT[7] A44_CDAC_CAP_BANK_ASSEMBLY_R8_M6_0/A44_CAP_CORE128_M6_R1_0/CAP_BOTTOM_097 VDD pfet_03v3 ad=0 pd=0 as=0 ps=0 w=1.56u l=0.28u
X2710 VREFP A44_DCTRL_STRIP_W_R2_0/CTRL_OUT[7] A44_CDAC_CAP_BANK_ASSEMBLY_R8_M6_0/A44_CAP_CORE128_M6_R1_0/CAP_BOTTOM_097 VDD pfet_03v3 ad=0 pd=0 as=0 ps=0 w=1.56u l=0.28u
X2711 VREFP A44_DCTRL_STRIP_W_R2_0/CTRL_OUT[7] A44_CDAC_CAP_BANK_ASSEMBLY_R8_M6_0/A44_CAP_CORE128_M6_R1_0/CAP_BOTTOM_097 VDD pfet_03v3 ad=0 pd=0 as=0 ps=0 w=1.56u l=0.28u
X2712 VREFP A44_DCTRL_STRIP_W_R2_0/CTRL_OUT[7] A44_CDAC_CAP_BANK_ASSEMBLY_R8_M6_0/A44_CAP_CORE128_M6_R1_0/CAP_BOTTOM_097 VDD pfet_03v3 ad=0 pd=0 as=0 ps=0 w=1.56u l=0.28u
X2713 VREFP A44_DCTRL_STRIP_W_R2_0/CTRL_OUT[7] A44_CDAC_CAP_BANK_ASSEMBLY_R8_M6_0/A44_CAP_CORE128_M6_R1_0/CAP_BOTTOM_097 VDD pfet_03v3 ad=0 pd=0 as=0 ps=0 w=1.56u l=0.28u
X2714 VREFP A44_DCTRL_STRIP_W_R2_0/CTRL_OUT[7] A44_CDAC_CAP_BANK_ASSEMBLY_R8_M6_0/A44_CAP_CORE128_M6_R1_0/CAP_BOTTOM_097 VDD pfet_03v3 ad=0 pd=0 as=0 ps=0 w=1.56u l=0.28u
X2715 VREFP A44_DCTRL_STRIP_W_R2_0/CTRL_OUT[7] A44_CDAC_CAP_BANK_ASSEMBLY_R8_M6_0/A44_CAP_CORE128_M6_R1_0/CAP_BOTTOM_097 VDD pfet_03v3 ad=0 pd=0 as=0 ps=0 w=1.56u l=0.28u
X2716 VREFP A44_DCTRL_STRIP_W_R2_0/CTRL_OUT[7] A44_CDAC_CAP_BANK_ASSEMBLY_R8_M6_0/A44_CAP_CORE128_M6_R1_0/CAP_BOTTOM_097 VDD pfet_03v3 ad=0 pd=0 as=0 ps=0 w=1.56u l=0.28u
X2717 VREFP A44_DCTRL_STRIP_W_R2_0/CTRL_OUT[7] A44_CDAC_CAP_BANK_ASSEMBLY_R8_M6_0/A44_CAP_CORE128_M6_R1_0/CAP_BOTTOM_097 VDD pfet_03v3 ad=0 pd=0 as=0 ps=0 w=1.56u l=0.28u
X2718 VREFP A44_DCTRL_STRIP_W_R2_0/CTRL_OUT[7] A44_CDAC_CAP_BANK_ASSEMBLY_R8_M6_0/A44_CAP_CORE128_M6_R1_0/CAP_BOTTOM_097 VDD pfet_03v3 ad=0 pd=0 as=0 ps=0 w=1.56u l=0.28u
X2719 VREFP A44_DCTRL_STRIP_W_R2_0/CTRL_OUT[7] A44_CDAC_CAP_BANK_ASSEMBLY_R8_M6_0/A44_CAP_CORE128_M6_R1_0/CAP_BOTTOM_097 VDD pfet_03v3 ad=0 pd=0 as=0 ps=0 w=1.56u l=0.28u
X2720 VREFN A44_DCTRL_STRIP_W_R2_0/CTRL_OUT[7] A44_CDAC_CAP_BANK_ASSEMBLY_R8_M6_0/A44_CAP_CORE128_M6_R1_0/CAP_BOTTOM_097 GND nfet_03v3 ad=0 pd=0 as=16.6842p ps=77.76u w=1.56u l=0.28u
X2721 VREFN A44_DCTRL_STRIP_W_R2_0/CTRL_OUT[7] A44_CDAC_CAP_BANK_ASSEMBLY_R8_M6_0/A44_CAP_CORE128_M6_R1_0/CAP_BOTTOM_097 GND nfet_03v3 ad=0 pd=0 as=0 ps=0 w=1.56u l=0.28u
X2722 VREFN A44_DCTRL_STRIP_W_R2_0/CTRL_OUT[7] A44_CDAC_CAP_BANK_ASSEMBLY_R8_M6_0/A44_CAP_CORE128_M6_R1_0/CAP_BOTTOM_097 GND nfet_03v3 ad=0 pd=0 as=0 ps=0 w=1.56u l=0.28u
X2723 VREFN A44_DCTRL_STRIP_W_R2_0/CTRL_OUT[7] A44_CDAC_CAP_BANK_ASSEMBLY_R8_M6_0/A44_CAP_CORE128_M6_R1_0/CAP_BOTTOM_097 GND nfet_03v3 ad=0 pd=0 as=0 ps=0 w=1.56u l=0.28u
X2724 VREFN A44_DCTRL_STRIP_W_R2_0/CTRL_OUT[7] A44_CDAC_CAP_BANK_ASSEMBLY_R8_M6_0/A44_CAP_CORE128_M6_R1_0/CAP_BOTTOM_097 GND nfet_03v3 ad=0 pd=0 as=0 ps=0 w=1.56u l=0.28u
X2725 VREFN A44_DCTRL_STRIP_W_R2_0/CTRL_OUT[7] A44_CDAC_CAP_BANK_ASSEMBLY_R8_M6_0/A44_CAP_CORE128_M6_R1_0/CAP_BOTTOM_097 GND nfet_03v3 ad=0 pd=0 as=0 ps=0 w=1.56u l=0.28u
X2726 VREFN A44_DCTRL_STRIP_W_R2_0/CTRL_OUT[7] A44_CDAC_CAP_BANK_ASSEMBLY_R8_M6_0/A44_CAP_CORE128_M6_R1_0/CAP_BOTTOM_097 GND nfet_03v3 ad=0 pd=0 as=0 ps=0 w=1.56u l=0.28u
X2727 VREFN A44_DCTRL_STRIP_W_R2_0/CTRL_OUT[7] A44_CDAC_CAP_BANK_ASSEMBLY_R8_M6_0/A44_CAP_CORE128_M6_R1_0/CAP_BOTTOM_097 GND nfet_03v3 ad=0 pd=0 as=0 ps=0 w=1.56u l=0.28u
X2728 VREFN A44_DCTRL_STRIP_W_R2_0/CTRL_OUT[7] A44_CDAC_CAP_BANK_ASSEMBLY_R8_M6_0/A44_CAP_CORE128_M6_R1_0/CAP_BOTTOM_097 GND nfet_03v3 ad=0 pd=0 as=0 ps=0 w=1.56u l=0.28u
X2729 VREFN A44_DCTRL_STRIP_W_R2_0/CTRL_OUT[7] A44_CDAC_CAP_BANK_ASSEMBLY_R8_M6_0/A44_CAP_CORE128_M6_R1_0/CAP_BOTTOM_097 GND nfet_03v3 ad=0 pd=0 as=0 ps=0 w=1.56u l=0.28u
X2730 VREFN A44_DCTRL_STRIP_W_R2_0/CTRL_OUT[7] A44_CDAC_CAP_BANK_ASSEMBLY_R8_M6_0/A44_CAP_CORE128_M6_R1_0/CAP_BOTTOM_097 GND nfet_03v3 ad=0 pd=0 as=0 ps=0 w=1.56u l=0.28u
X2731 VREFN A44_DCTRL_STRIP_W_R2_0/CTRL_OUT[7] A44_CDAC_CAP_BANK_ASSEMBLY_R8_M6_0/A44_CAP_CORE128_M6_R1_0/CAP_BOTTOM_097 GND nfet_03v3 ad=0 pd=0 as=0 ps=0 w=1.56u l=0.28u
X2732 VREFN A44_DCTRL_STRIP_W_R2_0/CTRL_OUT[7] A44_CDAC_CAP_BANK_ASSEMBLY_R8_M6_0/A44_CAP_CORE128_M6_R1_0/CAP_BOTTOM_097 GND nfet_03v3 ad=0 pd=0 as=0 ps=0 w=1.56u l=0.28u
X2733 VREFN A44_DCTRL_STRIP_W_R2_0/CTRL_OUT[7] A44_CDAC_CAP_BANK_ASSEMBLY_R8_M6_0/A44_CAP_CORE128_M6_R1_0/CAP_BOTTOM_097 GND nfet_03v3 ad=0 pd=0 as=0 ps=0 w=1.56u l=0.28u
X2734 VREFN A44_DCTRL_STRIP_W_R2_0/CTRL_OUT[7] A44_CDAC_CAP_BANK_ASSEMBLY_R8_M6_0/A44_CAP_CORE128_M6_R1_0/CAP_BOTTOM_097 GND nfet_03v3 ad=0 pd=0 as=0 ps=0 w=1.56u l=0.28u
X2735 VREFN A44_DCTRL_STRIP_W_R2_0/CTRL_OUT[7] A44_CDAC_CAP_BANK_ASSEMBLY_R8_M6_0/A44_CAP_CORE128_M6_R1_0/CAP_BOTTOM_097 GND nfet_03v3 ad=0 pd=0 as=0 ps=0 w=1.56u l=0.28u
X2736 VREFN A44_DCTRL_STRIP_W_R2_0/CTRL_OUT[7] A44_CDAC_CAP_BANK_ASSEMBLY_R8_M6_0/A44_CAP_CORE128_M6_R1_0/CAP_BOTTOM_097 GND nfet_03v3 ad=0 pd=0 as=0 ps=0 w=1.56u l=0.28u
X2737 VREFN A44_DCTRL_STRIP_W_R2_0/CTRL_OUT[7] A44_CDAC_CAP_BANK_ASSEMBLY_R8_M6_0/A44_CAP_CORE128_M6_R1_0/CAP_BOTTOM_097 GND nfet_03v3 ad=0 pd=0 as=0 ps=0 w=1.56u l=0.28u
X2738 VREFP A44_DCTRL_STRIP_W_R2_0/CTRL_OUT[5] A44_CDAC_CAP_BANK_ASSEMBLY_R8_M6_0/A44_CAP_CORE128_M6_R1_0/CAP_BOTTOM_094 VDD pfet_03v3 ad=0 pd=0 as=16.6842p ps=77.76u w=1.56u l=0.28u
X2739 VREFP A44_DCTRL_STRIP_W_R2_0/CTRL_OUT[5] A44_CDAC_CAP_BANK_ASSEMBLY_R8_M6_0/A44_CAP_CORE128_M6_R1_0/CAP_BOTTOM_094 VDD pfet_03v3 ad=0 pd=0 as=0 ps=0 w=1.56u l=0.28u
X2740 VREFP A44_DCTRL_STRIP_W_R2_0/CTRL_OUT[5] A44_CDAC_CAP_BANK_ASSEMBLY_R8_M6_0/A44_CAP_CORE128_M6_R1_0/CAP_BOTTOM_094 VDD pfet_03v3 ad=0 pd=0 as=0 ps=0 w=1.56u l=0.28u
X2741 VREFP A44_DCTRL_STRIP_W_R2_0/CTRL_OUT[5] A44_CDAC_CAP_BANK_ASSEMBLY_R8_M6_0/A44_CAP_CORE128_M6_R1_0/CAP_BOTTOM_094 VDD pfet_03v3 ad=0 pd=0 as=0 ps=0 w=1.56u l=0.28u
X2742 VREFP A44_DCTRL_STRIP_W_R2_0/CTRL_OUT[5] A44_CDAC_CAP_BANK_ASSEMBLY_R8_M6_0/A44_CAP_CORE128_M6_R1_0/CAP_BOTTOM_094 VDD pfet_03v3 ad=0 pd=0 as=0 ps=0 w=1.56u l=0.28u
X2743 VREFP A44_DCTRL_STRIP_W_R2_0/CTRL_OUT[5] A44_CDAC_CAP_BANK_ASSEMBLY_R8_M6_0/A44_CAP_CORE128_M6_R1_0/CAP_BOTTOM_094 VDD pfet_03v3 ad=0 pd=0 as=0 ps=0 w=1.56u l=0.28u
X2744 VREFP A44_DCTRL_STRIP_W_R2_0/CTRL_OUT[5] A44_CDAC_CAP_BANK_ASSEMBLY_R8_M6_0/A44_CAP_CORE128_M6_R1_0/CAP_BOTTOM_094 VDD pfet_03v3 ad=0 pd=0 as=0 ps=0 w=1.56u l=0.28u
X2745 VREFP A44_DCTRL_STRIP_W_R2_0/CTRL_OUT[5] A44_CDAC_CAP_BANK_ASSEMBLY_R8_M6_0/A44_CAP_CORE128_M6_R1_0/CAP_BOTTOM_094 VDD pfet_03v3 ad=0 pd=0 as=0 ps=0 w=1.56u l=0.28u
X2746 VREFP A44_DCTRL_STRIP_W_R2_0/CTRL_OUT[5] A44_CDAC_CAP_BANK_ASSEMBLY_R8_M6_0/A44_CAP_CORE128_M6_R1_0/CAP_BOTTOM_094 VDD pfet_03v3 ad=0 pd=0 as=0 ps=0 w=1.56u l=0.28u
X2747 VREFP A44_DCTRL_STRIP_W_R2_0/CTRL_OUT[5] A44_CDAC_CAP_BANK_ASSEMBLY_R8_M6_0/A44_CAP_CORE128_M6_R1_0/CAP_BOTTOM_094 VDD pfet_03v3 ad=0 pd=0 as=0 ps=0 w=1.56u l=0.28u
X2748 VREFP A44_DCTRL_STRIP_W_R2_0/CTRL_OUT[5] A44_CDAC_CAP_BANK_ASSEMBLY_R8_M6_0/A44_CAP_CORE128_M6_R1_0/CAP_BOTTOM_094 VDD pfet_03v3 ad=0 pd=0 as=0 ps=0 w=1.56u l=0.28u
X2749 VREFP A44_DCTRL_STRIP_W_R2_0/CTRL_OUT[5] A44_CDAC_CAP_BANK_ASSEMBLY_R8_M6_0/A44_CAP_CORE128_M6_R1_0/CAP_BOTTOM_094 VDD pfet_03v3 ad=0 pd=0 as=0 ps=0 w=1.56u l=0.28u
X2750 VREFP A44_DCTRL_STRIP_W_R2_0/CTRL_OUT[5] A44_CDAC_CAP_BANK_ASSEMBLY_R8_M6_0/A44_CAP_CORE128_M6_R1_0/CAP_BOTTOM_094 VDD pfet_03v3 ad=0 pd=0 as=0 ps=0 w=1.56u l=0.28u
X2751 VREFP A44_DCTRL_STRIP_W_R2_0/CTRL_OUT[5] A44_CDAC_CAP_BANK_ASSEMBLY_R8_M6_0/A44_CAP_CORE128_M6_R1_0/CAP_BOTTOM_094 VDD pfet_03v3 ad=0 pd=0 as=0 ps=0 w=1.56u l=0.28u
X2752 VREFP A44_DCTRL_STRIP_W_R2_0/CTRL_OUT[5] A44_CDAC_CAP_BANK_ASSEMBLY_R8_M6_0/A44_CAP_CORE128_M6_R1_0/CAP_BOTTOM_094 VDD pfet_03v3 ad=0 pd=0 as=0 ps=0 w=1.56u l=0.28u
X2753 VREFP A44_DCTRL_STRIP_W_R2_0/CTRL_OUT[5] A44_CDAC_CAP_BANK_ASSEMBLY_R8_M6_0/A44_CAP_CORE128_M6_R1_0/CAP_BOTTOM_094 VDD pfet_03v3 ad=0 pd=0 as=0 ps=0 w=1.56u l=0.28u
X2754 VREFP A44_DCTRL_STRIP_W_R2_0/CTRL_OUT[5] A44_CDAC_CAP_BANK_ASSEMBLY_R8_M6_0/A44_CAP_CORE128_M6_R1_0/CAP_BOTTOM_094 VDD pfet_03v3 ad=0 pd=0 as=0 ps=0 w=1.56u l=0.28u
X2755 VREFP A44_DCTRL_STRIP_W_R2_0/CTRL_OUT[5] A44_CDAC_CAP_BANK_ASSEMBLY_R8_M6_0/A44_CAP_CORE128_M6_R1_0/CAP_BOTTOM_094 VDD pfet_03v3 ad=0 pd=0 as=0 ps=0 w=1.56u l=0.28u
X2756 VREFN A44_DCTRL_STRIP_W_R2_0/CTRL_OUT[5] A44_CDAC_CAP_BANK_ASSEMBLY_R8_M6_0/A44_CAP_CORE128_M6_R1_0/CAP_BOTTOM_094 GND nfet_03v3 ad=0 pd=0 as=16.6842p ps=77.76u w=1.56u l=0.28u
X2757 VREFN A44_DCTRL_STRIP_W_R2_0/CTRL_OUT[5] A44_CDAC_CAP_BANK_ASSEMBLY_R8_M6_0/A44_CAP_CORE128_M6_R1_0/CAP_BOTTOM_094 GND nfet_03v3 ad=0 pd=0 as=0 ps=0 w=1.56u l=0.28u
X2758 VREFN A44_DCTRL_STRIP_W_R2_0/CTRL_OUT[5] A44_CDAC_CAP_BANK_ASSEMBLY_R8_M6_0/A44_CAP_CORE128_M6_R1_0/CAP_BOTTOM_094 GND nfet_03v3 ad=0 pd=0 as=0 ps=0 w=1.56u l=0.28u
X2759 VREFN A44_DCTRL_STRIP_W_R2_0/CTRL_OUT[5] A44_CDAC_CAP_BANK_ASSEMBLY_R8_M6_0/A44_CAP_CORE128_M6_R1_0/CAP_BOTTOM_094 GND nfet_03v3 ad=0 pd=0 as=0 ps=0 w=1.56u l=0.28u
X2760 VREFN A44_DCTRL_STRIP_W_R2_0/CTRL_OUT[5] A44_CDAC_CAP_BANK_ASSEMBLY_R8_M6_0/A44_CAP_CORE128_M6_R1_0/CAP_BOTTOM_094 GND nfet_03v3 ad=0 pd=0 as=0 ps=0 w=1.56u l=0.28u
X2761 VREFN A44_DCTRL_STRIP_W_R2_0/CTRL_OUT[5] A44_CDAC_CAP_BANK_ASSEMBLY_R8_M6_0/A44_CAP_CORE128_M6_R1_0/CAP_BOTTOM_094 GND nfet_03v3 ad=0 pd=0 as=0 ps=0 w=1.56u l=0.28u
X2762 VREFN A44_DCTRL_STRIP_W_R2_0/CTRL_OUT[5] A44_CDAC_CAP_BANK_ASSEMBLY_R8_M6_0/A44_CAP_CORE128_M6_R1_0/CAP_BOTTOM_094 GND nfet_03v3 ad=0 pd=0 as=0 ps=0 w=1.56u l=0.28u
X2763 VREFN A44_DCTRL_STRIP_W_R2_0/CTRL_OUT[5] A44_CDAC_CAP_BANK_ASSEMBLY_R8_M6_0/A44_CAP_CORE128_M6_R1_0/CAP_BOTTOM_094 GND nfet_03v3 ad=0 pd=0 as=0 ps=0 w=1.56u l=0.28u
X2764 VREFN A44_DCTRL_STRIP_W_R2_0/CTRL_OUT[5] A44_CDAC_CAP_BANK_ASSEMBLY_R8_M6_0/A44_CAP_CORE128_M6_R1_0/CAP_BOTTOM_094 GND nfet_03v3 ad=0 pd=0 as=0 ps=0 w=1.56u l=0.28u
X2765 VREFN A44_DCTRL_STRIP_W_R2_0/CTRL_OUT[5] A44_CDAC_CAP_BANK_ASSEMBLY_R8_M6_0/A44_CAP_CORE128_M6_R1_0/CAP_BOTTOM_094 GND nfet_03v3 ad=0 pd=0 as=0 ps=0 w=1.56u l=0.28u
X2766 VREFN A44_DCTRL_STRIP_W_R2_0/CTRL_OUT[5] A44_CDAC_CAP_BANK_ASSEMBLY_R8_M6_0/A44_CAP_CORE128_M6_R1_0/CAP_BOTTOM_094 GND nfet_03v3 ad=0 pd=0 as=0 ps=0 w=1.56u l=0.28u
X2767 VREFN A44_DCTRL_STRIP_W_R2_0/CTRL_OUT[5] A44_CDAC_CAP_BANK_ASSEMBLY_R8_M6_0/A44_CAP_CORE128_M6_R1_0/CAP_BOTTOM_094 GND nfet_03v3 ad=0 pd=0 as=0 ps=0 w=1.56u l=0.28u
X2768 VREFN A44_DCTRL_STRIP_W_R2_0/CTRL_OUT[5] A44_CDAC_CAP_BANK_ASSEMBLY_R8_M6_0/A44_CAP_CORE128_M6_R1_0/CAP_BOTTOM_094 GND nfet_03v3 ad=0 pd=0 as=0 ps=0 w=1.56u l=0.28u
X2769 VREFN A44_DCTRL_STRIP_W_R2_0/CTRL_OUT[5] A44_CDAC_CAP_BANK_ASSEMBLY_R8_M6_0/A44_CAP_CORE128_M6_R1_0/CAP_BOTTOM_094 GND nfet_03v3 ad=0 pd=0 as=0 ps=0 w=1.56u l=0.28u
X2770 VREFN A44_DCTRL_STRIP_W_R2_0/CTRL_OUT[5] A44_CDAC_CAP_BANK_ASSEMBLY_R8_M6_0/A44_CAP_CORE128_M6_R1_0/CAP_BOTTOM_094 GND nfet_03v3 ad=0 pd=0 as=0 ps=0 w=1.56u l=0.28u
X2771 VREFN A44_DCTRL_STRIP_W_R2_0/CTRL_OUT[5] A44_CDAC_CAP_BANK_ASSEMBLY_R8_M6_0/A44_CAP_CORE128_M6_R1_0/CAP_BOTTOM_094 GND nfet_03v3 ad=0 pd=0 as=0 ps=0 w=1.56u l=0.28u
X2772 VREFN A44_DCTRL_STRIP_W_R2_0/CTRL_OUT[5] A44_CDAC_CAP_BANK_ASSEMBLY_R8_M6_0/A44_CAP_CORE128_M6_R1_0/CAP_BOTTOM_094 GND nfet_03v3 ad=0 pd=0 as=0 ps=0 w=1.56u l=0.28u
X2773 VREFN A44_DCTRL_STRIP_W_R2_0/CTRL_OUT[5] A44_CDAC_CAP_BANK_ASSEMBLY_R8_M6_0/A44_CAP_CORE128_M6_R1_0/CAP_BOTTOM_094 GND nfet_03v3 ad=0 pd=0 as=0 ps=0 w=1.56u l=0.28u
X2774 VREFP A44_DCTRL_STRIP_W_R2_0/CTRL_OUT[4] A44_CDAC_CAP_BANK_ASSEMBLY_R8_M6_0/A44_CAP_CORE128_M6_R1_0/CAP_BOTTOM_121 VDD pfet_03v3 ad=0 pd=0 as=16.6842p ps=77.76u w=1.56u l=0.28u
X2775 VREFP A44_DCTRL_STRIP_W_R2_0/CTRL_OUT[4] A44_CDAC_CAP_BANK_ASSEMBLY_R8_M6_0/A44_CAP_CORE128_M6_R1_0/CAP_BOTTOM_121 VDD pfet_03v3 ad=0 pd=0 as=0 ps=0 w=1.56u l=0.28u
X2776 VREFP A44_DCTRL_STRIP_W_R2_0/CTRL_OUT[4] A44_CDAC_CAP_BANK_ASSEMBLY_R8_M6_0/A44_CAP_CORE128_M6_R1_0/CAP_BOTTOM_121 VDD pfet_03v3 ad=0 pd=0 as=0 ps=0 w=1.56u l=0.28u
X2777 VREFP A44_DCTRL_STRIP_W_R2_0/CTRL_OUT[4] A44_CDAC_CAP_BANK_ASSEMBLY_R8_M6_0/A44_CAP_CORE128_M6_R1_0/CAP_BOTTOM_121 VDD pfet_03v3 ad=0 pd=0 as=0 ps=0 w=1.56u l=0.28u
X2778 VREFP A44_DCTRL_STRIP_W_R2_0/CTRL_OUT[4] A44_CDAC_CAP_BANK_ASSEMBLY_R8_M6_0/A44_CAP_CORE128_M6_R1_0/CAP_BOTTOM_121 VDD pfet_03v3 ad=0 pd=0 as=0 ps=0 w=1.56u l=0.28u
X2779 VREFP A44_DCTRL_STRIP_W_R2_0/CTRL_OUT[4] A44_CDAC_CAP_BANK_ASSEMBLY_R8_M6_0/A44_CAP_CORE128_M6_R1_0/CAP_BOTTOM_121 VDD pfet_03v3 ad=0 pd=0 as=0 ps=0 w=1.56u l=0.28u
X2780 VREFP A44_DCTRL_STRIP_W_R2_0/CTRL_OUT[4] A44_CDAC_CAP_BANK_ASSEMBLY_R8_M6_0/A44_CAP_CORE128_M6_R1_0/CAP_BOTTOM_121 VDD pfet_03v3 ad=0 pd=0 as=0 ps=0 w=1.56u l=0.28u
X2781 VREFP A44_DCTRL_STRIP_W_R2_0/CTRL_OUT[4] A44_CDAC_CAP_BANK_ASSEMBLY_R8_M6_0/A44_CAP_CORE128_M6_R1_0/CAP_BOTTOM_121 VDD pfet_03v3 ad=0 pd=0 as=0 ps=0 w=1.56u l=0.28u
X2782 VREFP A44_DCTRL_STRIP_W_R2_0/CTRL_OUT[4] A44_CDAC_CAP_BANK_ASSEMBLY_R8_M6_0/A44_CAP_CORE128_M6_R1_0/CAP_BOTTOM_121 VDD pfet_03v3 ad=0 pd=0 as=0 ps=0 w=1.56u l=0.28u
X2783 VREFP A44_DCTRL_STRIP_W_R2_0/CTRL_OUT[4] A44_CDAC_CAP_BANK_ASSEMBLY_R8_M6_0/A44_CAP_CORE128_M6_R1_0/CAP_BOTTOM_121 VDD pfet_03v3 ad=0 pd=0 as=0 ps=0 w=1.56u l=0.28u
X2784 VREFP A44_DCTRL_STRIP_W_R2_0/CTRL_OUT[4] A44_CDAC_CAP_BANK_ASSEMBLY_R8_M6_0/A44_CAP_CORE128_M6_R1_0/CAP_BOTTOM_121 VDD pfet_03v3 ad=0 pd=0 as=0 ps=0 w=1.56u l=0.28u
X2785 VREFP A44_DCTRL_STRIP_W_R2_0/CTRL_OUT[4] A44_CDAC_CAP_BANK_ASSEMBLY_R8_M6_0/A44_CAP_CORE128_M6_R1_0/CAP_BOTTOM_121 VDD pfet_03v3 ad=0 pd=0 as=0 ps=0 w=1.56u l=0.28u
X2786 VREFP A44_DCTRL_STRIP_W_R2_0/CTRL_OUT[4] A44_CDAC_CAP_BANK_ASSEMBLY_R8_M6_0/A44_CAP_CORE128_M6_R1_0/CAP_BOTTOM_121 VDD pfet_03v3 ad=0 pd=0 as=0 ps=0 w=1.56u l=0.28u
X2787 VREFP A44_DCTRL_STRIP_W_R2_0/CTRL_OUT[4] A44_CDAC_CAP_BANK_ASSEMBLY_R8_M6_0/A44_CAP_CORE128_M6_R1_0/CAP_BOTTOM_121 VDD pfet_03v3 ad=0 pd=0 as=0 ps=0 w=1.56u l=0.28u
X2788 VREFP A44_DCTRL_STRIP_W_R2_0/CTRL_OUT[4] A44_CDAC_CAP_BANK_ASSEMBLY_R8_M6_0/A44_CAP_CORE128_M6_R1_0/CAP_BOTTOM_121 VDD pfet_03v3 ad=0 pd=0 as=0 ps=0 w=1.56u l=0.28u
X2789 VREFP A44_DCTRL_STRIP_W_R2_0/CTRL_OUT[4] A44_CDAC_CAP_BANK_ASSEMBLY_R8_M6_0/A44_CAP_CORE128_M6_R1_0/CAP_BOTTOM_121 VDD pfet_03v3 ad=0 pd=0 as=0 ps=0 w=1.56u l=0.28u
X2790 VREFP A44_DCTRL_STRIP_W_R2_0/CTRL_OUT[4] A44_CDAC_CAP_BANK_ASSEMBLY_R8_M6_0/A44_CAP_CORE128_M6_R1_0/CAP_BOTTOM_121 VDD pfet_03v3 ad=0 pd=0 as=0 ps=0 w=1.56u l=0.28u
X2791 VREFP A44_DCTRL_STRIP_W_R2_0/CTRL_OUT[4] A44_CDAC_CAP_BANK_ASSEMBLY_R8_M6_0/A44_CAP_CORE128_M6_R1_0/CAP_BOTTOM_121 VDD pfet_03v3 ad=0 pd=0 as=0 ps=0 w=1.56u l=0.28u
X2792 VREFN A44_DCTRL_STRIP_W_R2_0/CTRL_OUT[4] A44_CDAC_CAP_BANK_ASSEMBLY_R8_M6_0/A44_CAP_CORE128_M6_R1_0/CAP_BOTTOM_121 GND nfet_03v3 ad=0 pd=0 as=16.6842p ps=77.76u w=1.56u l=0.28u
X2793 VREFN A44_DCTRL_STRIP_W_R2_0/CTRL_OUT[4] A44_CDAC_CAP_BANK_ASSEMBLY_R8_M6_0/A44_CAP_CORE128_M6_R1_0/CAP_BOTTOM_121 GND nfet_03v3 ad=0 pd=0 as=0 ps=0 w=1.56u l=0.28u
X2794 VREFN A44_DCTRL_STRIP_W_R2_0/CTRL_OUT[4] A44_CDAC_CAP_BANK_ASSEMBLY_R8_M6_0/A44_CAP_CORE128_M6_R1_0/CAP_BOTTOM_121 GND nfet_03v3 ad=0 pd=0 as=0 ps=0 w=1.56u l=0.28u
X2795 VREFN A44_DCTRL_STRIP_W_R2_0/CTRL_OUT[4] A44_CDAC_CAP_BANK_ASSEMBLY_R8_M6_0/A44_CAP_CORE128_M6_R1_0/CAP_BOTTOM_121 GND nfet_03v3 ad=0 pd=0 as=0 ps=0 w=1.56u l=0.28u
X2796 VREFN A44_DCTRL_STRIP_W_R2_0/CTRL_OUT[4] A44_CDAC_CAP_BANK_ASSEMBLY_R8_M6_0/A44_CAP_CORE128_M6_R1_0/CAP_BOTTOM_121 GND nfet_03v3 ad=0 pd=0 as=0 ps=0 w=1.56u l=0.28u
X2797 VREFN A44_DCTRL_STRIP_W_R2_0/CTRL_OUT[4] A44_CDAC_CAP_BANK_ASSEMBLY_R8_M6_0/A44_CAP_CORE128_M6_R1_0/CAP_BOTTOM_121 GND nfet_03v3 ad=0 pd=0 as=0 ps=0 w=1.56u l=0.28u
X2798 VREFN A44_DCTRL_STRIP_W_R2_0/CTRL_OUT[4] A44_CDAC_CAP_BANK_ASSEMBLY_R8_M6_0/A44_CAP_CORE128_M6_R1_0/CAP_BOTTOM_121 GND nfet_03v3 ad=0 pd=0 as=0 ps=0 w=1.56u l=0.28u
X2799 VREFN A44_DCTRL_STRIP_W_R2_0/CTRL_OUT[4] A44_CDAC_CAP_BANK_ASSEMBLY_R8_M6_0/A44_CAP_CORE128_M6_R1_0/CAP_BOTTOM_121 GND nfet_03v3 ad=0 pd=0 as=0 ps=0 w=1.56u l=0.28u
X2800 VREFN A44_DCTRL_STRIP_W_R2_0/CTRL_OUT[4] A44_CDAC_CAP_BANK_ASSEMBLY_R8_M6_0/A44_CAP_CORE128_M6_R1_0/CAP_BOTTOM_121 GND nfet_03v3 ad=0 pd=0 as=0 ps=0 w=1.56u l=0.28u
X2801 VREFN A44_DCTRL_STRIP_W_R2_0/CTRL_OUT[4] A44_CDAC_CAP_BANK_ASSEMBLY_R8_M6_0/A44_CAP_CORE128_M6_R1_0/CAP_BOTTOM_121 GND nfet_03v3 ad=0 pd=0 as=0 ps=0 w=1.56u l=0.28u
X2802 VREFN A44_DCTRL_STRIP_W_R2_0/CTRL_OUT[4] A44_CDAC_CAP_BANK_ASSEMBLY_R8_M6_0/A44_CAP_CORE128_M6_R1_0/CAP_BOTTOM_121 GND nfet_03v3 ad=0 pd=0 as=0 ps=0 w=1.56u l=0.28u
X2803 VREFN A44_DCTRL_STRIP_W_R2_0/CTRL_OUT[4] A44_CDAC_CAP_BANK_ASSEMBLY_R8_M6_0/A44_CAP_CORE128_M6_R1_0/CAP_BOTTOM_121 GND nfet_03v3 ad=0 pd=0 as=0 ps=0 w=1.56u l=0.28u
X2804 VREFN A44_DCTRL_STRIP_W_R2_0/CTRL_OUT[4] A44_CDAC_CAP_BANK_ASSEMBLY_R8_M6_0/A44_CAP_CORE128_M6_R1_0/CAP_BOTTOM_121 GND nfet_03v3 ad=0 pd=0 as=0 ps=0 w=1.56u l=0.28u
X2805 VREFN A44_DCTRL_STRIP_W_R2_0/CTRL_OUT[4] A44_CDAC_CAP_BANK_ASSEMBLY_R8_M6_0/A44_CAP_CORE128_M6_R1_0/CAP_BOTTOM_121 GND nfet_03v3 ad=0 pd=0 as=0 ps=0 w=1.56u l=0.28u
X2806 VREFN A44_DCTRL_STRIP_W_R2_0/CTRL_OUT[4] A44_CDAC_CAP_BANK_ASSEMBLY_R8_M6_0/A44_CAP_CORE128_M6_R1_0/CAP_BOTTOM_121 GND nfet_03v3 ad=0 pd=0 as=0 ps=0 w=1.56u l=0.28u
X2807 VREFN A44_DCTRL_STRIP_W_R2_0/CTRL_OUT[4] A44_CDAC_CAP_BANK_ASSEMBLY_R8_M6_0/A44_CAP_CORE128_M6_R1_0/CAP_BOTTOM_121 GND nfet_03v3 ad=0 pd=0 as=0 ps=0 w=1.56u l=0.28u
X2808 VREFN A44_DCTRL_STRIP_W_R2_0/CTRL_OUT[4] A44_CDAC_CAP_BANK_ASSEMBLY_R8_M6_0/A44_CAP_CORE128_M6_R1_0/CAP_BOTTOM_121 GND nfet_03v3 ad=0 pd=0 as=0 ps=0 w=1.56u l=0.28u
X2809 VREFN A44_DCTRL_STRIP_W_R2_0/CTRL_OUT[4] A44_CDAC_CAP_BANK_ASSEMBLY_R8_M6_0/A44_CAP_CORE128_M6_R1_0/CAP_BOTTOM_121 GND nfet_03v3 ad=0 pd=0 as=0 ps=0 w=1.56u l=0.28u
X2810 VREFP A44_DCTRL_STRIP_W_R2_0/CTRL_OUT[7] A44_CDAC_CAP_BANK_ASSEMBLY_R8_M6_0/A44_CAP_CORE128_M6_R1_0/CAP_BOTTOM_118 VDD pfet_03v3 ad=0 pd=0 as=16.6842p ps=77.76u w=1.56u l=0.28u
X2811 VREFP A44_DCTRL_STRIP_W_R2_0/CTRL_OUT[7] A44_CDAC_CAP_BANK_ASSEMBLY_R8_M6_0/A44_CAP_CORE128_M6_R1_0/CAP_BOTTOM_118 VDD pfet_03v3 ad=0 pd=0 as=0 ps=0 w=1.56u l=0.28u
X2812 VREFP A44_DCTRL_STRIP_W_R2_0/CTRL_OUT[7] A44_CDAC_CAP_BANK_ASSEMBLY_R8_M6_0/A44_CAP_CORE128_M6_R1_0/CAP_BOTTOM_118 VDD pfet_03v3 ad=0 pd=0 as=0 ps=0 w=1.56u l=0.28u
X2813 VREFP A44_DCTRL_STRIP_W_R2_0/CTRL_OUT[7] A44_CDAC_CAP_BANK_ASSEMBLY_R8_M6_0/A44_CAP_CORE128_M6_R1_0/CAP_BOTTOM_118 VDD pfet_03v3 ad=0 pd=0 as=0 ps=0 w=1.56u l=0.28u
X2814 VREFP A44_DCTRL_STRIP_W_R2_0/CTRL_OUT[7] A44_CDAC_CAP_BANK_ASSEMBLY_R8_M6_0/A44_CAP_CORE128_M6_R1_0/CAP_BOTTOM_118 VDD pfet_03v3 ad=0 pd=0 as=0 ps=0 w=1.56u l=0.28u
X2815 VREFP A44_DCTRL_STRIP_W_R2_0/CTRL_OUT[7] A44_CDAC_CAP_BANK_ASSEMBLY_R8_M6_0/A44_CAP_CORE128_M6_R1_0/CAP_BOTTOM_118 VDD pfet_03v3 ad=0 pd=0 as=0 ps=0 w=1.56u l=0.28u
X2816 VREFP A44_DCTRL_STRIP_W_R2_0/CTRL_OUT[7] A44_CDAC_CAP_BANK_ASSEMBLY_R8_M6_0/A44_CAP_CORE128_M6_R1_0/CAP_BOTTOM_118 VDD pfet_03v3 ad=0 pd=0 as=0 ps=0 w=1.56u l=0.28u
X2817 VREFP A44_DCTRL_STRIP_W_R2_0/CTRL_OUT[7] A44_CDAC_CAP_BANK_ASSEMBLY_R8_M6_0/A44_CAP_CORE128_M6_R1_0/CAP_BOTTOM_118 VDD pfet_03v3 ad=0 pd=0 as=0 ps=0 w=1.56u l=0.28u
X2818 VREFP A44_DCTRL_STRIP_W_R2_0/CTRL_OUT[7] A44_CDAC_CAP_BANK_ASSEMBLY_R8_M6_0/A44_CAP_CORE128_M6_R1_0/CAP_BOTTOM_118 VDD pfet_03v3 ad=0 pd=0 as=0 ps=0 w=1.56u l=0.28u
X2819 VREFP A44_DCTRL_STRIP_W_R2_0/CTRL_OUT[7] A44_CDAC_CAP_BANK_ASSEMBLY_R8_M6_0/A44_CAP_CORE128_M6_R1_0/CAP_BOTTOM_118 VDD pfet_03v3 ad=0 pd=0 as=0 ps=0 w=1.56u l=0.28u
X2820 VREFP A44_DCTRL_STRIP_W_R2_0/CTRL_OUT[7] A44_CDAC_CAP_BANK_ASSEMBLY_R8_M6_0/A44_CAP_CORE128_M6_R1_0/CAP_BOTTOM_118 VDD pfet_03v3 ad=0 pd=0 as=0 ps=0 w=1.56u l=0.28u
X2821 VREFP A44_DCTRL_STRIP_W_R2_0/CTRL_OUT[7] A44_CDAC_CAP_BANK_ASSEMBLY_R8_M6_0/A44_CAP_CORE128_M6_R1_0/CAP_BOTTOM_118 VDD pfet_03v3 ad=0 pd=0 as=0 ps=0 w=1.56u l=0.28u
X2822 VREFP A44_DCTRL_STRIP_W_R2_0/CTRL_OUT[7] A44_CDAC_CAP_BANK_ASSEMBLY_R8_M6_0/A44_CAP_CORE128_M6_R1_0/CAP_BOTTOM_118 VDD pfet_03v3 ad=0 pd=0 as=0 ps=0 w=1.56u l=0.28u
X2823 VREFP A44_DCTRL_STRIP_W_R2_0/CTRL_OUT[7] A44_CDAC_CAP_BANK_ASSEMBLY_R8_M6_0/A44_CAP_CORE128_M6_R1_0/CAP_BOTTOM_118 VDD pfet_03v3 ad=0 pd=0 as=0 ps=0 w=1.56u l=0.28u
X2824 VREFP A44_DCTRL_STRIP_W_R2_0/CTRL_OUT[7] A44_CDAC_CAP_BANK_ASSEMBLY_R8_M6_0/A44_CAP_CORE128_M6_R1_0/CAP_BOTTOM_118 VDD pfet_03v3 ad=0 pd=0 as=0 ps=0 w=1.56u l=0.28u
X2825 VREFP A44_DCTRL_STRIP_W_R2_0/CTRL_OUT[7] A44_CDAC_CAP_BANK_ASSEMBLY_R8_M6_0/A44_CAP_CORE128_M6_R1_0/CAP_BOTTOM_118 VDD pfet_03v3 ad=0 pd=0 as=0 ps=0 w=1.56u l=0.28u
X2826 VREFP A44_DCTRL_STRIP_W_R2_0/CTRL_OUT[7] A44_CDAC_CAP_BANK_ASSEMBLY_R8_M6_0/A44_CAP_CORE128_M6_R1_0/CAP_BOTTOM_118 VDD pfet_03v3 ad=0 pd=0 as=0 ps=0 w=1.56u l=0.28u
X2827 VREFP A44_DCTRL_STRIP_W_R2_0/CTRL_OUT[7] A44_CDAC_CAP_BANK_ASSEMBLY_R8_M6_0/A44_CAP_CORE128_M6_R1_0/CAP_BOTTOM_118 VDD pfet_03v3 ad=0 pd=0 as=0 ps=0 w=1.56u l=0.28u
X2828 VREFN A44_DCTRL_STRIP_W_R2_0/CTRL_OUT[7] A44_CDAC_CAP_BANK_ASSEMBLY_R8_M6_0/A44_CAP_CORE128_M6_R1_0/CAP_BOTTOM_118 GND nfet_03v3 ad=0 pd=0 as=16.6842p ps=77.76u w=1.56u l=0.28u
X2829 VREFN A44_DCTRL_STRIP_W_R2_0/CTRL_OUT[7] A44_CDAC_CAP_BANK_ASSEMBLY_R8_M6_0/A44_CAP_CORE128_M6_R1_0/CAP_BOTTOM_118 GND nfet_03v3 ad=0 pd=0 as=0 ps=0 w=1.56u l=0.28u
X2830 VREFN A44_DCTRL_STRIP_W_R2_0/CTRL_OUT[7] A44_CDAC_CAP_BANK_ASSEMBLY_R8_M6_0/A44_CAP_CORE128_M6_R1_0/CAP_BOTTOM_118 GND nfet_03v3 ad=0 pd=0 as=0 ps=0 w=1.56u l=0.28u
X2831 VREFN A44_DCTRL_STRIP_W_R2_0/CTRL_OUT[7] A44_CDAC_CAP_BANK_ASSEMBLY_R8_M6_0/A44_CAP_CORE128_M6_R1_0/CAP_BOTTOM_118 GND nfet_03v3 ad=0 pd=0 as=0 ps=0 w=1.56u l=0.28u
X2832 VREFN A44_DCTRL_STRIP_W_R2_0/CTRL_OUT[7] A44_CDAC_CAP_BANK_ASSEMBLY_R8_M6_0/A44_CAP_CORE128_M6_R1_0/CAP_BOTTOM_118 GND nfet_03v3 ad=0 pd=0 as=0 ps=0 w=1.56u l=0.28u
X2833 VREFN A44_DCTRL_STRIP_W_R2_0/CTRL_OUT[7] A44_CDAC_CAP_BANK_ASSEMBLY_R8_M6_0/A44_CAP_CORE128_M6_R1_0/CAP_BOTTOM_118 GND nfet_03v3 ad=0 pd=0 as=0 ps=0 w=1.56u l=0.28u
X2834 VREFN A44_DCTRL_STRIP_W_R2_0/CTRL_OUT[7] A44_CDAC_CAP_BANK_ASSEMBLY_R8_M6_0/A44_CAP_CORE128_M6_R1_0/CAP_BOTTOM_118 GND nfet_03v3 ad=0 pd=0 as=0 ps=0 w=1.56u l=0.28u
X2835 VREFN A44_DCTRL_STRIP_W_R2_0/CTRL_OUT[7] A44_CDAC_CAP_BANK_ASSEMBLY_R8_M6_0/A44_CAP_CORE128_M6_R1_0/CAP_BOTTOM_118 GND nfet_03v3 ad=0 pd=0 as=0 ps=0 w=1.56u l=0.28u
X2836 VREFN A44_DCTRL_STRIP_W_R2_0/CTRL_OUT[7] A44_CDAC_CAP_BANK_ASSEMBLY_R8_M6_0/A44_CAP_CORE128_M6_R1_0/CAP_BOTTOM_118 GND nfet_03v3 ad=0 pd=0 as=0 ps=0 w=1.56u l=0.28u
X2837 VREFN A44_DCTRL_STRIP_W_R2_0/CTRL_OUT[7] A44_CDAC_CAP_BANK_ASSEMBLY_R8_M6_0/A44_CAP_CORE128_M6_R1_0/CAP_BOTTOM_118 GND nfet_03v3 ad=0 pd=0 as=0 ps=0 w=1.56u l=0.28u
X2838 VREFN A44_DCTRL_STRIP_W_R2_0/CTRL_OUT[7] A44_CDAC_CAP_BANK_ASSEMBLY_R8_M6_0/A44_CAP_CORE128_M6_R1_0/CAP_BOTTOM_118 GND nfet_03v3 ad=0 pd=0 as=0 ps=0 w=1.56u l=0.28u
X2839 VREFN A44_DCTRL_STRIP_W_R2_0/CTRL_OUT[7] A44_CDAC_CAP_BANK_ASSEMBLY_R8_M6_0/A44_CAP_CORE128_M6_R1_0/CAP_BOTTOM_118 GND nfet_03v3 ad=0 pd=0 as=0 ps=0 w=1.56u l=0.28u
X2840 VREFN A44_DCTRL_STRIP_W_R2_0/CTRL_OUT[7] A44_CDAC_CAP_BANK_ASSEMBLY_R8_M6_0/A44_CAP_CORE128_M6_R1_0/CAP_BOTTOM_118 GND nfet_03v3 ad=0 pd=0 as=0 ps=0 w=1.56u l=0.28u
X2841 VREFN A44_DCTRL_STRIP_W_R2_0/CTRL_OUT[7] A44_CDAC_CAP_BANK_ASSEMBLY_R8_M6_0/A44_CAP_CORE128_M6_R1_0/CAP_BOTTOM_118 GND nfet_03v3 ad=0 pd=0 as=0 ps=0 w=1.56u l=0.28u
X2842 VREFN A44_DCTRL_STRIP_W_R2_0/CTRL_OUT[7] A44_CDAC_CAP_BANK_ASSEMBLY_R8_M6_0/A44_CAP_CORE128_M6_R1_0/CAP_BOTTOM_118 GND nfet_03v3 ad=0 pd=0 as=0 ps=0 w=1.56u l=0.28u
X2843 VREFN A44_DCTRL_STRIP_W_R2_0/CTRL_OUT[7] A44_CDAC_CAP_BANK_ASSEMBLY_R8_M6_0/A44_CAP_CORE128_M6_R1_0/CAP_BOTTOM_118 GND nfet_03v3 ad=0 pd=0 as=0 ps=0 w=1.56u l=0.28u
X2844 VREFN A44_DCTRL_STRIP_W_R2_0/CTRL_OUT[7] A44_CDAC_CAP_BANK_ASSEMBLY_R8_M6_0/A44_CAP_CORE128_M6_R1_0/CAP_BOTTOM_118 GND nfet_03v3 ad=0 pd=0 as=0 ps=0 w=1.56u l=0.28u
X2845 VREFN A44_DCTRL_STRIP_W_R2_0/CTRL_OUT[7] A44_CDAC_CAP_BANK_ASSEMBLY_R8_M6_0/A44_CAP_CORE128_M6_R1_0/CAP_BOTTOM_118 GND nfet_03v3 ad=0 pd=0 as=0 ps=0 w=1.56u l=0.28u
X2846 VREFP A44_DCTRL_STRIP_W_R2_0/CTRL_OUT[7] A44_CDAC_CAP_BANK_ASSEMBLY_R8_M6_0/A44_CAP_CORE128_M6_R1_0/CAP_BOTTOM_081 VDD pfet_03v3 ad=0 pd=0 as=16.6842p ps=77.76u w=1.56u l=0.28u
X2847 VREFP A44_DCTRL_STRIP_W_R2_0/CTRL_OUT[7] A44_CDAC_CAP_BANK_ASSEMBLY_R8_M6_0/A44_CAP_CORE128_M6_R1_0/CAP_BOTTOM_081 VDD pfet_03v3 ad=0 pd=0 as=0 ps=0 w=1.56u l=0.28u
X2848 VREFP A44_DCTRL_STRIP_W_R2_0/CTRL_OUT[7] A44_CDAC_CAP_BANK_ASSEMBLY_R8_M6_0/A44_CAP_CORE128_M6_R1_0/CAP_BOTTOM_081 VDD pfet_03v3 ad=0 pd=0 as=0 ps=0 w=1.56u l=0.28u
X2849 VREFP A44_DCTRL_STRIP_W_R2_0/CTRL_OUT[7] A44_CDAC_CAP_BANK_ASSEMBLY_R8_M6_0/A44_CAP_CORE128_M6_R1_0/CAP_BOTTOM_081 VDD pfet_03v3 ad=0 pd=0 as=0 ps=0 w=1.56u l=0.28u
X2850 VREFP A44_DCTRL_STRIP_W_R2_0/CTRL_OUT[7] A44_CDAC_CAP_BANK_ASSEMBLY_R8_M6_0/A44_CAP_CORE128_M6_R1_0/CAP_BOTTOM_081 VDD pfet_03v3 ad=0 pd=0 as=0 ps=0 w=1.56u l=0.28u
X2851 VREFP A44_DCTRL_STRIP_W_R2_0/CTRL_OUT[7] A44_CDAC_CAP_BANK_ASSEMBLY_R8_M6_0/A44_CAP_CORE128_M6_R1_0/CAP_BOTTOM_081 VDD pfet_03v3 ad=0 pd=0 as=0 ps=0 w=1.56u l=0.28u
X2852 VREFP A44_DCTRL_STRIP_W_R2_0/CTRL_OUT[7] A44_CDAC_CAP_BANK_ASSEMBLY_R8_M6_0/A44_CAP_CORE128_M6_R1_0/CAP_BOTTOM_081 VDD pfet_03v3 ad=0 pd=0 as=0 ps=0 w=1.56u l=0.28u
X2853 VREFP A44_DCTRL_STRIP_W_R2_0/CTRL_OUT[7] A44_CDAC_CAP_BANK_ASSEMBLY_R8_M6_0/A44_CAP_CORE128_M6_R1_0/CAP_BOTTOM_081 VDD pfet_03v3 ad=0 pd=0 as=0 ps=0 w=1.56u l=0.28u
X2854 VREFP A44_DCTRL_STRIP_W_R2_0/CTRL_OUT[7] A44_CDAC_CAP_BANK_ASSEMBLY_R8_M6_0/A44_CAP_CORE128_M6_R1_0/CAP_BOTTOM_081 VDD pfet_03v3 ad=0 pd=0 as=0 ps=0 w=1.56u l=0.28u
X2855 VREFP A44_DCTRL_STRIP_W_R2_0/CTRL_OUT[7] A44_CDAC_CAP_BANK_ASSEMBLY_R8_M6_0/A44_CAP_CORE128_M6_R1_0/CAP_BOTTOM_081 VDD pfet_03v3 ad=0 pd=0 as=0 ps=0 w=1.56u l=0.28u
X2856 VREFP A44_DCTRL_STRIP_W_R2_0/CTRL_OUT[7] A44_CDAC_CAP_BANK_ASSEMBLY_R8_M6_0/A44_CAP_CORE128_M6_R1_0/CAP_BOTTOM_081 VDD pfet_03v3 ad=0 pd=0 as=0 ps=0 w=1.56u l=0.28u
X2857 VREFP A44_DCTRL_STRIP_W_R2_0/CTRL_OUT[7] A44_CDAC_CAP_BANK_ASSEMBLY_R8_M6_0/A44_CAP_CORE128_M6_R1_0/CAP_BOTTOM_081 VDD pfet_03v3 ad=0 pd=0 as=0 ps=0 w=1.56u l=0.28u
X2858 VREFP A44_DCTRL_STRIP_W_R2_0/CTRL_OUT[7] A44_CDAC_CAP_BANK_ASSEMBLY_R8_M6_0/A44_CAP_CORE128_M6_R1_0/CAP_BOTTOM_081 VDD pfet_03v3 ad=0 pd=0 as=0 ps=0 w=1.56u l=0.28u
X2859 VREFP A44_DCTRL_STRIP_W_R2_0/CTRL_OUT[7] A44_CDAC_CAP_BANK_ASSEMBLY_R8_M6_0/A44_CAP_CORE128_M6_R1_0/CAP_BOTTOM_081 VDD pfet_03v3 ad=0 pd=0 as=0 ps=0 w=1.56u l=0.28u
X2860 VREFP A44_DCTRL_STRIP_W_R2_0/CTRL_OUT[7] A44_CDAC_CAP_BANK_ASSEMBLY_R8_M6_0/A44_CAP_CORE128_M6_R1_0/CAP_BOTTOM_081 VDD pfet_03v3 ad=0 pd=0 as=0 ps=0 w=1.56u l=0.28u
X2861 VREFP A44_DCTRL_STRIP_W_R2_0/CTRL_OUT[7] A44_CDAC_CAP_BANK_ASSEMBLY_R8_M6_0/A44_CAP_CORE128_M6_R1_0/CAP_BOTTOM_081 VDD pfet_03v3 ad=0 pd=0 as=0 ps=0 w=1.56u l=0.28u
X2862 VREFP A44_DCTRL_STRIP_W_R2_0/CTRL_OUT[7] A44_CDAC_CAP_BANK_ASSEMBLY_R8_M6_0/A44_CAP_CORE128_M6_R1_0/CAP_BOTTOM_081 VDD pfet_03v3 ad=0 pd=0 as=0 ps=0 w=1.56u l=0.28u
X2863 VREFP A44_DCTRL_STRIP_W_R2_0/CTRL_OUT[7] A44_CDAC_CAP_BANK_ASSEMBLY_R8_M6_0/A44_CAP_CORE128_M6_R1_0/CAP_BOTTOM_081 VDD pfet_03v3 ad=0 pd=0 as=0 ps=0 w=1.56u l=0.28u
X2864 VREFN A44_DCTRL_STRIP_W_R2_0/CTRL_OUT[7] A44_CDAC_CAP_BANK_ASSEMBLY_R8_M6_0/A44_CAP_CORE128_M6_R1_0/CAP_BOTTOM_081 GND nfet_03v3 ad=0 pd=0 as=16.6842p ps=77.76u w=1.56u l=0.28u
X2865 VREFN A44_DCTRL_STRIP_W_R2_0/CTRL_OUT[7] A44_CDAC_CAP_BANK_ASSEMBLY_R8_M6_0/A44_CAP_CORE128_M6_R1_0/CAP_BOTTOM_081 GND nfet_03v3 ad=0 pd=0 as=0 ps=0 w=1.56u l=0.28u
X2866 VREFN A44_DCTRL_STRIP_W_R2_0/CTRL_OUT[7] A44_CDAC_CAP_BANK_ASSEMBLY_R8_M6_0/A44_CAP_CORE128_M6_R1_0/CAP_BOTTOM_081 GND nfet_03v3 ad=0 pd=0 as=0 ps=0 w=1.56u l=0.28u
X2867 VREFN A44_DCTRL_STRIP_W_R2_0/CTRL_OUT[7] A44_CDAC_CAP_BANK_ASSEMBLY_R8_M6_0/A44_CAP_CORE128_M6_R1_0/CAP_BOTTOM_081 GND nfet_03v3 ad=0 pd=0 as=0 ps=0 w=1.56u l=0.28u
X2868 VREFN A44_DCTRL_STRIP_W_R2_0/CTRL_OUT[7] A44_CDAC_CAP_BANK_ASSEMBLY_R8_M6_0/A44_CAP_CORE128_M6_R1_0/CAP_BOTTOM_081 GND nfet_03v3 ad=0 pd=0 as=0 ps=0 w=1.56u l=0.28u
X2869 VREFN A44_DCTRL_STRIP_W_R2_0/CTRL_OUT[7] A44_CDAC_CAP_BANK_ASSEMBLY_R8_M6_0/A44_CAP_CORE128_M6_R1_0/CAP_BOTTOM_081 GND nfet_03v3 ad=0 pd=0 as=0 ps=0 w=1.56u l=0.28u
X2870 VREFN A44_DCTRL_STRIP_W_R2_0/CTRL_OUT[7] A44_CDAC_CAP_BANK_ASSEMBLY_R8_M6_0/A44_CAP_CORE128_M6_R1_0/CAP_BOTTOM_081 GND nfet_03v3 ad=0 pd=0 as=0 ps=0 w=1.56u l=0.28u
X2871 VREFN A44_DCTRL_STRIP_W_R2_0/CTRL_OUT[7] A44_CDAC_CAP_BANK_ASSEMBLY_R8_M6_0/A44_CAP_CORE128_M6_R1_0/CAP_BOTTOM_081 GND nfet_03v3 ad=0 pd=0 as=0 ps=0 w=1.56u l=0.28u
X2872 VREFN A44_DCTRL_STRIP_W_R2_0/CTRL_OUT[7] A44_CDAC_CAP_BANK_ASSEMBLY_R8_M6_0/A44_CAP_CORE128_M6_R1_0/CAP_BOTTOM_081 GND nfet_03v3 ad=0 pd=0 as=0 ps=0 w=1.56u l=0.28u
X2873 VREFN A44_DCTRL_STRIP_W_R2_0/CTRL_OUT[7] A44_CDAC_CAP_BANK_ASSEMBLY_R8_M6_0/A44_CAP_CORE128_M6_R1_0/CAP_BOTTOM_081 GND nfet_03v3 ad=0 pd=0 as=0 ps=0 w=1.56u l=0.28u
X2874 VREFN A44_DCTRL_STRIP_W_R2_0/CTRL_OUT[7] A44_CDAC_CAP_BANK_ASSEMBLY_R8_M6_0/A44_CAP_CORE128_M6_R1_0/CAP_BOTTOM_081 GND nfet_03v3 ad=0 pd=0 as=0 ps=0 w=1.56u l=0.28u
X2875 VREFN A44_DCTRL_STRIP_W_R2_0/CTRL_OUT[7] A44_CDAC_CAP_BANK_ASSEMBLY_R8_M6_0/A44_CAP_CORE128_M6_R1_0/CAP_BOTTOM_081 GND nfet_03v3 ad=0 pd=0 as=0 ps=0 w=1.56u l=0.28u
X2876 VREFN A44_DCTRL_STRIP_W_R2_0/CTRL_OUT[7] A44_CDAC_CAP_BANK_ASSEMBLY_R8_M6_0/A44_CAP_CORE128_M6_R1_0/CAP_BOTTOM_081 GND nfet_03v3 ad=0 pd=0 as=0 ps=0 w=1.56u l=0.28u
X2877 VREFN A44_DCTRL_STRIP_W_R2_0/CTRL_OUT[7] A44_CDAC_CAP_BANK_ASSEMBLY_R8_M6_0/A44_CAP_CORE128_M6_R1_0/CAP_BOTTOM_081 GND nfet_03v3 ad=0 pd=0 as=0 ps=0 w=1.56u l=0.28u
X2878 VREFN A44_DCTRL_STRIP_W_R2_0/CTRL_OUT[7] A44_CDAC_CAP_BANK_ASSEMBLY_R8_M6_0/A44_CAP_CORE128_M6_R1_0/CAP_BOTTOM_081 GND nfet_03v3 ad=0 pd=0 as=0 ps=0 w=1.56u l=0.28u
X2879 VREFN A44_DCTRL_STRIP_W_R2_0/CTRL_OUT[7] A44_CDAC_CAP_BANK_ASSEMBLY_R8_M6_0/A44_CAP_CORE128_M6_R1_0/CAP_BOTTOM_081 GND nfet_03v3 ad=0 pd=0 as=0 ps=0 w=1.56u l=0.28u
X2880 VREFN A44_DCTRL_STRIP_W_R2_0/CTRL_OUT[7] A44_CDAC_CAP_BANK_ASSEMBLY_R8_M6_0/A44_CAP_CORE128_M6_R1_0/CAP_BOTTOM_081 GND nfet_03v3 ad=0 pd=0 as=0 ps=0 w=1.56u l=0.28u
X2881 VREFN A44_DCTRL_STRIP_W_R2_0/CTRL_OUT[7] A44_CDAC_CAP_BANK_ASSEMBLY_R8_M6_0/A44_CAP_CORE128_M6_R1_0/CAP_BOTTOM_081 GND nfet_03v3 ad=0 pd=0 as=0 ps=0 w=1.56u l=0.28u
X2882 VREFP A44_DCTRL_STRIP_W_R2_0/CTRL_OUT[6] A44_CDAC_CAP_BANK_ASSEMBLY_R8_M6_0/A44_CAP_CORE128_M6_R1_0/CAP_BOTTOM_110 VDD pfet_03v3 ad=0 pd=0 as=16.6842p ps=77.76u w=1.56u l=0.28u
X2883 VREFP A44_DCTRL_STRIP_W_R2_0/CTRL_OUT[6] A44_CDAC_CAP_BANK_ASSEMBLY_R8_M6_0/A44_CAP_CORE128_M6_R1_0/CAP_BOTTOM_110 VDD pfet_03v3 ad=0 pd=0 as=0 ps=0 w=1.56u l=0.28u
X2884 VREFP A44_DCTRL_STRIP_W_R2_0/CTRL_OUT[6] A44_CDAC_CAP_BANK_ASSEMBLY_R8_M6_0/A44_CAP_CORE128_M6_R1_0/CAP_BOTTOM_110 VDD pfet_03v3 ad=0 pd=0 as=0 ps=0 w=1.56u l=0.28u
X2885 VREFP A44_DCTRL_STRIP_W_R2_0/CTRL_OUT[6] A44_CDAC_CAP_BANK_ASSEMBLY_R8_M6_0/A44_CAP_CORE128_M6_R1_0/CAP_BOTTOM_110 VDD pfet_03v3 ad=0 pd=0 as=0 ps=0 w=1.56u l=0.28u
X2886 VREFP A44_DCTRL_STRIP_W_R2_0/CTRL_OUT[6] A44_CDAC_CAP_BANK_ASSEMBLY_R8_M6_0/A44_CAP_CORE128_M6_R1_0/CAP_BOTTOM_110 VDD pfet_03v3 ad=0 pd=0 as=0 ps=0 w=1.56u l=0.28u
X2887 VREFP A44_DCTRL_STRIP_W_R2_0/CTRL_OUT[6] A44_CDAC_CAP_BANK_ASSEMBLY_R8_M6_0/A44_CAP_CORE128_M6_R1_0/CAP_BOTTOM_110 VDD pfet_03v3 ad=0 pd=0 as=0 ps=0 w=1.56u l=0.28u
X2888 VREFP A44_DCTRL_STRIP_W_R2_0/CTRL_OUT[6] A44_CDAC_CAP_BANK_ASSEMBLY_R8_M6_0/A44_CAP_CORE128_M6_R1_0/CAP_BOTTOM_110 VDD pfet_03v3 ad=0 pd=0 as=0 ps=0 w=1.56u l=0.28u
X2889 VREFP A44_DCTRL_STRIP_W_R2_0/CTRL_OUT[6] A44_CDAC_CAP_BANK_ASSEMBLY_R8_M6_0/A44_CAP_CORE128_M6_R1_0/CAP_BOTTOM_110 VDD pfet_03v3 ad=0 pd=0 as=0 ps=0 w=1.56u l=0.28u
X2890 VREFP A44_DCTRL_STRIP_W_R2_0/CTRL_OUT[6] A44_CDAC_CAP_BANK_ASSEMBLY_R8_M6_0/A44_CAP_CORE128_M6_R1_0/CAP_BOTTOM_110 VDD pfet_03v3 ad=0 pd=0 as=0 ps=0 w=1.56u l=0.28u
X2891 VREFP A44_DCTRL_STRIP_W_R2_0/CTRL_OUT[6] A44_CDAC_CAP_BANK_ASSEMBLY_R8_M6_0/A44_CAP_CORE128_M6_R1_0/CAP_BOTTOM_110 VDD pfet_03v3 ad=0 pd=0 as=0 ps=0 w=1.56u l=0.28u
X2892 VREFP A44_DCTRL_STRIP_W_R2_0/CTRL_OUT[6] A44_CDAC_CAP_BANK_ASSEMBLY_R8_M6_0/A44_CAP_CORE128_M6_R1_0/CAP_BOTTOM_110 VDD pfet_03v3 ad=0 pd=0 as=0 ps=0 w=1.56u l=0.28u
X2893 VREFP A44_DCTRL_STRIP_W_R2_0/CTRL_OUT[6] A44_CDAC_CAP_BANK_ASSEMBLY_R8_M6_0/A44_CAP_CORE128_M6_R1_0/CAP_BOTTOM_110 VDD pfet_03v3 ad=0 pd=0 as=0 ps=0 w=1.56u l=0.28u
X2894 VREFP A44_DCTRL_STRIP_W_R2_0/CTRL_OUT[6] A44_CDAC_CAP_BANK_ASSEMBLY_R8_M6_0/A44_CAP_CORE128_M6_R1_0/CAP_BOTTOM_110 VDD pfet_03v3 ad=0 pd=0 as=0 ps=0 w=1.56u l=0.28u
X2895 VREFP A44_DCTRL_STRIP_W_R2_0/CTRL_OUT[6] A44_CDAC_CAP_BANK_ASSEMBLY_R8_M6_0/A44_CAP_CORE128_M6_R1_0/CAP_BOTTOM_110 VDD pfet_03v3 ad=0 pd=0 as=0 ps=0 w=1.56u l=0.28u
X2896 VREFP A44_DCTRL_STRIP_W_R2_0/CTRL_OUT[6] A44_CDAC_CAP_BANK_ASSEMBLY_R8_M6_0/A44_CAP_CORE128_M6_R1_0/CAP_BOTTOM_110 VDD pfet_03v3 ad=0 pd=0 as=0 ps=0 w=1.56u l=0.28u
X2897 VREFP A44_DCTRL_STRIP_W_R2_0/CTRL_OUT[6] A44_CDAC_CAP_BANK_ASSEMBLY_R8_M6_0/A44_CAP_CORE128_M6_R1_0/CAP_BOTTOM_110 VDD pfet_03v3 ad=0 pd=0 as=0 ps=0 w=1.56u l=0.28u
X2898 VREFP A44_DCTRL_STRIP_W_R2_0/CTRL_OUT[6] A44_CDAC_CAP_BANK_ASSEMBLY_R8_M6_0/A44_CAP_CORE128_M6_R1_0/CAP_BOTTOM_110 VDD pfet_03v3 ad=0 pd=0 as=0 ps=0 w=1.56u l=0.28u
X2899 VREFP A44_DCTRL_STRIP_W_R2_0/CTRL_OUT[6] A44_CDAC_CAP_BANK_ASSEMBLY_R8_M6_0/A44_CAP_CORE128_M6_R1_0/CAP_BOTTOM_110 VDD pfet_03v3 ad=0 pd=0 as=0 ps=0 w=1.56u l=0.28u
X2900 VREFN A44_DCTRL_STRIP_W_R2_0/CTRL_OUT[6] A44_CDAC_CAP_BANK_ASSEMBLY_R8_M6_0/A44_CAP_CORE128_M6_R1_0/CAP_BOTTOM_110 GND nfet_03v3 ad=0 pd=0 as=16.6842p ps=77.76u w=1.56u l=0.28u
X2901 VREFN A44_DCTRL_STRIP_W_R2_0/CTRL_OUT[6] A44_CDAC_CAP_BANK_ASSEMBLY_R8_M6_0/A44_CAP_CORE128_M6_R1_0/CAP_BOTTOM_110 GND nfet_03v3 ad=0 pd=0 as=0 ps=0 w=1.56u l=0.28u
X2902 VREFN A44_DCTRL_STRIP_W_R2_0/CTRL_OUT[6] A44_CDAC_CAP_BANK_ASSEMBLY_R8_M6_0/A44_CAP_CORE128_M6_R1_0/CAP_BOTTOM_110 GND nfet_03v3 ad=0 pd=0 as=0 ps=0 w=1.56u l=0.28u
X2903 VREFN A44_DCTRL_STRIP_W_R2_0/CTRL_OUT[6] A44_CDAC_CAP_BANK_ASSEMBLY_R8_M6_0/A44_CAP_CORE128_M6_R1_0/CAP_BOTTOM_110 GND nfet_03v3 ad=0 pd=0 as=0 ps=0 w=1.56u l=0.28u
X2904 VREFN A44_DCTRL_STRIP_W_R2_0/CTRL_OUT[6] A44_CDAC_CAP_BANK_ASSEMBLY_R8_M6_0/A44_CAP_CORE128_M6_R1_0/CAP_BOTTOM_110 GND nfet_03v3 ad=0 pd=0 as=0 ps=0 w=1.56u l=0.28u
X2905 VREFN A44_DCTRL_STRIP_W_R2_0/CTRL_OUT[6] A44_CDAC_CAP_BANK_ASSEMBLY_R8_M6_0/A44_CAP_CORE128_M6_R1_0/CAP_BOTTOM_110 GND nfet_03v3 ad=0 pd=0 as=0 ps=0 w=1.56u l=0.28u
X2906 VREFN A44_DCTRL_STRIP_W_R2_0/CTRL_OUT[6] A44_CDAC_CAP_BANK_ASSEMBLY_R8_M6_0/A44_CAP_CORE128_M6_R1_0/CAP_BOTTOM_110 GND nfet_03v3 ad=0 pd=0 as=0 ps=0 w=1.56u l=0.28u
X2907 VREFN A44_DCTRL_STRIP_W_R2_0/CTRL_OUT[6] A44_CDAC_CAP_BANK_ASSEMBLY_R8_M6_0/A44_CAP_CORE128_M6_R1_0/CAP_BOTTOM_110 GND nfet_03v3 ad=0 pd=0 as=0 ps=0 w=1.56u l=0.28u
X2908 VREFN A44_DCTRL_STRIP_W_R2_0/CTRL_OUT[6] A44_CDAC_CAP_BANK_ASSEMBLY_R8_M6_0/A44_CAP_CORE128_M6_R1_0/CAP_BOTTOM_110 GND nfet_03v3 ad=0 pd=0 as=0 ps=0 w=1.56u l=0.28u
X2909 VREFN A44_DCTRL_STRIP_W_R2_0/CTRL_OUT[6] A44_CDAC_CAP_BANK_ASSEMBLY_R8_M6_0/A44_CAP_CORE128_M6_R1_0/CAP_BOTTOM_110 GND nfet_03v3 ad=0 pd=0 as=0 ps=0 w=1.56u l=0.28u
X2910 VREFN A44_DCTRL_STRIP_W_R2_0/CTRL_OUT[6] A44_CDAC_CAP_BANK_ASSEMBLY_R8_M6_0/A44_CAP_CORE128_M6_R1_0/CAP_BOTTOM_110 GND nfet_03v3 ad=0 pd=0 as=0 ps=0 w=1.56u l=0.28u
X2911 VREFN A44_DCTRL_STRIP_W_R2_0/CTRL_OUT[6] A44_CDAC_CAP_BANK_ASSEMBLY_R8_M6_0/A44_CAP_CORE128_M6_R1_0/CAP_BOTTOM_110 GND nfet_03v3 ad=0 pd=0 as=0 ps=0 w=1.56u l=0.28u
X2912 VREFN A44_DCTRL_STRIP_W_R2_0/CTRL_OUT[6] A44_CDAC_CAP_BANK_ASSEMBLY_R8_M6_0/A44_CAP_CORE128_M6_R1_0/CAP_BOTTOM_110 GND nfet_03v3 ad=0 pd=0 as=0 ps=0 w=1.56u l=0.28u
X2913 VREFN A44_DCTRL_STRIP_W_R2_0/CTRL_OUT[6] A44_CDAC_CAP_BANK_ASSEMBLY_R8_M6_0/A44_CAP_CORE128_M6_R1_0/CAP_BOTTOM_110 GND nfet_03v3 ad=0 pd=0 as=0 ps=0 w=1.56u l=0.28u
X2914 VREFN A44_DCTRL_STRIP_W_R2_0/CTRL_OUT[6] A44_CDAC_CAP_BANK_ASSEMBLY_R8_M6_0/A44_CAP_CORE128_M6_R1_0/CAP_BOTTOM_110 GND nfet_03v3 ad=0 pd=0 as=0 ps=0 w=1.56u l=0.28u
X2915 VREFN A44_DCTRL_STRIP_W_R2_0/CTRL_OUT[6] A44_CDAC_CAP_BANK_ASSEMBLY_R8_M6_0/A44_CAP_CORE128_M6_R1_0/CAP_BOTTOM_110 GND nfet_03v3 ad=0 pd=0 as=0 ps=0 w=1.56u l=0.28u
X2916 VREFN A44_DCTRL_STRIP_W_R2_0/CTRL_OUT[6] A44_CDAC_CAP_BANK_ASSEMBLY_R8_M6_0/A44_CAP_CORE128_M6_R1_0/CAP_BOTTOM_110 GND nfet_03v3 ad=0 pd=0 as=0 ps=0 w=1.56u l=0.28u
X2917 VREFN A44_DCTRL_STRIP_W_R2_0/CTRL_OUT[6] A44_CDAC_CAP_BANK_ASSEMBLY_R8_M6_0/A44_CAP_CORE128_M6_R1_0/CAP_BOTTOM_110 GND nfet_03v3 ad=0 pd=0 as=0 ps=0 w=1.56u l=0.28u
X2918 VREFP A44_DCTRL_STRIP_W_R2_0/CTRL_OUT[7] A44_CDAC_CAP_BANK_ASSEMBLY_R8_M6_0/A44_CAP_CORE128_M6_R1_0/CAP_BOTTOM_069 VDD pfet_03v3 ad=0 pd=0 as=16.6842p ps=77.76u w=1.56u l=0.28u
X2919 VREFP A44_DCTRL_STRIP_W_R2_0/CTRL_OUT[7] A44_CDAC_CAP_BANK_ASSEMBLY_R8_M6_0/A44_CAP_CORE128_M6_R1_0/CAP_BOTTOM_069 VDD pfet_03v3 ad=0 pd=0 as=0 ps=0 w=1.56u l=0.28u
X2920 VREFP A44_DCTRL_STRIP_W_R2_0/CTRL_OUT[7] A44_CDAC_CAP_BANK_ASSEMBLY_R8_M6_0/A44_CAP_CORE128_M6_R1_0/CAP_BOTTOM_069 VDD pfet_03v3 ad=0 pd=0 as=0 ps=0 w=1.56u l=0.28u
X2921 VREFP A44_DCTRL_STRIP_W_R2_0/CTRL_OUT[7] A44_CDAC_CAP_BANK_ASSEMBLY_R8_M6_0/A44_CAP_CORE128_M6_R1_0/CAP_BOTTOM_069 VDD pfet_03v3 ad=0 pd=0 as=0 ps=0 w=1.56u l=0.28u
X2922 VREFP A44_DCTRL_STRIP_W_R2_0/CTRL_OUT[7] A44_CDAC_CAP_BANK_ASSEMBLY_R8_M6_0/A44_CAP_CORE128_M6_R1_0/CAP_BOTTOM_069 VDD pfet_03v3 ad=0 pd=0 as=0 ps=0 w=1.56u l=0.28u
X2923 VREFP A44_DCTRL_STRIP_W_R2_0/CTRL_OUT[7] A44_CDAC_CAP_BANK_ASSEMBLY_R8_M6_0/A44_CAP_CORE128_M6_R1_0/CAP_BOTTOM_069 VDD pfet_03v3 ad=0 pd=0 as=0 ps=0 w=1.56u l=0.28u
X2924 VREFP A44_DCTRL_STRIP_W_R2_0/CTRL_OUT[7] A44_CDAC_CAP_BANK_ASSEMBLY_R8_M6_0/A44_CAP_CORE128_M6_R1_0/CAP_BOTTOM_069 VDD pfet_03v3 ad=0 pd=0 as=0 ps=0 w=1.56u l=0.28u
X2925 VREFP A44_DCTRL_STRIP_W_R2_0/CTRL_OUT[7] A44_CDAC_CAP_BANK_ASSEMBLY_R8_M6_0/A44_CAP_CORE128_M6_R1_0/CAP_BOTTOM_069 VDD pfet_03v3 ad=0 pd=0 as=0 ps=0 w=1.56u l=0.28u
X2926 VREFP A44_DCTRL_STRIP_W_R2_0/CTRL_OUT[7] A44_CDAC_CAP_BANK_ASSEMBLY_R8_M6_0/A44_CAP_CORE128_M6_R1_0/CAP_BOTTOM_069 VDD pfet_03v3 ad=0 pd=0 as=0 ps=0 w=1.56u l=0.28u
X2927 VREFP A44_DCTRL_STRIP_W_R2_0/CTRL_OUT[7] A44_CDAC_CAP_BANK_ASSEMBLY_R8_M6_0/A44_CAP_CORE128_M6_R1_0/CAP_BOTTOM_069 VDD pfet_03v3 ad=0 pd=0 as=0 ps=0 w=1.56u l=0.28u
X2928 VREFP A44_DCTRL_STRIP_W_R2_0/CTRL_OUT[7] A44_CDAC_CAP_BANK_ASSEMBLY_R8_M6_0/A44_CAP_CORE128_M6_R1_0/CAP_BOTTOM_069 VDD pfet_03v3 ad=0 pd=0 as=0 ps=0 w=1.56u l=0.28u
X2929 VREFP A44_DCTRL_STRIP_W_R2_0/CTRL_OUT[7] A44_CDAC_CAP_BANK_ASSEMBLY_R8_M6_0/A44_CAP_CORE128_M6_R1_0/CAP_BOTTOM_069 VDD pfet_03v3 ad=0 pd=0 as=0 ps=0 w=1.56u l=0.28u
X2930 VREFP A44_DCTRL_STRIP_W_R2_0/CTRL_OUT[7] A44_CDAC_CAP_BANK_ASSEMBLY_R8_M6_0/A44_CAP_CORE128_M6_R1_0/CAP_BOTTOM_069 VDD pfet_03v3 ad=0 pd=0 as=0 ps=0 w=1.56u l=0.28u
X2931 VREFP A44_DCTRL_STRIP_W_R2_0/CTRL_OUT[7] A44_CDAC_CAP_BANK_ASSEMBLY_R8_M6_0/A44_CAP_CORE128_M6_R1_0/CAP_BOTTOM_069 VDD pfet_03v3 ad=0 pd=0 as=0 ps=0 w=1.56u l=0.28u
X2932 VREFP A44_DCTRL_STRIP_W_R2_0/CTRL_OUT[7] A44_CDAC_CAP_BANK_ASSEMBLY_R8_M6_0/A44_CAP_CORE128_M6_R1_0/CAP_BOTTOM_069 VDD pfet_03v3 ad=0 pd=0 as=0 ps=0 w=1.56u l=0.28u
X2933 VREFP A44_DCTRL_STRIP_W_R2_0/CTRL_OUT[7] A44_CDAC_CAP_BANK_ASSEMBLY_R8_M6_0/A44_CAP_CORE128_M6_R1_0/CAP_BOTTOM_069 VDD pfet_03v3 ad=0 pd=0 as=0 ps=0 w=1.56u l=0.28u
X2934 VREFP A44_DCTRL_STRIP_W_R2_0/CTRL_OUT[7] A44_CDAC_CAP_BANK_ASSEMBLY_R8_M6_0/A44_CAP_CORE128_M6_R1_0/CAP_BOTTOM_069 VDD pfet_03v3 ad=0 pd=0 as=0 ps=0 w=1.56u l=0.28u
X2935 VREFP A44_DCTRL_STRIP_W_R2_0/CTRL_OUT[7] A44_CDAC_CAP_BANK_ASSEMBLY_R8_M6_0/A44_CAP_CORE128_M6_R1_0/CAP_BOTTOM_069 VDD pfet_03v3 ad=0 pd=0 as=0 ps=0 w=1.56u l=0.28u
X2936 VREFN A44_DCTRL_STRIP_W_R2_0/CTRL_OUT[7] A44_CDAC_CAP_BANK_ASSEMBLY_R8_M6_0/A44_CAP_CORE128_M6_R1_0/CAP_BOTTOM_069 GND nfet_03v3 ad=0 pd=0 as=16.6842p ps=77.76u w=1.56u l=0.28u
X2937 VREFN A44_DCTRL_STRIP_W_R2_0/CTRL_OUT[7] A44_CDAC_CAP_BANK_ASSEMBLY_R8_M6_0/A44_CAP_CORE128_M6_R1_0/CAP_BOTTOM_069 GND nfet_03v3 ad=0 pd=0 as=0 ps=0 w=1.56u l=0.28u
X2938 VREFN A44_DCTRL_STRIP_W_R2_0/CTRL_OUT[7] A44_CDAC_CAP_BANK_ASSEMBLY_R8_M6_0/A44_CAP_CORE128_M6_R1_0/CAP_BOTTOM_069 GND nfet_03v3 ad=0 pd=0 as=0 ps=0 w=1.56u l=0.28u
X2939 VREFN A44_DCTRL_STRIP_W_R2_0/CTRL_OUT[7] A44_CDAC_CAP_BANK_ASSEMBLY_R8_M6_0/A44_CAP_CORE128_M6_R1_0/CAP_BOTTOM_069 GND nfet_03v3 ad=0 pd=0 as=0 ps=0 w=1.56u l=0.28u
X2940 VREFN A44_DCTRL_STRIP_W_R2_0/CTRL_OUT[7] A44_CDAC_CAP_BANK_ASSEMBLY_R8_M6_0/A44_CAP_CORE128_M6_R1_0/CAP_BOTTOM_069 GND nfet_03v3 ad=0 pd=0 as=0 ps=0 w=1.56u l=0.28u
X2941 VREFN A44_DCTRL_STRIP_W_R2_0/CTRL_OUT[7] A44_CDAC_CAP_BANK_ASSEMBLY_R8_M6_0/A44_CAP_CORE128_M6_R1_0/CAP_BOTTOM_069 GND nfet_03v3 ad=0 pd=0 as=0 ps=0 w=1.56u l=0.28u
X2942 VREFN A44_DCTRL_STRIP_W_R2_0/CTRL_OUT[7] A44_CDAC_CAP_BANK_ASSEMBLY_R8_M6_0/A44_CAP_CORE128_M6_R1_0/CAP_BOTTOM_069 GND nfet_03v3 ad=0 pd=0 as=0 ps=0 w=1.56u l=0.28u
X2943 VREFN A44_DCTRL_STRIP_W_R2_0/CTRL_OUT[7] A44_CDAC_CAP_BANK_ASSEMBLY_R8_M6_0/A44_CAP_CORE128_M6_R1_0/CAP_BOTTOM_069 GND nfet_03v3 ad=0 pd=0 as=0 ps=0 w=1.56u l=0.28u
X2944 VREFN A44_DCTRL_STRIP_W_R2_0/CTRL_OUT[7] A44_CDAC_CAP_BANK_ASSEMBLY_R8_M6_0/A44_CAP_CORE128_M6_R1_0/CAP_BOTTOM_069 GND nfet_03v3 ad=0 pd=0 as=0 ps=0 w=1.56u l=0.28u
X2945 VREFN A44_DCTRL_STRIP_W_R2_0/CTRL_OUT[7] A44_CDAC_CAP_BANK_ASSEMBLY_R8_M6_0/A44_CAP_CORE128_M6_R1_0/CAP_BOTTOM_069 GND nfet_03v3 ad=0 pd=0 as=0 ps=0 w=1.56u l=0.28u
X2946 VREFN A44_DCTRL_STRIP_W_R2_0/CTRL_OUT[7] A44_CDAC_CAP_BANK_ASSEMBLY_R8_M6_0/A44_CAP_CORE128_M6_R1_0/CAP_BOTTOM_069 GND nfet_03v3 ad=0 pd=0 as=0 ps=0 w=1.56u l=0.28u
X2947 VREFN A44_DCTRL_STRIP_W_R2_0/CTRL_OUT[7] A44_CDAC_CAP_BANK_ASSEMBLY_R8_M6_0/A44_CAP_CORE128_M6_R1_0/CAP_BOTTOM_069 GND nfet_03v3 ad=0 pd=0 as=0 ps=0 w=1.56u l=0.28u
X2948 VREFN A44_DCTRL_STRIP_W_R2_0/CTRL_OUT[7] A44_CDAC_CAP_BANK_ASSEMBLY_R8_M6_0/A44_CAP_CORE128_M6_R1_0/CAP_BOTTOM_069 GND nfet_03v3 ad=0 pd=0 as=0 ps=0 w=1.56u l=0.28u
X2949 VREFN A44_DCTRL_STRIP_W_R2_0/CTRL_OUT[7] A44_CDAC_CAP_BANK_ASSEMBLY_R8_M6_0/A44_CAP_CORE128_M6_R1_0/CAP_BOTTOM_069 GND nfet_03v3 ad=0 pd=0 as=0 ps=0 w=1.56u l=0.28u
X2950 VREFN A44_DCTRL_STRIP_W_R2_0/CTRL_OUT[7] A44_CDAC_CAP_BANK_ASSEMBLY_R8_M6_0/A44_CAP_CORE128_M6_R1_0/CAP_BOTTOM_069 GND nfet_03v3 ad=0 pd=0 as=0 ps=0 w=1.56u l=0.28u
X2951 VREFN A44_DCTRL_STRIP_W_R2_0/CTRL_OUT[7] A44_CDAC_CAP_BANK_ASSEMBLY_R8_M6_0/A44_CAP_CORE128_M6_R1_0/CAP_BOTTOM_069 GND nfet_03v3 ad=0 pd=0 as=0 ps=0 w=1.56u l=0.28u
X2952 VREFN A44_DCTRL_STRIP_W_R2_0/CTRL_OUT[7] A44_CDAC_CAP_BANK_ASSEMBLY_R8_M6_0/A44_CAP_CORE128_M6_R1_0/CAP_BOTTOM_069 GND nfet_03v3 ad=0 pd=0 as=0 ps=0 w=1.56u l=0.28u
X2953 VREFN A44_DCTRL_STRIP_W_R2_0/CTRL_OUT[7] A44_CDAC_CAP_BANK_ASSEMBLY_R8_M6_0/A44_CAP_CORE128_M6_R1_0/CAP_BOTTOM_069 GND nfet_03v3 ad=0 pd=0 as=0 ps=0 w=1.56u l=0.28u
X2954 VREFP A44_DCTRL_STRIP_W_R2_0/CTRL_OUT[6] A44_CDAC_CAP_BANK_ASSEMBLY_R8_M6_0/A44_CAP_CORE128_M6_R1_0/CAP_BOTTOM_092 VDD pfet_03v3 ad=0 pd=0 as=16.6842p ps=77.76u w=1.56u l=0.28u
X2955 VREFP A44_DCTRL_STRIP_W_R2_0/CTRL_OUT[6] A44_CDAC_CAP_BANK_ASSEMBLY_R8_M6_0/A44_CAP_CORE128_M6_R1_0/CAP_BOTTOM_092 VDD pfet_03v3 ad=0 pd=0 as=0 ps=0 w=1.56u l=0.28u
X2956 VREFP A44_DCTRL_STRIP_W_R2_0/CTRL_OUT[6] A44_CDAC_CAP_BANK_ASSEMBLY_R8_M6_0/A44_CAP_CORE128_M6_R1_0/CAP_BOTTOM_092 VDD pfet_03v3 ad=0 pd=0 as=0 ps=0 w=1.56u l=0.28u
X2957 VREFP A44_DCTRL_STRIP_W_R2_0/CTRL_OUT[6] A44_CDAC_CAP_BANK_ASSEMBLY_R8_M6_0/A44_CAP_CORE128_M6_R1_0/CAP_BOTTOM_092 VDD pfet_03v3 ad=0 pd=0 as=0 ps=0 w=1.56u l=0.28u
X2958 VREFP A44_DCTRL_STRIP_W_R2_0/CTRL_OUT[6] A44_CDAC_CAP_BANK_ASSEMBLY_R8_M6_0/A44_CAP_CORE128_M6_R1_0/CAP_BOTTOM_092 VDD pfet_03v3 ad=0 pd=0 as=0 ps=0 w=1.56u l=0.28u
X2959 VREFP A44_DCTRL_STRIP_W_R2_0/CTRL_OUT[6] A44_CDAC_CAP_BANK_ASSEMBLY_R8_M6_0/A44_CAP_CORE128_M6_R1_0/CAP_BOTTOM_092 VDD pfet_03v3 ad=0 pd=0 as=0 ps=0 w=1.56u l=0.28u
X2960 VREFP A44_DCTRL_STRIP_W_R2_0/CTRL_OUT[6] A44_CDAC_CAP_BANK_ASSEMBLY_R8_M6_0/A44_CAP_CORE128_M6_R1_0/CAP_BOTTOM_092 VDD pfet_03v3 ad=0 pd=0 as=0 ps=0 w=1.56u l=0.28u
X2961 VREFP A44_DCTRL_STRIP_W_R2_0/CTRL_OUT[6] A44_CDAC_CAP_BANK_ASSEMBLY_R8_M6_0/A44_CAP_CORE128_M6_R1_0/CAP_BOTTOM_092 VDD pfet_03v3 ad=0 pd=0 as=0 ps=0 w=1.56u l=0.28u
X2962 VREFP A44_DCTRL_STRIP_W_R2_0/CTRL_OUT[6] A44_CDAC_CAP_BANK_ASSEMBLY_R8_M6_0/A44_CAP_CORE128_M6_R1_0/CAP_BOTTOM_092 VDD pfet_03v3 ad=0 pd=0 as=0 ps=0 w=1.56u l=0.28u
X2963 VREFP A44_DCTRL_STRIP_W_R2_0/CTRL_OUT[6] A44_CDAC_CAP_BANK_ASSEMBLY_R8_M6_0/A44_CAP_CORE128_M6_R1_0/CAP_BOTTOM_092 VDD pfet_03v3 ad=0 pd=0 as=0 ps=0 w=1.56u l=0.28u
X2964 VREFP A44_DCTRL_STRIP_W_R2_0/CTRL_OUT[6] A44_CDAC_CAP_BANK_ASSEMBLY_R8_M6_0/A44_CAP_CORE128_M6_R1_0/CAP_BOTTOM_092 VDD pfet_03v3 ad=0 pd=0 as=0 ps=0 w=1.56u l=0.28u
X2965 VREFP A44_DCTRL_STRIP_W_R2_0/CTRL_OUT[6] A44_CDAC_CAP_BANK_ASSEMBLY_R8_M6_0/A44_CAP_CORE128_M6_R1_0/CAP_BOTTOM_092 VDD pfet_03v3 ad=0 pd=0 as=0 ps=0 w=1.56u l=0.28u
X2966 VREFP A44_DCTRL_STRIP_W_R2_0/CTRL_OUT[6] A44_CDAC_CAP_BANK_ASSEMBLY_R8_M6_0/A44_CAP_CORE128_M6_R1_0/CAP_BOTTOM_092 VDD pfet_03v3 ad=0 pd=0 as=0 ps=0 w=1.56u l=0.28u
X2967 VREFP A44_DCTRL_STRIP_W_R2_0/CTRL_OUT[6] A44_CDAC_CAP_BANK_ASSEMBLY_R8_M6_0/A44_CAP_CORE128_M6_R1_0/CAP_BOTTOM_092 VDD pfet_03v3 ad=0 pd=0 as=0 ps=0 w=1.56u l=0.28u
X2968 VREFP A44_DCTRL_STRIP_W_R2_0/CTRL_OUT[6] A44_CDAC_CAP_BANK_ASSEMBLY_R8_M6_0/A44_CAP_CORE128_M6_R1_0/CAP_BOTTOM_092 VDD pfet_03v3 ad=0 pd=0 as=0 ps=0 w=1.56u l=0.28u
X2969 VREFP A44_DCTRL_STRIP_W_R2_0/CTRL_OUT[6] A44_CDAC_CAP_BANK_ASSEMBLY_R8_M6_0/A44_CAP_CORE128_M6_R1_0/CAP_BOTTOM_092 VDD pfet_03v3 ad=0 pd=0 as=0 ps=0 w=1.56u l=0.28u
X2970 VREFP A44_DCTRL_STRIP_W_R2_0/CTRL_OUT[6] A44_CDAC_CAP_BANK_ASSEMBLY_R8_M6_0/A44_CAP_CORE128_M6_R1_0/CAP_BOTTOM_092 VDD pfet_03v3 ad=0 pd=0 as=0 ps=0 w=1.56u l=0.28u
X2971 VREFP A44_DCTRL_STRIP_W_R2_0/CTRL_OUT[6] A44_CDAC_CAP_BANK_ASSEMBLY_R8_M6_0/A44_CAP_CORE128_M6_R1_0/CAP_BOTTOM_092 VDD pfet_03v3 ad=0 pd=0 as=0 ps=0 w=1.56u l=0.28u
X2972 VREFN A44_DCTRL_STRIP_W_R2_0/CTRL_OUT[6] A44_CDAC_CAP_BANK_ASSEMBLY_R8_M6_0/A44_CAP_CORE128_M6_R1_0/CAP_BOTTOM_092 GND nfet_03v3 ad=0 pd=0 as=16.6842p ps=77.76u w=1.56u l=0.28u
X2973 VREFN A44_DCTRL_STRIP_W_R2_0/CTRL_OUT[6] A44_CDAC_CAP_BANK_ASSEMBLY_R8_M6_0/A44_CAP_CORE128_M6_R1_0/CAP_BOTTOM_092 GND nfet_03v3 ad=0 pd=0 as=0 ps=0 w=1.56u l=0.28u
X2974 VREFN A44_DCTRL_STRIP_W_R2_0/CTRL_OUT[6] A44_CDAC_CAP_BANK_ASSEMBLY_R8_M6_0/A44_CAP_CORE128_M6_R1_0/CAP_BOTTOM_092 GND nfet_03v3 ad=0 pd=0 as=0 ps=0 w=1.56u l=0.28u
X2975 VREFN A44_DCTRL_STRIP_W_R2_0/CTRL_OUT[6] A44_CDAC_CAP_BANK_ASSEMBLY_R8_M6_0/A44_CAP_CORE128_M6_R1_0/CAP_BOTTOM_092 GND nfet_03v3 ad=0 pd=0 as=0 ps=0 w=1.56u l=0.28u
X2976 VREFN A44_DCTRL_STRIP_W_R2_0/CTRL_OUT[6] A44_CDAC_CAP_BANK_ASSEMBLY_R8_M6_0/A44_CAP_CORE128_M6_R1_0/CAP_BOTTOM_092 GND nfet_03v3 ad=0 pd=0 as=0 ps=0 w=1.56u l=0.28u
X2977 VREFN A44_DCTRL_STRIP_W_R2_0/CTRL_OUT[6] A44_CDAC_CAP_BANK_ASSEMBLY_R8_M6_0/A44_CAP_CORE128_M6_R1_0/CAP_BOTTOM_092 GND nfet_03v3 ad=0 pd=0 as=0 ps=0 w=1.56u l=0.28u
X2978 VREFN A44_DCTRL_STRIP_W_R2_0/CTRL_OUT[6] A44_CDAC_CAP_BANK_ASSEMBLY_R8_M6_0/A44_CAP_CORE128_M6_R1_0/CAP_BOTTOM_092 GND nfet_03v3 ad=0 pd=0 as=0 ps=0 w=1.56u l=0.28u
X2979 VREFN A44_DCTRL_STRIP_W_R2_0/CTRL_OUT[6] A44_CDAC_CAP_BANK_ASSEMBLY_R8_M6_0/A44_CAP_CORE128_M6_R1_0/CAP_BOTTOM_092 GND nfet_03v3 ad=0 pd=0 as=0 ps=0 w=1.56u l=0.28u
X2980 VREFN A44_DCTRL_STRIP_W_R2_0/CTRL_OUT[6] A44_CDAC_CAP_BANK_ASSEMBLY_R8_M6_0/A44_CAP_CORE128_M6_R1_0/CAP_BOTTOM_092 GND nfet_03v3 ad=0 pd=0 as=0 ps=0 w=1.56u l=0.28u
X2981 VREFN A44_DCTRL_STRIP_W_R2_0/CTRL_OUT[6] A44_CDAC_CAP_BANK_ASSEMBLY_R8_M6_0/A44_CAP_CORE128_M6_R1_0/CAP_BOTTOM_092 GND nfet_03v3 ad=0 pd=0 as=0 ps=0 w=1.56u l=0.28u
X2982 VREFN A44_DCTRL_STRIP_W_R2_0/CTRL_OUT[6] A44_CDAC_CAP_BANK_ASSEMBLY_R8_M6_0/A44_CAP_CORE128_M6_R1_0/CAP_BOTTOM_092 GND nfet_03v3 ad=0 pd=0 as=0 ps=0 w=1.56u l=0.28u
X2983 VREFN A44_DCTRL_STRIP_W_R2_0/CTRL_OUT[6] A44_CDAC_CAP_BANK_ASSEMBLY_R8_M6_0/A44_CAP_CORE128_M6_R1_0/CAP_BOTTOM_092 GND nfet_03v3 ad=0 pd=0 as=0 ps=0 w=1.56u l=0.28u
X2984 VREFN A44_DCTRL_STRIP_W_R2_0/CTRL_OUT[6] A44_CDAC_CAP_BANK_ASSEMBLY_R8_M6_0/A44_CAP_CORE128_M6_R1_0/CAP_BOTTOM_092 GND nfet_03v3 ad=0 pd=0 as=0 ps=0 w=1.56u l=0.28u
X2985 VREFN A44_DCTRL_STRIP_W_R2_0/CTRL_OUT[6] A44_CDAC_CAP_BANK_ASSEMBLY_R8_M6_0/A44_CAP_CORE128_M6_R1_0/CAP_BOTTOM_092 GND nfet_03v3 ad=0 pd=0 as=0 ps=0 w=1.56u l=0.28u
X2986 VREFN A44_DCTRL_STRIP_W_R2_0/CTRL_OUT[6] A44_CDAC_CAP_BANK_ASSEMBLY_R8_M6_0/A44_CAP_CORE128_M6_R1_0/CAP_BOTTOM_092 GND nfet_03v3 ad=0 pd=0 as=0 ps=0 w=1.56u l=0.28u
X2987 VREFN A44_DCTRL_STRIP_W_R2_0/CTRL_OUT[6] A44_CDAC_CAP_BANK_ASSEMBLY_R8_M6_0/A44_CAP_CORE128_M6_R1_0/CAP_BOTTOM_092 GND nfet_03v3 ad=0 pd=0 as=0 ps=0 w=1.56u l=0.28u
X2988 VREFN A44_DCTRL_STRIP_W_R2_0/CTRL_OUT[6] A44_CDAC_CAP_BANK_ASSEMBLY_R8_M6_0/A44_CAP_CORE128_M6_R1_0/CAP_BOTTOM_092 GND nfet_03v3 ad=0 pd=0 as=0 ps=0 w=1.56u l=0.28u
X2989 VREFN A44_DCTRL_STRIP_W_R2_0/CTRL_OUT[6] A44_CDAC_CAP_BANK_ASSEMBLY_R8_M6_0/A44_CAP_CORE128_M6_R1_0/CAP_BOTTOM_092 GND nfet_03v3 ad=0 pd=0 as=0 ps=0 w=1.56u l=0.28u
X2990 VREFP A44_DCTRL_STRIP_W_R2_0/CTRL_OUT[6] A44_CDAC_CAP_BANK_ASSEMBLY_R8_M6_0/A44_CAP_CORE128_M6_R1_0/CAP_BOTTOM_115 VDD pfet_03v3 ad=0 pd=0 as=16.6842p ps=77.76u w=1.56u l=0.28u
X2991 VREFP A44_DCTRL_STRIP_W_R2_0/CTRL_OUT[6] A44_CDAC_CAP_BANK_ASSEMBLY_R8_M6_0/A44_CAP_CORE128_M6_R1_0/CAP_BOTTOM_115 VDD pfet_03v3 ad=0 pd=0 as=0 ps=0 w=1.56u l=0.28u
X2992 VREFP A44_DCTRL_STRIP_W_R2_0/CTRL_OUT[6] A44_CDAC_CAP_BANK_ASSEMBLY_R8_M6_0/A44_CAP_CORE128_M6_R1_0/CAP_BOTTOM_115 VDD pfet_03v3 ad=0 pd=0 as=0 ps=0 w=1.56u l=0.28u
X2993 VREFP A44_DCTRL_STRIP_W_R2_0/CTRL_OUT[6] A44_CDAC_CAP_BANK_ASSEMBLY_R8_M6_0/A44_CAP_CORE128_M6_R1_0/CAP_BOTTOM_115 VDD pfet_03v3 ad=0 pd=0 as=0 ps=0 w=1.56u l=0.28u
X2994 VREFP A44_DCTRL_STRIP_W_R2_0/CTRL_OUT[6] A44_CDAC_CAP_BANK_ASSEMBLY_R8_M6_0/A44_CAP_CORE128_M6_R1_0/CAP_BOTTOM_115 VDD pfet_03v3 ad=0 pd=0 as=0 ps=0 w=1.56u l=0.28u
X2995 VREFP A44_DCTRL_STRIP_W_R2_0/CTRL_OUT[6] A44_CDAC_CAP_BANK_ASSEMBLY_R8_M6_0/A44_CAP_CORE128_M6_R1_0/CAP_BOTTOM_115 VDD pfet_03v3 ad=0 pd=0 as=0 ps=0 w=1.56u l=0.28u
X2996 VREFP A44_DCTRL_STRIP_W_R2_0/CTRL_OUT[6] A44_CDAC_CAP_BANK_ASSEMBLY_R8_M6_0/A44_CAP_CORE128_M6_R1_0/CAP_BOTTOM_115 VDD pfet_03v3 ad=0 pd=0 as=0 ps=0 w=1.56u l=0.28u
X2997 VREFP A44_DCTRL_STRIP_W_R2_0/CTRL_OUT[6] A44_CDAC_CAP_BANK_ASSEMBLY_R8_M6_0/A44_CAP_CORE128_M6_R1_0/CAP_BOTTOM_115 VDD pfet_03v3 ad=0 pd=0 as=0 ps=0 w=1.56u l=0.28u
X2998 VREFP A44_DCTRL_STRIP_W_R2_0/CTRL_OUT[6] A44_CDAC_CAP_BANK_ASSEMBLY_R8_M6_0/A44_CAP_CORE128_M6_R1_0/CAP_BOTTOM_115 VDD pfet_03v3 ad=0 pd=0 as=0 ps=0 w=1.56u l=0.28u
X2999 VREFP A44_DCTRL_STRIP_W_R2_0/CTRL_OUT[6] A44_CDAC_CAP_BANK_ASSEMBLY_R8_M6_0/A44_CAP_CORE128_M6_R1_0/CAP_BOTTOM_115 VDD pfet_03v3 ad=0 pd=0 as=0 ps=0 w=1.56u l=0.28u
X3000 VREFP A44_DCTRL_STRIP_W_R2_0/CTRL_OUT[6] A44_CDAC_CAP_BANK_ASSEMBLY_R8_M6_0/A44_CAP_CORE128_M6_R1_0/CAP_BOTTOM_115 VDD pfet_03v3 ad=0 pd=0 as=0 ps=0 w=1.56u l=0.28u
X3001 VREFP A44_DCTRL_STRIP_W_R2_0/CTRL_OUT[6] A44_CDAC_CAP_BANK_ASSEMBLY_R8_M6_0/A44_CAP_CORE128_M6_R1_0/CAP_BOTTOM_115 VDD pfet_03v3 ad=0 pd=0 as=0 ps=0 w=1.56u l=0.28u
X3002 VREFP A44_DCTRL_STRIP_W_R2_0/CTRL_OUT[6] A44_CDAC_CAP_BANK_ASSEMBLY_R8_M6_0/A44_CAP_CORE128_M6_R1_0/CAP_BOTTOM_115 VDD pfet_03v3 ad=0 pd=0 as=0 ps=0 w=1.56u l=0.28u
X3003 VREFP A44_DCTRL_STRIP_W_R2_0/CTRL_OUT[6] A44_CDAC_CAP_BANK_ASSEMBLY_R8_M6_0/A44_CAP_CORE128_M6_R1_0/CAP_BOTTOM_115 VDD pfet_03v3 ad=0 pd=0 as=0 ps=0 w=1.56u l=0.28u
X3004 VREFP A44_DCTRL_STRIP_W_R2_0/CTRL_OUT[6] A44_CDAC_CAP_BANK_ASSEMBLY_R8_M6_0/A44_CAP_CORE128_M6_R1_0/CAP_BOTTOM_115 VDD pfet_03v3 ad=0 pd=0 as=0 ps=0 w=1.56u l=0.28u
X3005 VREFP A44_DCTRL_STRIP_W_R2_0/CTRL_OUT[6] A44_CDAC_CAP_BANK_ASSEMBLY_R8_M6_0/A44_CAP_CORE128_M6_R1_0/CAP_BOTTOM_115 VDD pfet_03v3 ad=0 pd=0 as=0 ps=0 w=1.56u l=0.28u
X3006 VREFP A44_DCTRL_STRIP_W_R2_0/CTRL_OUT[6] A44_CDAC_CAP_BANK_ASSEMBLY_R8_M6_0/A44_CAP_CORE128_M6_R1_0/CAP_BOTTOM_115 VDD pfet_03v3 ad=0 pd=0 as=0 ps=0 w=1.56u l=0.28u
X3007 VREFP A44_DCTRL_STRIP_W_R2_0/CTRL_OUT[6] A44_CDAC_CAP_BANK_ASSEMBLY_R8_M6_0/A44_CAP_CORE128_M6_R1_0/CAP_BOTTOM_115 VDD pfet_03v3 ad=0 pd=0 as=0 ps=0 w=1.56u l=0.28u
X3008 VREFN A44_DCTRL_STRIP_W_R2_0/CTRL_OUT[6] A44_CDAC_CAP_BANK_ASSEMBLY_R8_M6_0/A44_CAP_CORE128_M6_R1_0/CAP_BOTTOM_115 GND nfet_03v3 ad=0 pd=0 as=16.6842p ps=77.76u w=1.56u l=0.28u
X3009 VREFN A44_DCTRL_STRIP_W_R2_0/CTRL_OUT[6] A44_CDAC_CAP_BANK_ASSEMBLY_R8_M6_0/A44_CAP_CORE128_M6_R1_0/CAP_BOTTOM_115 GND nfet_03v3 ad=0 pd=0 as=0 ps=0 w=1.56u l=0.28u
X3010 VREFN A44_DCTRL_STRIP_W_R2_0/CTRL_OUT[6] A44_CDAC_CAP_BANK_ASSEMBLY_R8_M6_0/A44_CAP_CORE128_M6_R1_0/CAP_BOTTOM_115 GND nfet_03v3 ad=0 pd=0 as=0 ps=0 w=1.56u l=0.28u
X3011 VREFN A44_DCTRL_STRIP_W_R2_0/CTRL_OUT[6] A44_CDAC_CAP_BANK_ASSEMBLY_R8_M6_0/A44_CAP_CORE128_M6_R1_0/CAP_BOTTOM_115 GND nfet_03v3 ad=0 pd=0 as=0 ps=0 w=1.56u l=0.28u
X3012 VREFN A44_DCTRL_STRIP_W_R2_0/CTRL_OUT[6] A44_CDAC_CAP_BANK_ASSEMBLY_R8_M6_0/A44_CAP_CORE128_M6_R1_0/CAP_BOTTOM_115 GND nfet_03v3 ad=0 pd=0 as=0 ps=0 w=1.56u l=0.28u
X3013 VREFN A44_DCTRL_STRIP_W_R2_0/CTRL_OUT[6] A44_CDAC_CAP_BANK_ASSEMBLY_R8_M6_0/A44_CAP_CORE128_M6_R1_0/CAP_BOTTOM_115 GND nfet_03v3 ad=0 pd=0 as=0 ps=0 w=1.56u l=0.28u
X3014 VREFN A44_DCTRL_STRIP_W_R2_0/CTRL_OUT[6] A44_CDAC_CAP_BANK_ASSEMBLY_R8_M6_0/A44_CAP_CORE128_M6_R1_0/CAP_BOTTOM_115 GND nfet_03v3 ad=0 pd=0 as=0 ps=0 w=1.56u l=0.28u
X3015 VREFN A44_DCTRL_STRIP_W_R2_0/CTRL_OUT[6] A44_CDAC_CAP_BANK_ASSEMBLY_R8_M6_0/A44_CAP_CORE128_M6_R1_0/CAP_BOTTOM_115 GND nfet_03v3 ad=0 pd=0 as=0 ps=0 w=1.56u l=0.28u
X3016 VREFN A44_DCTRL_STRIP_W_R2_0/CTRL_OUT[6] A44_CDAC_CAP_BANK_ASSEMBLY_R8_M6_0/A44_CAP_CORE128_M6_R1_0/CAP_BOTTOM_115 GND nfet_03v3 ad=0 pd=0 as=0 ps=0 w=1.56u l=0.28u
X3017 VREFN A44_DCTRL_STRIP_W_R2_0/CTRL_OUT[6] A44_CDAC_CAP_BANK_ASSEMBLY_R8_M6_0/A44_CAP_CORE128_M6_R1_0/CAP_BOTTOM_115 GND nfet_03v3 ad=0 pd=0 as=0 ps=0 w=1.56u l=0.28u
X3018 VREFN A44_DCTRL_STRIP_W_R2_0/CTRL_OUT[6] A44_CDAC_CAP_BANK_ASSEMBLY_R8_M6_0/A44_CAP_CORE128_M6_R1_0/CAP_BOTTOM_115 GND nfet_03v3 ad=0 pd=0 as=0 ps=0 w=1.56u l=0.28u
X3019 VREFN A44_DCTRL_STRIP_W_R2_0/CTRL_OUT[6] A44_CDAC_CAP_BANK_ASSEMBLY_R8_M6_0/A44_CAP_CORE128_M6_R1_0/CAP_BOTTOM_115 GND nfet_03v3 ad=0 pd=0 as=0 ps=0 w=1.56u l=0.28u
X3020 VREFN A44_DCTRL_STRIP_W_R2_0/CTRL_OUT[6] A44_CDAC_CAP_BANK_ASSEMBLY_R8_M6_0/A44_CAP_CORE128_M6_R1_0/CAP_BOTTOM_115 GND nfet_03v3 ad=0 pd=0 as=0 ps=0 w=1.56u l=0.28u
X3021 VREFN A44_DCTRL_STRIP_W_R2_0/CTRL_OUT[6] A44_CDAC_CAP_BANK_ASSEMBLY_R8_M6_0/A44_CAP_CORE128_M6_R1_0/CAP_BOTTOM_115 GND nfet_03v3 ad=0 pd=0 as=0 ps=0 w=1.56u l=0.28u
X3022 VREFN A44_DCTRL_STRIP_W_R2_0/CTRL_OUT[6] A44_CDAC_CAP_BANK_ASSEMBLY_R8_M6_0/A44_CAP_CORE128_M6_R1_0/CAP_BOTTOM_115 GND nfet_03v3 ad=0 pd=0 as=0 ps=0 w=1.56u l=0.28u
X3023 VREFN A44_DCTRL_STRIP_W_R2_0/CTRL_OUT[6] A44_CDAC_CAP_BANK_ASSEMBLY_R8_M6_0/A44_CAP_CORE128_M6_R1_0/CAP_BOTTOM_115 GND nfet_03v3 ad=0 pd=0 as=0 ps=0 w=1.56u l=0.28u
X3024 VREFN A44_DCTRL_STRIP_W_R2_0/CTRL_OUT[6] A44_CDAC_CAP_BANK_ASSEMBLY_R8_M6_0/A44_CAP_CORE128_M6_R1_0/CAP_BOTTOM_115 GND nfet_03v3 ad=0 pd=0 as=0 ps=0 w=1.56u l=0.28u
X3025 VREFN A44_DCTRL_STRIP_W_R2_0/CTRL_OUT[6] A44_CDAC_CAP_BANK_ASSEMBLY_R8_M6_0/A44_CAP_CORE128_M6_R1_0/CAP_BOTTOM_115 GND nfet_03v3 ad=0 pd=0 as=0 ps=0 w=1.56u l=0.28u
X3026 VREFP A44_DCTRL_STRIP_W_R2_0/CTRL_OUT[7] A44_CDAC_CAP_BANK_ASSEMBLY_R8_M6_0/A44_CAP_CORE128_M6_R1_0/CAP_BOTTOM_078 VDD pfet_03v3 ad=0 pd=0 as=16.6842p ps=77.76u w=1.56u l=0.28u
X3027 VREFP A44_DCTRL_STRIP_W_R2_0/CTRL_OUT[7] A44_CDAC_CAP_BANK_ASSEMBLY_R8_M6_0/A44_CAP_CORE128_M6_R1_0/CAP_BOTTOM_078 VDD pfet_03v3 ad=0 pd=0 as=0 ps=0 w=1.56u l=0.28u
X3028 VREFP A44_DCTRL_STRIP_W_R2_0/CTRL_OUT[7] A44_CDAC_CAP_BANK_ASSEMBLY_R8_M6_0/A44_CAP_CORE128_M6_R1_0/CAP_BOTTOM_078 VDD pfet_03v3 ad=0 pd=0 as=0 ps=0 w=1.56u l=0.28u
X3029 VREFP A44_DCTRL_STRIP_W_R2_0/CTRL_OUT[7] A44_CDAC_CAP_BANK_ASSEMBLY_R8_M6_0/A44_CAP_CORE128_M6_R1_0/CAP_BOTTOM_078 VDD pfet_03v3 ad=0 pd=0 as=0 ps=0 w=1.56u l=0.28u
X3030 VREFP A44_DCTRL_STRIP_W_R2_0/CTRL_OUT[7] A44_CDAC_CAP_BANK_ASSEMBLY_R8_M6_0/A44_CAP_CORE128_M6_R1_0/CAP_BOTTOM_078 VDD pfet_03v3 ad=0 pd=0 as=0 ps=0 w=1.56u l=0.28u
X3031 VREFP A44_DCTRL_STRIP_W_R2_0/CTRL_OUT[7] A44_CDAC_CAP_BANK_ASSEMBLY_R8_M6_0/A44_CAP_CORE128_M6_R1_0/CAP_BOTTOM_078 VDD pfet_03v3 ad=0 pd=0 as=0 ps=0 w=1.56u l=0.28u
X3032 VREFP A44_DCTRL_STRIP_W_R2_0/CTRL_OUT[7] A44_CDAC_CAP_BANK_ASSEMBLY_R8_M6_0/A44_CAP_CORE128_M6_R1_0/CAP_BOTTOM_078 VDD pfet_03v3 ad=0 pd=0 as=0 ps=0 w=1.56u l=0.28u
X3033 VREFP A44_DCTRL_STRIP_W_R2_0/CTRL_OUT[7] A44_CDAC_CAP_BANK_ASSEMBLY_R8_M6_0/A44_CAP_CORE128_M6_R1_0/CAP_BOTTOM_078 VDD pfet_03v3 ad=0 pd=0 as=0 ps=0 w=1.56u l=0.28u
X3034 VREFP A44_DCTRL_STRIP_W_R2_0/CTRL_OUT[7] A44_CDAC_CAP_BANK_ASSEMBLY_R8_M6_0/A44_CAP_CORE128_M6_R1_0/CAP_BOTTOM_078 VDD pfet_03v3 ad=0 pd=0 as=0 ps=0 w=1.56u l=0.28u
X3035 VREFP A44_DCTRL_STRIP_W_R2_0/CTRL_OUT[7] A44_CDAC_CAP_BANK_ASSEMBLY_R8_M6_0/A44_CAP_CORE128_M6_R1_0/CAP_BOTTOM_078 VDD pfet_03v3 ad=0 pd=0 as=0 ps=0 w=1.56u l=0.28u
X3036 VREFP A44_DCTRL_STRIP_W_R2_0/CTRL_OUT[7] A44_CDAC_CAP_BANK_ASSEMBLY_R8_M6_0/A44_CAP_CORE128_M6_R1_0/CAP_BOTTOM_078 VDD pfet_03v3 ad=0 pd=0 as=0 ps=0 w=1.56u l=0.28u
X3037 VREFP A44_DCTRL_STRIP_W_R2_0/CTRL_OUT[7] A44_CDAC_CAP_BANK_ASSEMBLY_R8_M6_0/A44_CAP_CORE128_M6_R1_0/CAP_BOTTOM_078 VDD pfet_03v3 ad=0 pd=0 as=0 ps=0 w=1.56u l=0.28u
X3038 VREFP A44_DCTRL_STRIP_W_R2_0/CTRL_OUT[7] A44_CDAC_CAP_BANK_ASSEMBLY_R8_M6_0/A44_CAP_CORE128_M6_R1_0/CAP_BOTTOM_078 VDD pfet_03v3 ad=0 pd=0 as=0 ps=0 w=1.56u l=0.28u
X3039 VREFP A44_DCTRL_STRIP_W_R2_0/CTRL_OUT[7] A44_CDAC_CAP_BANK_ASSEMBLY_R8_M6_0/A44_CAP_CORE128_M6_R1_0/CAP_BOTTOM_078 VDD pfet_03v3 ad=0 pd=0 as=0 ps=0 w=1.56u l=0.28u
X3040 VREFP A44_DCTRL_STRIP_W_R2_0/CTRL_OUT[7] A44_CDAC_CAP_BANK_ASSEMBLY_R8_M6_0/A44_CAP_CORE128_M6_R1_0/CAP_BOTTOM_078 VDD pfet_03v3 ad=0 pd=0 as=0 ps=0 w=1.56u l=0.28u
X3041 VREFP A44_DCTRL_STRIP_W_R2_0/CTRL_OUT[7] A44_CDAC_CAP_BANK_ASSEMBLY_R8_M6_0/A44_CAP_CORE128_M6_R1_0/CAP_BOTTOM_078 VDD pfet_03v3 ad=0 pd=0 as=0 ps=0 w=1.56u l=0.28u
X3042 VREFP A44_DCTRL_STRIP_W_R2_0/CTRL_OUT[7] A44_CDAC_CAP_BANK_ASSEMBLY_R8_M6_0/A44_CAP_CORE128_M6_R1_0/CAP_BOTTOM_078 VDD pfet_03v3 ad=0 pd=0 as=0 ps=0 w=1.56u l=0.28u
X3043 VREFP A44_DCTRL_STRIP_W_R2_0/CTRL_OUT[7] A44_CDAC_CAP_BANK_ASSEMBLY_R8_M6_0/A44_CAP_CORE128_M6_R1_0/CAP_BOTTOM_078 VDD pfet_03v3 ad=0 pd=0 as=0 ps=0 w=1.56u l=0.28u
X3044 VREFN A44_DCTRL_STRIP_W_R2_0/CTRL_OUT[7] A44_CDAC_CAP_BANK_ASSEMBLY_R8_M6_0/A44_CAP_CORE128_M6_R1_0/CAP_BOTTOM_078 GND nfet_03v3 ad=0 pd=0 as=16.6842p ps=77.76u w=1.56u l=0.28u
X3045 VREFN A44_DCTRL_STRIP_W_R2_0/CTRL_OUT[7] A44_CDAC_CAP_BANK_ASSEMBLY_R8_M6_0/A44_CAP_CORE128_M6_R1_0/CAP_BOTTOM_078 GND nfet_03v3 ad=0 pd=0 as=0 ps=0 w=1.56u l=0.28u
X3046 VREFN A44_DCTRL_STRIP_W_R2_0/CTRL_OUT[7] A44_CDAC_CAP_BANK_ASSEMBLY_R8_M6_0/A44_CAP_CORE128_M6_R1_0/CAP_BOTTOM_078 GND nfet_03v3 ad=0 pd=0 as=0 ps=0 w=1.56u l=0.28u
X3047 VREFN A44_DCTRL_STRIP_W_R2_0/CTRL_OUT[7] A44_CDAC_CAP_BANK_ASSEMBLY_R8_M6_0/A44_CAP_CORE128_M6_R1_0/CAP_BOTTOM_078 GND nfet_03v3 ad=0 pd=0 as=0 ps=0 w=1.56u l=0.28u
X3048 VREFN A44_DCTRL_STRIP_W_R2_0/CTRL_OUT[7] A44_CDAC_CAP_BANK_ASSEMBLY_R8_M6_0/A44_CAP_CORE128_M6_R1_0/CAP_BOTTOM_078 GND nfet_03v3 ad=0 pd=0 as=0 ps=0 w=1.56u l=0.28u
X3049 VREFN A44_DCTRL_STRIP_W_R2_0/CTRL_OUT[7] A44_CDAC_CAP_BANK_ASSEMBLY_R8_M6_0/A44_CAP_CORE128_M6_R1_0/CAP_BOTTOM_078 GND nfet_03v3 ad=0 pd=0 as=0 ps=0 w=1.56u l=0.28u
X3050 VREFN A44_DCTRL_STRIP_W_R2_0/CTRL_OUT[7] A44_CDAC_CAP_BANK_ASSEMBLY_R8_M6_0/A44_CAP_CORE128_M6_R1_0/CAP_BOTTOM_078 GND nfet_03v3 ad=0 pd=0 as=0 ps=0 w=1.56u l=0.28u
X3051 VREFN A44_DCTRL_STRIP_W_R2_0/CTRL_OUT[7] A44_CDAC_CAP_BANK_ASSEMBLY_R8_M6_0/A44_CAP_CORE128_M6_R1_0/CAP_BOTTOM_078 GND nfet_03v3 ad=0 pd=0 as=0 ps=0 w=1.56u l=0.28u
X3052 VREFN A44_DCTRL_STRIP_W_R2_0/CTRL_OUT[7] A44_CDAC_CAP_BANK_ASSEMBLY_R8_M6_0/A44_CAP_CORE128_M6_R1_0/CAP_BOTTOM_078 GND nfet_03v3 ad=0 pd=0 as=0 ps=0 w=1.56u l=0.28u
X3053 VREFN A44_DCTRL_STRIP_W_R2_0/CTRL_OUT[7] A44_CDAC_CAP_BANK_ASSEMBLY_R8_M6_0/A44_CAP_CORE128_M6_R1_0/CAP_BOTTOM_078 GND nfet_03v3 ad=0 pd=0 as=0 ps=0 w=1.56u l=0.28u
X3054 VREFN A44_DCTRL_STRIP_W_R2_0/CTRL_OUT[7] A44_CDAC_CAP_BANK_ASSEMBLY_R8_M6_0/A44_CAP_CORE128_M6_R1_0/CAP_BOTTOM_078 GND nfet_03v3 ad=0 pd=0 as=0 ps=0 w=1.56u l=0.28u
X3055 VREFN A44_DCTRL_STRIP_W_R2_0/CTRL_OUT[7] A44_CDAC_CAP_BANK_ASSEMBLY_R8_M6_0/A44_CAP_CORE128_M6_R1_0/CAP_BOTTOM_078 GND nfet_03v3 ad=0 pd=0 as=0 ps=0 w=1.56u l=0.28u
X3056 VREFN A44_DCTRL_STRIP_W_R2_0/CTRL_OUT[7] A44_CDAC_CAP_BANK_ASSEMBLY_R8_M6_0/A44_CAP_CORE128_M6_R1_0/CAP_BOTTOM_078 GND nfet_03v3 ad=0 pd=0 as=0 ps=0 w=1.56u l=0.28u
X3057 VREFN A44_DCTRL_STRIP_W_R2_0/CTRL_OUT[7] A44_CDAC_CAP_BANK_ASSEMBLY_R8_M6_0/A44_CAP_CORE128_M6_R1_0/CAP_BOTTOM_078 GND nfet_03v3 ad=0 pd=0 as=0 ps=0 w=1.56u l=0.28u
X3058 VREFN A44_DCTRL_STRIP_W_R2_0/CTRL_OUT[7] A44_CDAC_CAP_BANK_ASSEMBLY_R8_M6_0/A44_CAP_CORE128_M6_R1_0/CAP_BOTTOM_078 GND nfet_03v3 ad=0 pd=0 as=0 ps=0 w=1.56u l=0.28u
X3059 VREFN A44_DCTRL_STRIP_W_R2_0/CTRL_OUT[7] A44_CDAC_CAP_BANK_ASSEMBLY_R8_M6_0/A44_CAP_CORE128_M6_R1_0/CAP_BOTTOM_078 GND nfet_03v3 ad=0 pd=0 as=0 ps=0 w=1.56u l=0.28u
X3060 VREFN A44_DCTRL_STRIP_W_R2_0/CTRL_OUT[7] A44_CDAC_CAP_BANK_ASSEMBLY_R8_M6_0/A44_CAP_CORE128_M6_R1_0/CAP_BOTTOM_078 GND nfet_03v3 ad=0 pd=0 as=0 ps=0 w=1.56u l=0.28u
X3061 VREFN A44_DCTRL_STRIP_W_R2_0/CTRL_OUT[7] A44_CDAC_CAP_BANK_ASSEMBLY_R8_M6_0/A44_CAP_CORE128_M6_R1_0/CAP_BOTTOM_078 GND nfet_03v3 ad=0 pd=0 as=0 ps=0 w=1.56u l=0.28u
X3062 VREFP A44_DCTRL_STRIP_W_R2_0/CTRL_OUT[7] A44_CDAC_CAP_BANK_ASSEMBLY_R8_M6_0/A44_CAP_CORE128_M6_R1_0/CAP_BOTTOM_105 VDD pfet_03v3 ad=0 pd=0 as=16.6842p ps=77.76u w=1.56u l=0.28u
X3063 VREFP A44_DCTRL_STRIP_W_R2_0/CTRL_OUT[7] A44_CDAC_CAP_BANK_ASSEMBLY_R8_M6_0/A44_CAP_CORE128_M6_R1_0/CAP_BOTTOM_105 VDD pfet_03v3 ad=0 pd=0 as=0 ps=0 w=1.56u l=0.28u
X3064 VREFP A44_DCTRL_STRIP_W_R2_0/CTRL_OUT[7] A44_CDAC_CAP_BANK_ASSEMBLY_R8_M6_0/A44_CAP_CORE128_M6_R1_0/CAP_BOTTOM_105 VDD pfet_03v3 ad=0 pd=0 as=0 ps=0 w=1.56u l=0.28u
X3065 VREFP A44_DCTRL_STRIP_W_R2_0/CTRL_OUT[7] A44_CDAC_CAP_BANK_ASSEMBLY_R8_M6_0/A44_CAP_CORE128_M6_R1_0/CAP_BOTTOM_105 VDD pfet_03v3 ad=0 pd=0 as=0 ps=0 w=1.56u l=0.28u
X3066 VREFP A44_DCTRL_STRIP_W_R2_0/CTRL_OUT[7] A44_CDAC_CAP_BANK_ASSEMBLY_R8_M6_0/A44_CAP_CORE128_M6_R1_0/CAP_BOTTOM_105 VDD pfet_03v3 ad=0 pd=0 as=0 ps=0 w=1.56u l=0.28u
X3067 VREFP A44_DCTRL_STRIP_W_R2_0/CTRL_OUT[7] A44_CDAC_CAP_BANK_ASSEMBLY_R8_M6_0/A44_CAP_CORE128_M6_R1_0/CAP_BOTTOM_105 VDD pfet_03v3 ad=0 pd=0 as=0 ps=0 w=1.56u l=0.28u
X3068 VREFP A44_DCTRL_STRIP_W_R2_0/CTRL_OUT[7] A44_CDAC_CAP_BANK_ASSEMBLY_R8_M6_0/A44_CAP_CORE128_M6_R1_0/CAP_BOTTOM_105 VDD pfet_03v3 ad=0 pd=0 as=0 ps=0 w=1.56u l=0.28u
X3069 VREFP A44_DCTRL_STRIP_W_R2_0/CTRL_OUT[7] A44_CDAC_CAP_BANK_ASSEMBLY_R8_M6_0/A44_CAP_CORE128_M6_R1_0/CAP_BOTTOM_105 VDD pfet_03v3 ad=0 pd=0 as=0 ps=0 w=1.56u l=0.28u
X3070 VREFP A44_DCTRL_STRIP_W_R2_0/CTRL_OUT[7] A44_CDAC_CAP_BANK_ASSEMBLY_R8_M6_0/A44_CAP_CORE128_M6_R1_0/CAP_BOTTOM_105 VDD pfet_03v3 ad=0 pd=0 as=0 ps=0 w=1.56u l=0.28u
X3071 VREFP A44_DCTRL_STRIP_W_R2_0/CTRL_OUT[7] A44_CDAC_CAP_BANK_ASSEMBLY_R8_M6_0/A44_CAP_CORE128_M6_R1_0/CAP_BOTTOM_105 VDD pfet_03v3 ad=0 pd=0 as=0 ps=0 w=1.56u l=0.28u
X3072 VREFP A44_DCTRL_STRIP_W_R2_0/CTRL_OUT[7] A44_CDAC_CAP_BANK_ASSEMBLY_R8_M6_0/A44_CAP_CORE128_M6_R1_0/CAP_BOTTOM_105 VDD pfet_03v3 ad=0 pd=0 as=0 ps=0 w=1.56u l=0.28u
X3073 VREFP A44_DCTRL_STRIP_W_R2_0/CTRL_OUT[7] A44_CDAC_CAP_BANK_ASSEMBLY_R8_M6_0/A44_CAP_CORE128_M6_R1_0/CAP_BOTTOM_105 VDD pfet_03v3 ad=0 pd=0 as=0 ps=0 w=1.56u l=0.28u
X3074 VREFP A44_DCTRL_STRIP_W_R2_0/CTRL_OUT[7] A44_CDAC_CAP_BANK_ASSEMBLY_R8_M6_0/A44_CAP_CORE128_M6_R1_0/CAP_BOTTOM_105 VDD pfet_03v3 ad=0 pd=0 as=0 ps=0 w=1.56u l=0.28u
X3075 VREFP A44_DCTRL_STRIP_W_R2_0/CTRL_OUT[7] A44_CDAC_CAP_BANK_ASSEMBLY_R8_M6_0/A44_CAP_CORE128_M6_R1_0/CAP_BOTTOM_105 VDD pfet_03v3 ad=0 pd=0 as=0 ps=0 w=1.56u l=0.28u
X3076 VREFP A44_DCTRL_STRIP_W_R2_0/CTRL_OUT[7] A44_CDAC_CAP_BANK_ASSEMBLY_R8_M6_0/A44_CAP_CORE128_M6_R1_0/CAP_BOTTOM_105 VDD pfet_03v3 ad=0 pd=0 as=0 ps=0 w=1.56u l=0.28u
X3077 VREFP A44_DCTRL_STRIP_W_R2_0/CTRL_OUT[7] A44_CDAC_CAP_BANK_ASSEMBLY_R8_M6_0/A44_CAP_CORE128_M6_R1_0/CAP_BOTTOM_105 VDD pfet_03v3 ad=0 pd=0 as=0 ps=0 w=1.56u l=0.28u
X3078 VREFP A44_DCTRL_STRIP_W_R2_0/CTRL_OUT[7] A44_CDAC_CAP_BANK_ASSEMBLY_R8_M6_0/A44_CAP_CORE128_M6_R1_0/CAP_BOTTOM_105 VDD pfet_03v3 ad=0 pd=0 as=0 ps=0 w=1.56u l=0.28u
X3079 VREFP A44_DCTRL_STRIP_W_R2_0/CTRL_OUT[7] A44_CDAC_CAP_BANK_ASSEMBLY_R8_M6_0/A44_CAP_CORE128_M6_R1_0/CAP_BOTTOM_105 VDD pfet_03v3 ad=0 pd=0 as=0 ps=0 w=1.56u l=0.28u
X3080 VREFN A44_DCTRL_STRIP_W_R2_0/CTRL_OUT[7] A44_CDAC_CAP_BANK_ASSEMBLY_R8_M6_0/A44_CAP_CORE128_M6_R1_0/CAP_BOTTOM_105 GND nfet_03v3 ad=0 pd=0 as=16.6842p ps=77.76u w=1.56u l=0.28u
X3081 VREFN A44_DCTRL_STRIP_W_R2_0/CTRL_OUT[7] A44_CDAC_CAP_BANK_ASSEMBLY_R8_M6_0/A44_CAP_CORE128_M6_R1_0/CAP_BOTTOM_105 GND nfet_03v3 ad=0 pd=0 as=0 ps=0 w=1.56u l=0.28u
X3082 VREFN A44_DCTRL_STRIP_W_R2_0/CTRL_OUT[7] A44_CDAC_CAP_BANK_ASSEMBLY_R8_M6_0/A44_CAP_CORE128_M6_R1_0/CAP_BOTTOM_105 GND nfet_03v3 ad=0 pd=0 as=0 ps=0 w=1.56u l=0.28u
X3083 VREFN A44_DCTRL_STRIP_W_R2_0/CTRL_OUT[7] A44_CDAC_CAP_BANK_ASSEMBLY_R8_M6_0/A44_CAP_CORE128_M6_R1_0/CAP_BOTTOM_105 GND nfet_03v3 ad=0 pd=0 as=0 ps=0 w=1.56u l=0.28u
X3084 VREFN A44_DCTRL_STRIP_W_R2_0/CTRL_OUT[7] A44_CDAC_CAP_BANK_ASSEMBLY_R8_M6_0/A44_CAP_CORE128_M6_R1_0/CAP_BOTTOM_105 GND nfet_03v3 ad=0 pd=0 as=0 ps=0 w=1.56u l=0.28u
X3085 VREFN A44_DCTRL_STRIP_W_R2_0/CTRL_OUT[7] A44_CDAC_CAP_BANK_ASSEMBLY_R8_M6_0/A44_CAP_CORE128_M6_R1_0/CAP_BOTTOM_105 GND nfet_03v3 ad=0 pd=0 as=0 ps=0 w=1.56u l=0.28u
X3086 VREFN A44_DCTRL_STRIP_W_R2_0/CTRL_OUT[7] A44_CDAC_CAP_BANK_ASSEMBLY_R8_M6_0/A44_CAP_CORE128_M6_R1_0/CAP_BOTTOM_105 GND nfet_03v3 ad=0 pd=0 as=0 ps=0 w=1.56u l=0.28u
X3087 VREFN A44_DCTRL_STRIP_W_R2_0/CTRL_OUT[7] A44_CDAC_CAP_BANK_ASSEMBLY_R8_M6_0/A44_CAP_CORE128_M6_R1_0/CAP_BOTTOM_105 GND nfet_03v3 ad=0 pd=0 as=0 ps=0 w=1.56u l=0.28u
X3088 VREFN A44_DCTRL_STRIP_W_R2_0/CTRL_OUT[7] A44_CDAC_CAP_BANK_ASSEMBLY_R8_M6_0/A44_CAP_CORE128_M6_R1_0/CAP_BOTTOM_105 GND nfet_03v3 ad=0 pd=0 as=0 ps=0 w=1.56u l=0.28u
X3089 VREFN A44_DCTRL_STRIP_W_R2_0/CTRL_OUT[7] A44_CDAC_CAP_BANK_ASSEMBLY_R8_M6_0/A44_CAP_CORE128_M6_R1_0/CAP_BOTTOM_105 GND nfet_03v3 ad=0 pd=0 as=0 ps=0 w=1.56u l=0.28u
X3090 VREFN A44_DCTRL_STRIP_W_R2_0/CTRL_OUT[7] A44_CDAC_CAP_BANK_ASSEMBLY_R8_M6_0/A44_CAP_CORE128_M6_R1_0/CAP_BOTTOM_105 GND nfet_03v3 ad=0 pd=0 as=0 ps=0 w=1.56u l=0.28u
X3091 VREFN A44_DCTRL_STRIP_W_R2_0/CTRL_OUT[7] A44_CDAC_CAP_BANK_ASSEMBLY_R8_M6_0/A44_CAP_CORE128_M6_R1_0/CAP_BOTTOM_105 GND nfet_03v3 ad=0 pd=0 as=0 ps=0 w=1.56u l=0.28u
X3092 VREFN A44_DCTRL_STRIP_W_R2_0/CTRL_OUT[7] A44_CDAC_CAP_BANK_ASSEMBLY_R8_M6_0/A44_CAP_CORE128_M6_R1_0/CAP_BOTTOM_105 GND nfet_03v3 ad=0 pd=0 as=0 ps=0 w=1.56u l=0.28u
X3093 VREFN A44_DCTRL_STRIP_W_R2_0/CTRL_OUT[7] A44_CDAC_CAP_BANK_ASSEMBLY_R8_M6_0/A44_CAP_CORE128_M6_R1_0/CAP_BOTTOM_105 GND nfet_03v3 ad=0 pd=0 as=0 ps=0 w=1.56u l=0.28u
X3094 VREFN A44_DCTRL_STRIP_W_R2_0/CTRL_OUT[7] A44_CDAC_CAP_BANK_ASSEMBLY_R8_M6_0/A44_CAP_CORE128_M6_R1_0/CAP_BOTTOM_105 GND nfet_03v3 ad=0 pd=0 as=0 ps=0 w=1.56u l=0.28u
X3095 VREFN A44_DCTRL_STRIP_W_R2_0/CTRL_OUT[7] A44_CDAC_CAP_BANK_ASSEMBLY_R8_M6_0/A44_CAP_CORE128_M6_R1_0/CAP_BOTTOM_105 GND nfet_03v3 ad=0 pd=0 as=0 ps=0 w=1.56u l=0.28u
X3096 VREFN A44_DCTRL_STRIP_W_R2_0/CTRL_OUT[7] A44_CDAC_CAP_BANK_ASSEMBLY_R8_M6_0/A44_CAP_CORE128_M6_R1_0/CAP_BOTTOM_105 GND nfet_03v3 ad=0 pd=0 as=0 ps=0 w=1.56u l=0.28u
X3097 VREFN A44_DCTRL_STRIP_W_R2_0/CTRL_OUT[7] A44_CDAC_CAP_BANK_ASSEMBLY_R8_M6_0/A44_CAP_CORE128_M6_R1_0/CAP_BOTTOM_105 GND nfet_03v3 ad=0 pd=0 as=0 ps=0 w=1.56u l=0.28u
X3098 VREFP A44_DCTRL_STRIP_W_R2_0/CTRL_OUT[6] A44_CDAC_CAP_BANK_ASSEMBLY_R8_M6_0/A44_CAP_CORE128_M6_R1_0/CAP_BOTTOM_102 VDD pfet_03v3 ad=0 pd=0 as=16.6842p ps=77.76u w=1.56u l=0.28u
X3099 VREFP A44_DCTRL_STRIP_W_R2_0/CTRL_OUT[6] A44_CDAC_CAP_BANK_ASSEMBLY_R8_M6_0/A44_CAP_CORE128_M6_R1_0/CAP_BOTTOM_102 VDD pfet_03v3 ad=0 pd=0 as=0 ps=0 w=1.56u l=0.28u
X3100 VREFP A44_DCTRL_STRIP_W_R2_0/CTRL_OUT[6] A44_CDAC_CAP_BANK_ASSEMBLY_R8_M6_0/A44_CAP_CORE128_M6_R1_0/CAP_BOTTOM_102 VDD pfet_03v3 ad=0 pd=0 as=0 ps=0 w=1.56u l=0.28u
X3101 VREFP A44_DCTRL_STRIP_W_R2_0/CTRL_OUT[6] A44_CDAC_CAP_BANK_ASSEMBLY_R8_M6_0/A44_CAP_CORE128_M6_R1_0/CAP_BOTTOM_102 VDD pfet_03v3 ad=0 pd=0 as=0 ps=0 w=1.56u l=0.28u
X3102 VREFP A44_DCTRL_STRIP_W_R2_0/CTRL_OUT[6] A44_CDAC_CAP_BANK_ASSEMBLY_R8_M6_0/A44_CAP_CORE128_M6_R1_0/CAP_BOTTOM_102 VDD pfet_03v3 ad=0 pd=0 as=0 ps=0 w=1.56u l=0.28u
X3103 VREFP A44_DCTRL_STRIP_W_R2_0/CTRL_OUT[6] A44_CDAC_CAP_BANK_ASSEMBLY_R8_M6_0/A44_CAP_CORE128_M6_R1_0/CAP_BOTTOM_102 VDD pfet_03v3 ad=0 pd=0 as=0 ps=0 w=1.56u l=0.28u
X3104 VREFP A44_DCTRL_STRIP_W_R2_0/CTRL_OUT[6] A44_CDAC_CAP_BANK_ASSEMBLY_R8_M6_0/A44_CAP_CORE128_M6_R1_0/CAP_BOTTOM_102 VDD pfet_03v3 ad=0 pd=0 as=0 ps=0 w=1.56u l=0.28u
X3105 VREFP A44_DCTRL_STRIP_W_R2_0/CTRL_OUT[6] A44_CDAC_CAP_BANK_ASSEMBLY_R8_M6_0/A44_CAP_CORE128_M6_R1_0/CAP_BOTTOM_102 VDD pfet_03v3 ad=0 pd=0 as=0 ps=0 w=1.56u l=0.28u
X3106 VREFP A44_DCTRL_STRIP_W_R2_0/CTRL_OUT[6] A44_CDAC_CAP_BANK_ASSEMBLY_R8_M6_0/A44_CAP_CORE128_M6_R1_0/CAP_BOTTOM_102 VDD pfet_03v3 ad=0 pd=0 as=0 ps=0 w=1.56u l=0.28u
X3107 VREFP A44_DCTRL_STRIP_W_R2_0/CTRL_OUT[6] A44_CDAC_CAP_BANK_ASSEMBLY_R8_M6_0/A44_CAP_CORE128_M6_R1_0/CAP_BOTTOM_102 VDD pfet_03v3 ad=0 pd=0 as=0 ps=0 w=1.56u l=0.28u
X3108 VREFP A44_DCTRL_STRIP_W_R2_0/CTRL_OUT[6] A44_CDAC_CAP_BANK_ASSEMBLY_R8_M6_0/A44_CAP_CORE128_M6_R1_0/CAP_BOTTOM_102 VDD pfet_03v3 ad=0 pd=0 as=0 ps=0 w=1.56u l=0.28u
X3109 VREFP A44_DCTRL_STRIP_W_R2_0/CTRL_OUT[6] A44_CDAC_CAP_BANK_ASSEMBLY_R8_M6_0/A44_CAP_CORE128_M6_R1_0/CAP_BOTTOM_102 VDD pfet_03v3 ad=0 pd=0 as=0 ps=0 w=1.56u l=0.28u
X3110 VREFP A44_DCTRL_STRIP_W_R2_0/CTRL_OUT[6] A44_CDAC_CAP_BANK_ASSEMBLY_R8_M6_0/A44_CAP_CORE128_M6_R1_0/CAP_BOTTOM_102 VDD pfet_03v3 ad=0 pd=0 as=0 ps=0 w=1.56u l=0.28u
X3111 VREFP A44_DCTRL_STRIP_W_R2_0/CTRL_OUT[6] A44_CDAC_CAP_BANK_ASSEMBLY_R8_M6_0/A44_CAP_CORE128_M6_R1_0/CAP_BOTTOM_102 VDD pfet_03v3 ad=0 pd=0 as=0 ps=0 w=1.56u l=0.28u
X3112 VREFP A44_DCTRL_STRIP_W_R2_0/CTRL_OUT[6] A44_CDAC_CAP_BANK_ASSEMBLY_R8_M6_0/A44_CAP_CORE128_M6_R1_0/CAP_BOTTOM_102 VDD pfet_03v3 ad=0 pd=0 as=0 ps=0 w=1.56u l=0.28u
X3113 VREFP A44_DCTRL_STRIP_W_R2_0/CTRL_OUT[6] A44_CDAC_CAP_BANK_ASSEMBLY_R8_M6_0/A44_CAP_CORE128_M6_R1_0/CAP_BOTTOM_102 VDD pfet_03v3 ad=0 pd=0 as=0 ps=0 w=1.56u l=0.28u
X3114 VREFP A44_DCTRL_STRIP_W_R2_0/CTRL_OUT[6] A44_CDAC_CAP_BANK_ASSEMBLY_R8_M6_0/A44_CAP_CORE128_M6_R1_0/CAP_BOTTOM_102 VDD pfet_03v3 ad=0 pd=0 as=0 ps=0 w=1.56u l=0.28u
X3115 VREFP A44_DCTRL_STRIP_W_R2_0/CTRL_OUT[6] A44_CDAC_CAP_BANK_ASSEMBLY_R8_M6_0/A44_CAP_CORE128_M6_R1_0/CAP_BOTTOM_102 VDD pfet_03v3 ad=0 pd=0 as=0 ps=0 w=1.56u l=0.28u
X3116 VREFN A44_DCTRL_STRIP_W_R2_0/CTRL_OUT[6] A44_CDAC_CAP_BANK_ASSEMBLY_R8_M6_0/A44_CAP_CORE128_M6_R1_0/CAP_BOTTOM_102 GND nfet_03v3 ad=0 pd=0 as=16.6842p ps=77.76u w=1.56u l=0.28u
X3117 VREFN A44_DCTRL_STRIP_W_R2_0/CTRL_OUT[6] A44_CDAC_CAP_BANK_ASSEMBLY_R8_M6_0/A44_CAP_CORE128_M6_R1_0/CAP_BOTTOM_102 GND nfet_03v3 ad=0 pd=0 as=0 ps=0 w=1.56u l=0.28u
X3118 VREFN A44_DCTRL_STRIP_W_R2_0/CTRL_OUT[6] A44_CDAC_CAP_BANK_ASSEMBLY_R8_M6_0/A44_CAP_CORE128_M6_R1_0/CAP_BOTTOM_102 GND nfet_03v3 ad=0 pd=0 as=0 ps=0 w=1.56u l=0.28u
X3119 VREFN A44_DCTRL_STRIP_W_R2_0/CTRL_OUT[6] A44_CDAC_CAP_BANK_ASSEMBLY_R8_M6_0/A44_CAP_CORE128_M6_R1_0/CAP_BOTTOM_102 GND nfet_03v3 ad=0 pd=0 as=0 ps=0 w=1.56u l=0.28u
X3120 VREFN A44_DCTRL_STRIP_W_R2_0/CTRL_OUT[6] A44_CDAC_CAP_BANK_ASSEMBLY_R8_M6_0/A44_CAP_CORE128_M6_R1_0/CAP_BOTTOM_102 GND nfet_03v3 ad=0 pd=0 as=0 ps=0 w=1.56u l=0.28u
X3121 VREFN A44_DCTRL_STRIP_W_R2_0/CTRL_OUT[6] A44_CDAC_CAP_BANK_ASSEMBLY_R8_M6_0/A44_CAP_CORE128_M6_R1_0/CAP_BOTTOM_102 GND nfet_03v3 ad=0 pd=0 as=0 ps=0 w=1.56u l=0.28u
X3122 VREFN A44_DCTRL_STRIP_W_R2_0/CTRL_OUT[6] A44_CDAC_CAP_BANK_ASSEMBLY_R8_M6_0/A44_CAP_CORE128_M6_R1_0/CAP_BOTTOM_102 GND nfet_03v3 ad=0 pd=0 as=0 ps=0 w=1.56u l=0.28u
X3123 VREFN A44_DCTRL_STRIP_W_R2_0/CTRL_OUT[6] A44_CDAC_CAP_BANK_ASSEMBLY_R8_M6_0/A44_CAP_CORE128_M6_R1_0/CAP_BOTTOM_102 GND nfet_03v3 ad=0 pd=0 as=0 ps=0 w=1.56u l=0.28u
X3124 VREFN A44_DCTRL_STRIP_W_R2_0/CTRL_OUT[6] A44_CDAC_CAP_BANK_ASSEMBLY_R8_M6_0/A44_CAP_CORE128_M6_R1_0/CAP_BOTTOM_102 GND nfet_03v3 ad=0 pd=0 as=0 ps=0 w=1.56u l=0.28u
X3125 VREFN A44_DCTRL_STRIP_W_R2_0/CTRL_OUT[6] A44_CDAC_CAP_BANK_ASSEMBLY_R8_M6_0/A44_CAP_CORE128_M6_R1_0/CAP_BOTTOM_102 GND nfet_03v3 ad=0 pd=0 as=0 ps=0 w=1.56u l=0.28u
X3126 VREFN A44_DCTRL_STRIP_W_R2_0/CTRL_OUT[6] A44_CDAC_CAP_BANK_ASSEMBLY_R8_M6_0/A44_CAP_CORE128_M6_R1_0/CAP_BOTTOM_102 GND nfet_03v3 ad=0 pd=0 as=0 ps=0 w=1.56u l=0.28u
X3127 VREFN A44_DCTRL_STRIP_W_R2_0/CTRL_OUT[6] A44_CDAC_CAP_BANK_ASSEMBLY_R8_M6_0/A44_CAP_CORE128_M6_R1_0/CAP_BOTTOM_102 GND nfet_03v3 ad=0 pd=0 as=0 ps=0 w=1.56u l=0.28u
X3128 VREFN A44_DCTRL_STRIP_W_R2_0/CTRL_OUT[6] A44_CDAC_CAP_BANK_ASSEMBLY_R8_M6_0/A44_CAP_CORE128_M6_R1_0/CAP_BOTTOM_102 GND nfet_03v3 ad=0 pd=0 as=0 ps=0 w=1.56u l=0.28u
X3129 VREFN A44_DCTRL_STRIP_W_R2_0/CTRL_OUT[6] A44_CDAC_CAP_BANK_ASSEMBLY_R8_M6_0/A44_CAP_CORE128_M6_R1_0/CAP_BOTTOM_102 GND nfet_03v3 ad=0 pd=0 as=0 ps=0 w=1.56u l=0.28u
X3130 VREFN A44_DCTRL_STRIP_W_R2_0/CTRL_OUT[6] A44_CDAC_CAP_BANK_ASSEMBLY_R8_M6_0/A44_CAP_CORE128_M6_R1_0/CAP_BOTTOM_102 GND nfet_03v3 ad=0 pd=0 as=0 ps=0 w=1.56u l=0.28u
X3131 VREFN A44_DCTRL_STRIP_W_R2_0/CTRL_OUT[6] A44_CDAC_CAP_BANK_ASSEMBLY_R8_M6_0/A44_CAP_CORE128_M6_R1_0/CAP_BOTTOM_102 GND nfet_03v3 ad=0 pd=0 as=0 ps=0 w=1.56u l=0.28u
X3132 VREFN A44_DCTRL_STRIP_W_R2_0/CTRL_OUT[6] A44_CDAC_CAP_BANK_ASSEMBLY_R8_M6_0/A44_CAP_CORE128_M6_R1_0/CAP_BOTTOM_102 GND nfet_03v3 ad=0 pd=0 as=0 ps=0 w=1.56u l=0.28u
X3133 VREFN A44_DCTRL_STRIP_W_R2_0/CTRL_OUT[6] A44_CDAC_CAP_BANK_ASSEMBLY_R8_M6_0/A44_CAP_CORE128_M6_R1_0/CAP_BOTTOM_102 GND nfet_03v3 ad=0 pd=0 as=0 ps=0 w=1.56u l=0.28u
X3134 VREFP A44_DCTRL_STRIP_W_R2_0/CTRL_OUT[6] A44_CDAC_CAP_BANK_ASSEMBLY_R8_M6_0/A44_CAP_CORE128_M6_R1_0/CAP_BOTTOM_066 VDD pfet_03v3 ad=0 pd=0 as=16.6842p ps=77.76u w=1.56u l=0.28u
X3135 VREFP A44_DCTRL_STRIP_W_R2_0/CTRL_OUT[6] A44_CDAC_CAP_BANK_ASSEMBLY_R8_M6_0/A44_CAP_CORE128_M6_R1_0/CAP_BOTTOM_066 VDD pfet_03v3 ad=0 pd=0 as=0 ps=0 w=1.56u l=0.28u
X3136 VREFP A44_DCTRL_STRIP_W_R2_0/CTRL_OUT[6] A44_CDAC_CAP_BANK_ASSEMBLY_R8_M6_0/A44_CAP_CORE128_M6_R1_0/CAP_BOTTOM_066 VDD pfet_03v3 ad=0 pd=0 as=0 ps=0 w=1.56u l=0.28u
X3137 VREFP A44_DCTRL_STRIP_W_R2_0/CTRL_OUT[6] A44_CDAC_CAP_BANK_ASSEMBLY_R8_M6_0/A44_CAP_CORE128_M6_R1_0/CAP_BOTTOM_066 VDD pfet_03v3 ad=0 pd=0 as=0 ps=0 w=1.56u l=0.28u
X3138 VREFP A44_DCTRL_STRIP_W_R2_0/CTRL_OUT[6] A44_CDAC_CAP_BANK_ASSEMBLY_R8_M6_0/A44_CAP_CORE128_M6_R1_0/CAP_BOTTOM_066 VDD pfet_03v3 ad=0 pd=0 as=0 ps=0 w=1.56u l=0.28u
X3139 VREFP A44_DCTRL_STRIP_W_R2_0/CTRL_OUT[6] A44_CDAC_CAP_BANK_ASSEMBLY_R8_M6_0/A44_CAP_CORE128_M6_R1_0/CAP_BOTTOM_066 VDD pfet_03v3 ad=0 pd=0 as=0 ps=0 w=1.56u l=0.28u
X3140 VREFP A44_DCTRL_STRIP_W_R2_0/CTRL_OUT[6] A44_CDAC_CAP_BANK_ASSEMBLY_R8_M6_0/A44_CAP_CORE128_M6_R1_0/CAP_BOTTOM_066 VDD pfet_03v3 ad=0 pd=0 as=0 ps=0 w=1.56u l=0.28u
X3141 VREFP A44_DCTRL_STRIP_W_R2_0/CTRL_OUT[6] A44_CDAC_CAP_BANK_ASSEMBLY_R8_M6_0/A44_CAP_CORE128_M6_R1_0/CAP_BOTTOM_066 VDD pfet_03v3 ad=0 pd=0 as=0 ps=0 w=1.56u l=0.28u
X3142 VREFP A44_DCTRL_STRIP_W_R2_0/CTRL_OUT[6] A44_CDAC_CAP_BANK_ASSEMBLY_R8_M6_0/A44_CAP_CORE128_M6_R1_0/CAP_BOTTOM_066 VDD pfet_03v3 ad=0 pd=0 as=0 ps=0 w=1.56u l=0.28u
X3143 VREFP A44_DCTRL_STRIP_W_R2_0/CTRL_OUT[6] A44_CDAC_CAP_BANK_ASSEMBLY_R8_M6_0/A44_CAP_CORE128_M6_R1_0/CAP_BOTTOM_066 VDD pfet_03v3 ad=0 pd=0 as=0 ps=0 w=1.56u l=0.28u
X3144 VREFP A44_DCTRL_STRIP_W_R2_0/CTRL_OUT[6] A44_CDAC_CAP_BANK_ASSEMBLY_R8_M6_0/A44_CAP_CORE128_M6_R1_0/CAP_BOTTOM_066 VDD pfet_03v3 ad=0 pd=0 as=0 ps=0 w=1.56u l=0.28u
X3145 VREFP A44_DCTRL_STRIP_W_R2_0/CTRL_OUT[6] A44_CDAC_CAP_BANK_ASSEMBLY_R8_M6_0/A44_CAP_CORE128_M6_R1_0/CAP_BOTTOM_066 VDD pfet_03v3 ad=0 pd=0 as=0 ps=0 w=1.56u l=0.28u
X3146 VREFP A44_DCTRL_STRIP_W_R2_0/CTRL_OUT[6] A44_CDAC_CAP_BANK_ASSEMBLY_R8_M6_0/A44_CAP_CORE128_M6_R1_0/CAP_BOTTOM_066 VDD pfet_03v3 ad=0 pd=0 as=0 ps=0 w=1.56u l=0.28u
X3147 VREFP A44_DCTRL_STRIP_W_R2_0/CTRL_OUT[6] A44_CDAC_CAP_BANK_ASSEMBLY_R8_M6_0/A44_CAP_CORE128_M6_R1_0/CAP_BOTTOM_066 VDD pfet_03v3 ad=0 pd=0 as=0 ps=0 w=1.56u l=0.28u
X3148 VREFP A44_DCTRL_STRIP_W_R2_0/CTRL_OUT[6] A44_CDAC_CAP_BANK_ASSEMBLY_R8_M6_0/A44_CAP_CORE128_M6_R1_0/CAP_BOTTOM_066 VDD pfet_03v3 ad=0 pd=0 as=0 ps=0 w=1.56u l=0.28u
X3149 VREFP A44_DCTRL_STRIP_W_R2_0/CTRL_OUT[6] A44_CDAC_CAP_BANK_ASSEMBLY_R8_M6_0/A44_CAP_CORE128_M6_R1_0/CAP_BOTTOM_066 VDD pfet_03v3 ad=0 pd=0 as=0 ps=0 w=1.56u l=0.28u
X3150 VREFP A44_DCTRL_STRIP_W_R2_0/CTRL_OUT[6] A44_CDAC_CAP_BANK_ASSEMBLY_R8_M6_0/A44_CAP_CORE128_M6_R1_0/CAP_BOTTOM_066 VDD pfet_03v3 ad=0 pd=0 as=0 ps=0 w=1.56u l=0.28u
X3151 VREFP A44_DCTRL_STRIP_W_R2_0/CTRL_OUT[6] A44_CDAC_CAP_BANK_ASSEMBLY_R8_M6_0/A44_CAP_CORE128_M6_R1_0/CAP_BOTTOM_066 VDD pfet_03v3 ad=0 pd=0 as=0 ps=0 w=1.56u l=0.28u
X3152 VREFN A44_DCTRL_STRIP_W_R2_0/CTRL_OUT[6] A44_CDAC_CAP_BANK_ASSEMBLY_R8_M6_0/A44_CAP_CORE128_M6_R1_0/CAP_BOTTOM_066 GND nfet_03v3 ad=0 pd=0 as=16.6842p ps=77.76u w=1.56u l=0.28u
X3153 VREFN A44_DCTRL_STRIP_W_R2_0/CTRL_OUT[6] A44_CDAC_CAP_BANK_ASSEMBLY_R8_M6_0/A44_CAP_CORE128_M6_R1_0/CAP_BOTTOM_066 GND nfet_03v3 ad=0 pd=0 as=0 ps=0 w=1.56u l=0.28u
X3154 VREFN A44_DCTRL_STRIP_W_R2_0/CTRL_OUT[6] A44_CDAC_CAP_BANK_ASSEMBLY_R8_M6_0/A44_CAP_CORE128_M6_R1_0/CAP_BOTTOM_066 GND nfet_03v3 ad=0 pd=0 as=0 ps=0 w=1.56u l=0.28u
X3155 VREFN A44_DCTRL_STRIP_W_R2_0/CTRL_OUT[6] A44_CDAC_CAP_BANK_ASSEMBLY_R8_M6_0/A44_CAP_CORE128_M6_R1_0/CAP_BOTTOM_066 GND nfet_03v3 ad=0 pd=0 as=0 ps=0 w=1.56u l=0.28u
X3156 VREFN A44_DCTRL_STRIP_W_R2_0/CTRL_OUT[6] A44_CDAC_CAP_BANK_ASSEMBLY_R8_M6_0/A44_CAP_CORE128_M6_R1_0/CAP_BOTTOM_066 GND nfet_03v3 ad=0 pd=0 as=0 ps=0 w=1.56u l=0.28u
X3157 VREFN A44_DCTRL_STRIP_W_R2_0/CTRL_OUT[6] A44_CDAC_CAP_BANK_ASSEMBLY_R8_M6_0/A44_CAP_CORE128_M6_R1_0/CAP_BOTTOM_066 GND nfet_03v3 ad=0 pd=0 as=0 ps=0 w=1.56u l=0.28u
X3158 VREFN A44_DCTRL_STRIP_W_R2_0/CTRL_OUT[6] A44_CDAC_CAP_BANK_ASSEMBLY_R8_M6_0/A44_CAP_CORE128_M6_R1_0/CAP_BOTTOM_066 GND nfet_03v3 ad=0 pd=0 as=0 ps=0 w=1.56u l=0.28u
X3159 VREFN A44_DCTRL_STRIP_W_R2_0/CTRL_OUT[6] A44_CDAC_CAP_BANK_ASSEMBLY_R8_M6_0/A44_CAP_CORE128_M6_R1_0/CAP_BOTTOM_066 GND nfet_03v3 ad=0 pd=0 as=0 ps=0 w=1.56u l=0.28u
X3160 VREFN A44_DCTRL_STRIP_W_R2_0/CTRL_OUT[6] A44_CDAC_CAP_BANK_ASSEMBLY_R8_M6_0/A44_CAP_CORE128_M6_R1_0/CAP_BOTTOM_066 GND nfet_03v3 ad=0 pd=0 as=0 ps=0 w=1.56u l=0.28u
X3161 VREFN A44_DCTRL_STRIP_W_R2_0/CTRL_OUT[6] A44_CDAC_CAP_BANK_ASSEMBLY_R8_M6_0/A44_CAP_CORE128_M6_R1_0/CAP_BOTTOM_066 GND nfet_03v3 ad=0 pd=0 as=0 ps=0 w=1.56u l=0.28u
X3162 VREFN A44_DCTRL_STRIP_W_R2_0/CTRL_OUT[6] A44_CDAC_CAP_BANK_ASSEMBLY_R8_M6_0/A44_CAP_CORE128_M6_R1_0/CAP_BOTTOM_066 GND nfet_03v3 ad=0 pd=0 as=0 ps=0 w=1.56u l=0.28u
X3163 VREFN A44_DCTRL_STRIP_W_R2_0/CTRL_OUT[6] A44_CDAC_CAP_BANK_ASSEMBLY_R8_M6_0/A44_CAP_CORE128_M6_R1_0/CAP_BOTTOM_066 GND nfet_03v3 ad=0 pd=0 as=0 ps=0 w=1.56u l=0.28u
X3164 VREFN A44_DCTRL_STRIP_W_R2_0/CTRL_OUT[6] A44_CDAC_CAP_BANK_ASSEMBLY_R8_M6_0/A44_CAP_CORE128_M6_R1_0/CAP_BOTTOM_066 GND nfet_03v3 ad=0 pd=0 as=0 ps=0 w=1.56u l=0.28u
X3165 VREFN A44_DCTRL_STRIP_W_R2_0/CTRL_OUT[6] A44_CDAC_CAP_BANK_ASSEMBLY_R8_M6_0/A44_CAP_CORE128_M6_R1_0/CAP_BOTTOM_066 GND nfet_03v3 ad=0 pd=0 as=0 ps=0 w=1.56u l=0.28u
X3166 VREFN A44_DCTRL_STRIP_W_R2_0/CTRL_OUT[6] A44_CDAC_CAP_BANK_ASSEMBLY_R8_M6_0/A44_CAP_CORE128_M6_R1_0/CAP_BOTTOM_066 GND nfet_03v3 ad=0 pd=0 as=0 ps=0 w=1.56u l=0.28u
X3167 VREFN A44_DCTRL_STRIP_W_R2_0/CTRL_OUT[6] A44_CDAC_CAP_BANK_ASSEMBLY_R8_M6_0/A44_CAP_CORE128_M6_R1_0/CAP_BOTTOM_066 GND nfet_03v3 ad=0 pd=0 as=0 ps=0 w=1.56u l=0.28u
X3168 VREFN A44_DCTRL_STRIP_W_R2_0/CTRL_OUT[6] A44_CDAC_CAP_BANK_ASSEMBLY_R8_M6_0/A44_CAP_CORE128_M6_R1_0/CAP_BOTTOM_066 GND nfet_03v3 ad=0 pd=0 as=0 ps=0 w=1.56u l=0.28u
X3169 VREFN A44_DCTRL_STRIP_W_R2_0/CTRL_OUT[6] A44_CDAC_CAP_BANK_ASSEMBLY_R8_M6_0/A44_CAP_CORE128_M6_R1_0/CAP_BOTTOM_066 GND nfet_03v3 ad=0 pd=0 as=0 ps=0 w=1.56u l=0.28u
X3170 VREFP A44_DCTRL_STRIP_W_R2_0/CTRL_OUT[3] A44_CDAC_CAP_BANK_ASSEMBLY_R8_M6_0/A44_CAP_CORE128_M6_R1_0/CAP_BOTTOM_125 VDD pfet_03v3 ad=0 pd=0 as=16.6842p ps=77.76u w=1.56u l=0.28u
X3171 VREFP A44_DCTRL_STRIP_W_R2_0/CTRL_OUT[3] A44_CDAC_CAP_BANK_ASSEMBLY_R8_M6_0/A44_CAP_CORE128_M6_R1_0/CAP_BOTTOM_125 VDD pfet_03v3 ad=0 pd=0 as=0 ps=0 w=1.56u l=0.28u
X3172 VREFP A44_DCTRL_STRIP_W_R2_0/CTRL_OUT[3] A44_CDAC_CAP_BANK_ASSEMBLY_R8_M6_0/A44_CAP_CORE128_M6_R1_0/CAP_BOTTOM_125 VDD pfet_03v3 ad=0 pd=0 as=0 ps=0 w=1.56u l=0.28u
X3173 VREFP A44_DCTRL_STRIP_W_R2_0/CTRL_OUT[3] A44_CDAC_CAP_BANK_ASSEMBLY_R8_M6_0/A44_CAP_CORE128_M6_R1_0/CAP_BOTTOM_125 VDD pfet_03v3 ad=0 pd=0 as=0 ps=0 w=1.56u l=0.28u
X3174 VREFP A44_DCTRL_STRIP_W_R2_0/CTRL_OUT[3] A44_CDAC_CAP_BANK_ASSEMBLY_R8_M6_0/A44_CAP_CORE128_M6_R1_0/CAP_BOTTOM_125 VDD pfet_03v3 ad=0 pd=0 as=0 ps=0 w=1.56u l=0.28u
X3175 VREFP A44_DCTRL_STRIP_W_R2_0/CTRL_OUT[3] A44_CDAC_CAP_BANK_ASSEMBLY_R8_M6_0/A44_CAP_CORE128_M6_R1_0/CAP_BOTTOM_125 VDD pfet_03v3 ad=0 pd=0 as=0 ps=0 w=1.56u l=0.28u
X3176 VREFP A44_DCTRL_STRIP_W_R2_0/CTRL_OUT[3] A44_CDAC_CAP_BANK_ASSEMBLY_R8_M6_0/A44_CAP_CORE128_M6_R1_0/CAP_BOTTOM_125 VDD pfet_03v3 ad=0 pd=0 as=0 ps=0 w=1.56u l=0.28u
X3177 VREFP A44_DCTRL_STRIP_W_R2_0/CTRL_OUT[3] A44_CDAC_CAP_BANK_ASSEMBLY_R8_M6_0/A44_CAP_CORE128_M6_R1_0/CAP_BOTTOM_125 VDD pfet_03v3 ad=0 pd=0 as=0 ps=0 w=1.56u l=0.28u
X3178 VREFP A44_DCTRL_STRIP_W_R2_0/CTRL_OUT[3] A44_CDAC_CAP_BANK_ASSEMBLY_R8_M6_0/A44_CAP_CORE128_M6_R1_0/CAP_BOTTOM_125 VDD pfet_03v3 ad=0 pd=0 as=0 ps=0 w=1.56u l=0.28u
X3179 VREFP A44_DCTRL_STRIP_W_R2_0/CTRL_OUT[3] A44_CDAC_CAP_BANK_ASSEMBLY_R8_M6_0/A44_CAP_CORE128_M6_R1_0/CAP_BOTTOM_125 VDD pfet_03v3 ad=0 pd=0 as=0 ps=0 w=1.56u l=0.28u
X3180 VREFP A44_DCTRL_STRIP_W_R2_0/CTRL_OUT[3] A44_CDAC_CAP_BANK_ASSEMBLY_R8_M6_0/A44_CAP_CORE128_M6_R1_0/CAP_BOTTOM_125 VDD pfet_03v3 ad=0 pd=0 as=0 ps=0 w=1.56u l=0.28u
X3181 VREFP A44_DCTRL_STRIP_W_R2_0/CTRL_OUT[3] A44_CDAC_CAP_BANK_ASSEMBLY_R8_M6_0/A44_CAP_CORE128_M6_R1_0/CAP_BOTTOM_125 VDD pfet_03v3 ad=0 pd=0 as=0 ps=0 w=1.56u l=0.28u
X3182 VREFP A44_DCTRL_STRIP_W_R2_0/CTRL_OUT[3] A44_CDAC_CAP_BANK_ASSEMBLY_R8_M6_0/A44_CAP_CORE128_M6_R1_0/CAP_BOTTOM_125 VDD pfet_03v3 ad=0 pd=0 as=0 ps=0 w=1.56u l=0.28u
X3183 VREFP A44_DCTRL_STRIP_W_R2_0/CTRL_OUT[3] A44_CDAC_CAP_BANK_ASSEMBLY_R8_M6_0/A44_CAP_CORE128_M6_R1_0/CAP_BOTTOM_125 VDD pfet_03v3 ad=0 pd=0 as=0 ps=0 w=1.56u l=0.28u
X3184 VREFP A44_DCTRL_STRIP_W_R2_0/CTRL_OUT[3] A44_CDAC_CAP_BANK_ASSEMBLY_R8_M6_0/A44_CAP_CORE128_M6_R1_0/CAP_BOTTOM_125 VDD pfet_03v3 ad=0 pd=0 as=0 ps=0 w=1.56u l=0.28u
X3185 VREFP A44_DCTRL_STRIP_W_R2_0/CTRL_OUT[3] A44_CDAC_CAP_BANK_ASSEMBLY_R8_M6_0/A44_CAP_CORE128_M6_R1_0/CAP_BOTTOM_125 VDD pfet_03v3 ad=0 pd=0 as=0 ps=0 w=1.56u l=0.28u
X3186 VREFP A44_DCTRL_STRIP_W_R2_0/CTRL_OUT[3] A44_CDAC_CAP_BANK_ASSEMBLY_R8_M6_0/A44_CAP_CORE128_M6_R1_0/CAP_BOTTOM_125 VDD pfet_03v3 ad=0 pd=0 as=0 ps=0 w=1.56u l=0.28u
X3187 VREFP A44_DCTRL_STRIP_W_R2_0/CTRL_OUT[3] A44_CDAC_CAP_BANK_ASSEMBLY_R8_M6_0/A44_CAP_CORE128_M6_R1_0/CAP_BOTTOM_125 VDD pfet_03v3 ad=0 pd=0 as=0 ps=0 w=1.56u l=0.28u
X3188 VREFN A44_DCTRL_STRIP_W_R2_0/CTRL_OUT[3] A44_CDAC_CAP_BANK_ASSEMBLY_R8_M6_0/A44_CAP_CORE128_M6_R1_0/CAP_BOTTOM_125 GND nfet_03v3 ad=0 pd=0 as=16.6842p ps=77.76u w=1.56u l=0.28u
X3189 VREFN A44_DCTRL_STRIP_W_R2_0/CTRL_OUT[3] A44_CDAC_CAP_BANK_ASSEMBLY_R8_M6_0/A44_CAP_CORE128_M6_R1_0/CAP_BOTTOM_125 GND nfet_03v3 ad=0 pd=0 as=0 ps=0 w=1.56u l=0.28u
X3190 VREFN A44_DCTRL_STRIP_W_R2_0/CTRL_OUT[3] A44_CDAC_CAP_BANK_ASSEMBLY_R8_M6_0/A44_CAP_CORE128_M6_R1_0/CAP_BOTTOM_125 GND nfet_03v3 ad=0 pd=0 as=0 ps=0 w=1.56u l=0.28u
X3191 VREFN A44_DCTRL_STRIP_W_R2_0/CTRL_OUT[3] A44_CDAC_CAP_BANK_ASSEMBLY_R8_M6_0/A44_CAP_CORE128_M6_R1_0/CAP_BOTTOM_125 GND nfet_03v3 ad=0 pd=0 as=0 ps=0 w=1.56u l=0.28u
X3192 VREFN A44_DCTRL_STRIP_W_R2_0/CTRL_OUT[3] A44_CDAC_CAP_BANK_ASSEMBLY_R8_M6_0/A44_CAP_CORE128_M6_R1_0/CAP_BOTTOM_125 GND nfet_03v3 ad=0 pd=0 as=0 ps=0 w=1.56u l=0.28u
X3193 VREFN A44_DCTRL_STRIP_W_R2_0/CTRL_OUT[3] A44_CDAC_CAP_BANK_ASSEMBLY_R8_M6_0/A44_CAP_CORE128_M6_R1_0/CAP_BOTTOM_125 GND nfet_03v3 ad=0 pd=0 as=0 ps=0 w=1.56u l=0.28u
X3194 VREFN A44_DCTRL_STRIP_W_R2_0/CTRL_OUT[3] A44_CDAC_CAP_BANK_ASSEMBLY_R8_M6_0/A44_CAP_CORE128_M6_R1_0/CAP_BOTTOM_125 GND nfet_03v3 ad=0 pd=0 as=0 ps=0 w=1.56u l=0.28u
X3195 VREFN A44_DCTRL_STRIP_W_R2_0/CTRL_OUT[3] A44_CDAC_CAP_BANK_ASSEMBLY_R8_M6_0/A44_CAP_CORE128_M6_R1_0/CAP_BOTTOM_125 GND nfet_03v3 ad=0 pd=0 as=0 ps=0 w=1.56u l=0.28u
X3196 VREFN A44_DCTRL_STRIP_W_R2_0/CTRL_OUT[3] A44_CDAC_CAP_BANK_ASSEMBLY_R8_M6_0/A44_CAP_CORE128_M6_R1_0/CAP_BOTTOM_125 GND nfet_03v3 ad=0 pd=0 as=0 ps=0 w=1.56u l=0.28u
X3197 VREFN A44_DCTRL_STRIP_W_R2_0/CTRL_OUT[3] A44_CDAC_CAP_BANK_ASSEMBLY_R8_M6_0/A44_CAP_CORE128_M6_R1_0/CAP_BOTTOM_125 GND nfet_03v3 ad=0 pd=0 as=0 ps=0 w=1.56u l=0.28u
X3198 VREFN A44_DCTRL_STRIP_W_R2_0/CTRL_OUT[3] A44_CDAC_CAP_BANK_ASSEMBLY_R8_M6_0/A44_CAP_CORE128_M6_R1_0/CAP_BOTTOM_125 GND nfet_03v3 ad=0 pd=0 as=0 ps=0 w=1.56u l=0.28u
X3199 VREFN A44_DCTRL_STRIP_W_R2_0/CTRL_OUT[3] A44_CDAC_CAP_BANK_ASSEMBLY_R8_M6_0/A44_CAP_CORE128_M6_R1_0/CAP_BOTTOM_125 GND nfet_03v3 ad=0 pd=0 as=0 ps=0 w=1.56u l=0.28u
X3200 VREFN A44_DCTRL_STRIP_W_R2_0/CTRL_OUT[3] A44_CDAC_CAP_BANK_ASSEMBLY_R8_M6_0/A44_CAP_CORE128_M6_R1_0/CAP_BOTTOM_125 GND nfet_03v3 ad=0 pd=0 as=0 ps=0 w=1.56u l=0.28u
X3201 VREFN A44_DCTRL_STRIP_W_R2_0/CTRL_OUT[3] A44_CDAC_CAP_BANK_ASSEMBLY_R8_M6_0/A44_CAP_CORE128_M6_R1_0/CAP_BOTTOM_125 GND nfet_03v3 ad=0 pd=0 as=0 ps=0 w=1.56u l=0.28u
X3202 VREFN A44_DCTRL_STRIP_W_R2_0/CTRL_OUT[3] A44_CDAC_CAP_BANK_ASSEMBLY_R8_M6_0/A44_CAP_CORE128_M6_R1_0/CAP_BOTTOM_125 GND nfet_03v3 ad=0 pd=0 as=0 ps=0 w=1.56u l=0.28u
X3203 VREFN A44_DCTRL_STRIP_W_R2_0/CTRL_OUT[3] A44_CDAC_CAP_BANK_ASSEMBLY_R8_M6_0/A44_CAP_CORE128_M6_R1_0/CAP_BOTTOM_125 GND nfet_03v3 ad=0 pd=0 as=0 ps=0 w=1.56u l=0.28u
X3204 VREFN A44_DCTRL_STRIP_W_R2_0/CTRL_OUT[3] A44_CDAC_CAP_BANK_ASSEMBLY_R8_M6_0/A44_CAP_CORE128_M6_R1_0/CAP_BOTTOM_125 GND nfet_03v3 ad=0 pd=0 as=0 ps=0 w=1.56u l=0.28u
X3205 VREFN A44_DCTRL_STRIP_W_R2_0/CTRL_OUT[3] A44_CDAC_CAP_BANK_ASSEMBLY_R8_M6_0/A44_CAP_CORE128_M6_R1_0/CAP_BOTTOM_125 GND nfet_03v3 ad=0 pd=0 as=0 ps=0 w=1.56u l=0.28u
X3206 VREFP A44_DCTRL_STRIP_W_R2_0/CTRL_OUT[7] A44_CDAC_CAP_BANK_ASSEMBLY_R8_M6_0/A44_CAP_CORE128_M6_R1_0/CAP_BOTTOM_089 VDD pfet_03v3 ad=0 pd=0 as=16.6842p ps=77.76u w=1.56u l=0.28u
X3207 VREFP A44_DCTRL_STRIP_W_R2_0/CTRL_OUT[7] A44_CDAC_CAP_BANK_ASSEMBLY_R8_M6_0/A44_CAP_CORE128_M6_R1_0/CAP_BOTTOM_089 VDD pfet_03v3 ad=0 pd=0 as=0 ps=0 w=1.56u l=0.28u
X3208 VREFP A44_DCTRL_STRIP_W_R2_0/CTRL_OUT[7] A44_CDAC_CAP_BANK_ASSEMBLY_R8_M6_0/A44_CAP_CORE128_M6_R1_0/CAP_BOTTOM_089 VDD pfet_03v3 ad=0 pd=0 as=0 ps=0 w=1.56u l=0.28u
X3209 VREFP A44_DCTRL_STRIP_W_R2_0/CTRL_OUT[7] A44_CDAC_CAP_BANK_ASSEMBLY_R8_M6_0/A44_CAP_CORE128_M6_R1_0/CAP_BOTTOM_089 VDD pfet_03v3 ad=0 pd=0 as=0 ps=0 w=1.56u l=0.28u
X3210 VREFP A44_DCTRL_STRIP_W_R2_0/CTRL_OUT[7] A44_CDAC_CAP_BANK_ASSEMBLY_R8_M6_0/A44_CAP_CORE128_M6_R1_0/CAP_BOTTOM_089 VDD pfet_03v3 ad=0 pd=0 as=0 ps=0 w=1.56u l=0.28u
X3211 VREFP A44_DCTRL_STRIP_W_R2_0/CTRL_OUT[7] A44_CDAC_CAP_BANK_ASSEMBLY_R8_M6_0/A44_CAP_CORE128_M6_R1_0/CAP_BOTTOM_089 VDD pfet_03v3 ad=0 pd=0 as=0 ps=0 w=1.56u l=0.28u
X3212 VREFP A44_DCTRL_STRIP_W_R2_0/CTRL_OUT[7] A44_CDAC_CAP_BANK_ASSEMBLY_R8_M6_0/A44_CAP_CORE128_M6_R1_0/CAP_BOTTOM_089 VDD pfet_03v3 ad=0 pd=0 as=0 ps=0 w=1.56u l=0.28u
X3213 VREFP A44_DCTRL_STRIP_W_R2_0/CTRL_OUT[7] A44_CDAC_CAP_BANK_ASSEMBLY_R8_M6_0/A44_CAP_CORE128_M6_R1_0/CAP_BOTTOM_089 VDD pfet_03v3 ad=0 pd=0 as=0 ps=0 w=1.56u l=0.28u
X3214 VREFP A44_DCTRL_STRIP_W_R2_0/CTRL_OUT[7] A44_CDAC_CAP_BANK_ASSEMBLY_R8_M6_0/A44_CAP_CORE128_M6_R1_0/CAP_BOTTOM_089 VDD pfet_03v3 ad=0 pd=0 as=0 ps=0 w=1.56u l=0.28u
X3215 VREFP A44_DCTRL_STRIP_W_R2_0/CTRL_OUT[7] A44_CDAC_CAP_BANK_ASSEMBLY_R8_M6_0/A44_CAP_CORE128_M6_R1_0/CAP_BOTTOM_089 VDD pfet_03v3 ad=0 pd=0 as=0 ps=0 w=1.56u l=0.28u
X3216 VREFP A44_DCTRL_STRIP_W_R2_0/CTRL_OUT[7] A44_CDAC_CAP_BANK_ASSEMBLY_R8_M6_0/A44_CAP_CORE128_M6_R1_0/CAP_BOTTOM_089 VDD pfet_03v3 ad=0 pd=0 as=0 ps=0 w=1.56u l=0.28u
X3217 VREFP A44_DCTRL_STRIP_W_R2_0/CTRL_OUT[7] A44_CDAC_CAP_BANK_ASSEMBLY_R8_M6_0/A44_CAP_CORE128_M6_R1_0/CAP_BOTTOM_089 VDD pfet_03v3 ad=0 pd=0 as=0 ps=0 w=1.56u l=0.28u
X3218 VREFP A44_DCTRL_STRIP_W_R2_0/CTRL_OUT[7] A44_CDAC_CAP_BANK_ASSEMBLY_R8_M6_0/A44_CAP_CORE128_M6_R1_0/CAP_BOTTOM_089 VDD pfet_03v3 ad=0 pd=0 as=0 ps=0 w=1.56u l=0.28u
X3219 VREFP A44_DCTRL_STRIP_W_R2_0/CTRL_OUT[7] A44_CDAC_CAP_BANK_ASSEMBLY_R8_M6_0/A44_CAP_CORE128_M6_R1_0/CAP_BOTTOM_089 VDD pfet_03v3 ad=0 pd=0 as=0 ps=0 w=1.56u l=0.28u
X3220 VREFP A44_DCTRL_STRIP_W_R2_0/CTRL_OUT[7] A44_CDAC_CAP_BANK_ASSEMBLY_R8_M6_0/A44_CAP_CORE128_M6_R1_0/CAP_BOTTOM_089 VDD pfet_03v3 ad=0 pd=0 as=0 ps=0 w=1.56u l=0.28u
X3221 VREFP A44_DCTRL_STRIP_W_R2_0/CTRL_OUT[7] A44_CDAC_CAP_BANK_ASSEMBLY_R8_M6_0/A44_CAP_CORE128_M6_R1_0/CAP_BOTTOM_089 VDD pfet_03v3 ad=0 pd=0 as=0 ps=0 w=1.56u l=0.28u
X3222 VREFP A44_DCTRL_STRIP_W_R2_0/CTRL_OUT[7] A44_CDAC_CAP_BANK_ASSEMBLY_R8_M6_0/A44_CAP_CORE128_M6_R1_0/CAP_BOTTOM_089 VDD pfet_03v3 ad=0 pd=0 as=0 ps=0 w=1.56u l=0.28u
X3223 VREFP A44_DCTRL_STRIP_W_R2_0/CTRL_OUT[7] A44_CDAC_CAP_BANK_ASSEMBLY_R8_M6_0/A44_CAP_CORE128_M6_R1_0/CAP_BOTTOM_089 VDD pfet_03v3 ad=0 pd=0 as=0 ps=0 w=1.56u l=0.28u
X3224 VREFN A44_DCTRL_STRIP_W_R2_0/CTRL_OUT[7] A44_CDAC_CAP_BANK_ASSEMBLY_R8_M6_0/A44_CAP_CORE128_M6_R1_0/CAP_BOTTOM_089 GND nfet_03v3 ad=0 pd=0 as=16.6842p ps=77.76u w=1.56u l=0.28u
X3225 VREFN A44_DCTRL_STRIP_W_R2_0/CTRL_OUT[7] A44_CDAC_CAP_BANK_ASSEMBLY_R8_M6_0/A44_CAP_CORE128_M6_R1_0/CAP_BOTTOM_089 GND nfet_03v3 ad=0 pd=0 as=0 ps=0 w=1.56u l=0.28u
X3226 VREFN A44_DCTRL_STRIP_W_R2_0/CTRL_OUT[7] A44_CDAC_CAP_BANK_ASSEMBLY_R8_M6_0/A44_CAP_CORE128_M6_R1_0/CAP_BOTTOM_089 GND nfet_03v3 ad=0 pd=0 as=0 ps=0 w=1.56u l=0.28u
X3227 VREFN A44_DCTRL_STRIP_W_R2_0/CTRL_OUT[7] A44_CDAC_CAP_BANK_ASSEMBLY_R8_M6_0/A44_CAP_CORE128_M6_R1_0/CAP_BOTTOM_089 GND nfet_03v3 ad=0 pd=0 as=0 ps=0 w=1.56u l=0.28u
X3228 VREFN A44_DCTRL_STRIP_W_R2_0/CTRL_OUT[7] A44_CDAC_CAP_BANK_ASSEMBLY_R8_M6_0/A44_CAP_CORE128_M6_R1_0/CAP_BOTTOM_089 GND nfet_03v3 ad=0 pd=0 as=0 ps=0 w=1.56u l=0.28u
X3229 VREFN A44_DCTRL_STRIP_W_R2_0/CTRL_OUT[7] A44_CDAC_CAP_BANK_ASSEMBLY_R8_M6_0/A44_CAP_CORE128_M6_R1_0/CAP_BOTTOM_089 GND nfet_03v3 ad=0 pd=0 as=0 ps=0 w=1.56u l=0.28u
X3230 VREFN A44_DCTRL_STRIP_W_R2_0/CTRL_OUT[7] A44_CDAC_CAP_BANK_ASSEMBLY_R8_M6_0/A44_CAP_CORE128_M6_R1_0/CAP_BOTTOM_089 GND nfet_03v3 ad=0 pd=0 as=0 ps=0 w=1.56u l=0.28u
X3231 VREFN A44_DCTRL_STRIP_W_R2_0/CTRL_OUT[7] A44_CDAC_CAP_BANK_ASSEMBLY_R8_M6_0/A44_CAP_CORE128_M6_R1_0/CAP_BOTTOM_089 GND nfet_03v3 ad=0 pd=0 as=0 ps=0 w=1.56u l=0.28u
X3232 VREFN A44_DCTRL_STRIP_W_R2_0/CTRL_OUT[7] A44_CDAC_CAP_BANK_ASSEMBLY_R8_M6_0/A44_CAP_CORE128_M6_R1_0/CAP_BOTTOM_089 GND nfet_03v3 ad=0 pd=0 as=0 ps=0 w=1.56u l=0.28u
X3233 VREFN A44_DCTRL_STRIP_W_R2_0/CTRL_OUT[7] A44_CDAC_CAP_BANK_ASSEMBLY_R8_M6_0/A44_CAP_CORE128_M6_R1_0/CAP_BOTTOM_089 GND nfet_03v3 ad=0 pd=0 as=0 ps=0 w=1.56u l=0.28u
X3234 VREFN A44_DCTRL_STRIP_W_R2_0/CTRL_OUT[7] A44_CDAC_CAP_BANK_ASSEMBLY_R8_M6_0/A44_CAP_CORE128_M6_R1_0/CAP_BOTTOM_089 GND nfet_03v3 ad=0 pd=0 as=0 ps=0 w=1.56u l=0.28u
X3235 VREFN A44_DCTRL_STRIP_W_R2_0/CTRL_OUT[7] A44_CDAC_CAP_BANK_ASSEMBLY_R8_M6_0/A44_CAP_CORE128_M6_R1_0/CAP_BOTTOM_089 GND nfet_03v3 ad=0 pd=0 as=0 ps=0 w=1.56u l=0.28u
X3236 VREFN A44_DCTRL_STRIP_W_R2_0/CTRL_OUT[7] A44_CDAC_CAP_BANK_ASSEMBLY_R8_M6_0/A44_CAP_CORE128_M6_R1_0/CAP_BOTTOM_089 GND nfet_03v3 ad=0 pd=0 as=0 ps=0 w=1.56u l=0.28u
X3237 VREFN A44_DCTRL_STRIP_W_R2_0/CTRL_OUT[7] A44_CDAC_CAP_BANK_ASSEMBLY_R8_M6_0/A44_CAP_CORE128_M6_R1_0/CAP_BOTTOM_089 GND nfet_03v3 ad=0 pd=0 as=0 ps=0 w=1.56u l=0.28u
X3238 VREFN A44_DCTRL_STRIP_W_R2_0/CTRL_OUT[7] A44_CDAC_CAP_BANK_ASSEMBLY_R8_M6_0/A44_CAP_CORE128_M6_R1_0/CAP_BOTTOM_089 GND nfet_03v3 ad=0 pd=0 as=0 ps=0 w=1.56u l=0.28u
X3239 VREFN A44_DCTRL_STRIP_W_R2_0/CTRL_OUT[7] A44_CDAC_CAP_BANK_ASSEMBLY_R8_M6_0/A44_CAP_CORE128_M6_R1_0/CAP_BOTTOM_089 GND nfet_03v3 ad=0 pd=0 as=0 ps=0 w=1.56u l=0.28u
X3240 VREFN A44_DCTRL_STRIP_W_R2_0/CTRL_OUT[7] A44_CDAC_CAP_BANK_ASSEMBLY_R8_M6_0/A44_CAP_CORE128_M6_R1_0/CAP_BOTTOM_089 GND nfet_03v3 ad=0 pd=0 as=0 ps=0 w=1.56u l=0.28u
X3241 VREFN A44_DCTRL_STRIP_W_R2_0/CTRL_OUT[7] A44_CDAC_CAP_BANK_ASSEMBLY_R8_M6_0/A44_CAP_CORE128_M6_R1_0/CAP_BOTTOM_089 GND nfet_03v3 ad=0 pd=0 as=0 ps=0 w=1.56u l=0.28u
X3242 VREFP A44_DCTRL_STRIP_W_R2_0/CTRL_OUT[4] A44_CDAC_CAP_BANK_ASSEMBLY_R8_M6_0/A44_CAP_CORE128_M6_R1_0/CAP_BOTTOM_086 VDD pfet_03v3 ad=0 pd=0 as=16.6842p ps=77.76u w=1.56u l=0.28u
X3243 VREFP A44_DCTRL_STRIP_W_R2_0/CTRL_OUT[4] A44_CDAC_CAP_BANK_ASSEMBLY_R8_M6_0/A44_CAP_CORE128_M6_R1_0/CAP_BOTTOM_086 VDD pfet_03v3 ad=0 pd=0 as=0 ps=0 w=1.56u l=0.28u
X3244 VREFP A44_DCTRL_STRIP_W_R2_0/CTRL_OUT[4] A44_CDAC_CAP_BANK_ASSEMBLY_R8_M6_0/A44_CAP_CORE128_M6_R1_0/CAP_BOTTOM_086 VDD pfet_03v3 ad=0 pd=0 as=0 ps=0 w=1.56u l=0.28u
X3245 VREFP A44_DCTRL_STRIP_W_R2_0/CTRL_OUT[4] A44_CDAC_CAP_BANK_ASSEMBLY_R8_M6_0/A44_CAP_CORE128_M6_R1_0/CAP_BOTTOM_086 VDD pfet_03v3 ad=0 pd=0 as=0 ps=0 w=1.56u l=0.28u
X3246 VREFP A44_DCTRL_STRIP_W_R2_0/CTRL_OUT[4] A44_CDAC_CAP_BANK_ASSEMBLY_R8_M6_0/A44_CAP_CORE128_M6_R1_0/CAP_BOTTOM_086 VDD pfet_03v3 ad=0 pd=0 as=0 ps=0 w=1.56u l=0.28u
X3247 VREFP A44_DCTRL_STRIP_W_R2_0/CTRL_OUT[4] A44_CDAC_CAP_BANK_ASSEMBLY_R8_M6_0/A44_CAP_CORE128_M6_R1_0/CAP_BOTTOM_086 VDD pfet_03v3 ad=0 pd=0 as=0 ps=0 w=1.56u l=0.28u
X3248 VREFP A44_DCTRL_STRIP_W_R2_0/CTRL_OUT[4] A44_CDAC_CAP_BANK_ASSEMBLY_R8_M6_0/A44_CAP_CORE128_M6_R1_0/CAP_BOTTOM_086 VDD pfet_03v3 ad=0 pd=0 as=0 ps=0 w=1.56u l=0.28u
X3249 VREFP A44_DCTRL_STRIP_W_R2_0/CTRL_OUT[4] A44_CDAC_CAP_BANK_ASSEMBLY_R8_M6_0/A44_CAP_CORE128_M6_R1_0/CAP_BOTTOM_086 VDD pfet_03v3 ad=0 pd=0 as=0 ps=0 w=1.56u l=0.28u
X3250 VREFP A44_DCTRL_STRIP_W_R2_0/CTRL_OUT[4] A44_CDAC_CAP_BANK_ASSEMBLY_R8_M6_0/A44_CAP_CORE128_M6_R1_0/CAP_BOTTOM_086 VDD pfet_03v3 ad=0 pd=0 as=0 ps=0 w=1.56u l=0.28u
X3251 VREFP A44_DCTRL_STRIP_W_R2_0/CTRL_OUT[4] A44_CDAC_CAP_BANK_ASSEMBLY_R8_M6_0/A44_CAP_CORE128_M6_R1_0/CAP_BOTTOM_086 VDD pfet_03v3 ad=0 pd=0 as=0 ps=0 w=1.56u l=0.28u
X3252 VREFP A44_DCTRL_STRIP_W_R2_0/CTRL_OUT[4] A44_CDAC_CAP_BANK_ASSEMBLY_R8_M6_0/A44_CAP_CORE128_M6_R1_0/CAP_BOTTOM_086 VDD pfet_03v3 ad=0 pd=0 as=0 ps=0 w=1.56u l=0.28u
X3253 VREFP A44_DCTRL_STRIP_W_R2_0/CTRL_OUT[4] A44_CDAC_CAP_BANK_ASSEMBLY_R8_M6_0/A44_CAP_CORE128_M6_R1_0/CAP_BOTTOM_086 VDD pfet_03v3 ad=0 pd=0 as=0 ps=0 w=1.56u l=0.28u
X3254 VREFP A44_DCTRL_STRIP_W_R2_0/CTRL_OUT[4] A44_CDAC_CAP_BANK_ASSEMBLY_R8_M6_0/A44_CAP_CORE128_M6_R1_0/CAP_BOTTOM_086 VDD pfet_03v3 ad=0 pd=0 as=0 ps=0 w=1.56u l=0.28u
X3255 VREFP A44_DCTRL_STRIP_W_R2_0/CTRL_OUT[4] A44_CDAC_CAP_BANK_ASSEMBLY_R8_M6_0/A44_CAP_CORE128_M6_R1_0/CAP_BOTTOM_086 VDD pfet_03v3 ad=0 pd=0 as=0 ps=0 w=1.56u l=0.28u
X3256 VREFP A44_DCTRL_STRIP_W_R2_0/CTRL_OUT[4] A44_CDAC_CAP_BANK_ASSEMBLY_R8_M6_0/A44_CAP_CORE128_M6_R1_0/CAP_BOTTOM_086 VDD pfet_03v3 ad=0 pd=0 as=0 ps=0 w=1.56u l=0.28u
X3257 VREFP A44_DCTRL_STRIP_W_R2_0/CTRL_OUT[4] A44_CDAC_CAP_BANK_ASSEMBLY_R8_M6_0/A44_CAP_CORE128_M6_R1_0/CAP_BOTTOM_086 VDD pfet_03v3 ad=0 pd=0 as=0 ps=0 w=1.56u l=0.28u
X3258 VREFP A44_DCTRL_STRIP_W_R2_0/CTRL_OUT[4] A44_CDAC_CAP_BANK_ASSEMBLY_R8_M6_0/A44_CAP_CORE128_M6_R1_0/CAP_BOTTOM_086 VDD pfet_03v3 ad=0 pd=0 as=0 ps=0 w=1.56u l=0.28u
X3259 VREFP A44_DCTRL_STRIP_W_R2_0/CTRL_OUT[4] A44_CDAC_CAP_BANK_ASSEMBLY_R8_M6_0/A44_CAP_CORE128_M6_R1_0/CAP_BOTTOM_086 VDD pfet_03v3 ad=0 pd=0 as=0 ps=0 w=1.56u l=0.28u
X3260 VREFN A44_DCTRL_STRIP_W_R2_0/CTRL_OUT[4] A44_CDAC_CAP_BANK_ASSEMBLY_R8_M6_0/A44_CAP_CORE128_M6_R1_0/CAP_BOTTOM_086 GND nfet_03v3 ad=0 pd=0 as=16.6842p ps=77.76u w=1.56u l=0.28u
X3261 VREFN A44_DCTRL_STRIP_W_R2_0/CTRL_OUT[4] A44_CDAC_CAP_BANK_ASSEMBLY_R8_M6_0/A44_CAP_CORE128_M6_R1_0/CAP_BOTTOM_086 GND nfet_03v3 ad=0 pd=0 as=0 ps=0 w=1.56u l=0.28u
X3262 VREFN A44_DCTRL_STRIP_W_R2_0/CTRL_OUT[4] A44_CDAC_CAP_BANK_ASSEMBLY_R8_M6_0/A44_CAP_CORE128_M6_R1_0/CAP_BOTTOM_086 GND nfet_03v3 ad=0 pd=0 as=0 ps=0 w=1.56u l=0.28u
X3263 VREFN A44_DCTRL_STRIP_W_R2_0/CTRL_OUT[4] A44_CDAC_CAP_BANK_ASSEMBLY_R8_M6_0/A44_CAP_CORE128_M6_R1_0/CAP_BOTTOM_086 GND nfet_03v3 ad=0 pd=0 as=0 ps=0 w=1.56u l=0.28u
X3264 VREFN A44_DCTRL_STRIP_W_R2_0/CTRL_OUT[4] A44_CDAC_CAP_BANK_ASSEMBLY_R8_M6_0/A44_CAP_CORE128_M6_R1_0/CAP_BOTTOM_086 GND nfet_03v3 ad=0 pd=0 as=0 ps=0 w=1.56u l=0.28u
X3265 VREFN A44_DCTRL_STRIP_W_R2_0/CTRL_OUT[4] A44_CDAC_CAP_BANK_ASSEMBLY_R8_M6_0/A44_CAP_CORE128_M6_R1_0/CAP_BOTTOM_086 GND nfet_03v3 ad=0 pd=0 as=0 ps=0 w=1.56u l=0.28u
X3266 VREFN A44_DCTRL_STRIP_W_R2_0/CTRL_OUT[4] A44_CDAC_CAP_BANK_ASSEMBLY_R8_M6_0/A44_CAP_CORE128_M6_R1_0/CAP_BOTTOM_086 GND nfet_03v3 ad=0 pd=0 as=0 ps=0 w=1.56u l=0.28u
X3267 VREFN A44_DCTRL_STRIP_W_R2_0/CTRL_OUT[4] A44_CDAC_CAP_BANK_ASSEMBLY_R8_M6_0/A44_CAP_CORE128_M6_R1_0/CAP_BOTTOM_086 GND nfet_03v3 ad=0 pd=0 as=0 ps=0 w=1.56u l=0.28u
X3268 VREFN A44_DCTRL_STRIP_W_R2_0/CTRL_OUT[4] A44_CDAC_CAP_BANK_ASSEMBLY_R8_M6_0/A44_CAP_CORE128_M6_R1_0/CAP_BOTTOM_086 GND nfet_03v3 ad=0 pd=0 as=0 ps=0 w=1.56u l=0.28u
X3269 VREFN A44_DCTRL_STRIP_W_R2_0/CTRL_OUT[4] A44_CDAC_CAP_BANK_ASSEMBLY_R8_M6_0/A44_CAP_CORE128_M6_R1_0/CAP_BOTTOM_086 GND nfet_03v3 ad=0 pd=0 as=0 ps=0 w=1.56u l=0.28u
X3270 VREFN A44_DCTRL_STRIP_W_R2_0/CTRL_OUT[4] A44_CDAC_CAP_BANK_ASSEMBLY_R8_M6_0/A44_CAP_CORE128_M6_R1_0/CAP_BOTTOM_086 GND nfet_03v3 ad=0 pd=0 as=0 ps=0 w=1.56u l=0.28u
X3271 VREFN A44_DCTRL_STRIP_W_R2_0/CTRL_OUT[4] A44_CDAC_CAP_BANK_ASSEMBLY_R8_M6_0/A44_CAP_CORE128_M6_R1_0/CAP_BOTTOM_086 GND nfet_03v3 ad=0 pd=0 as=0 ps=0 w=1.56u l=0.28u
X3272 VREFN A44_DCTRL_STRIP_W_R2_0/CTRL_OUT[4] A44_CDAC_CAP_BANK_ASSEMBLY_R8_M6_0/A44_CAP_CORE128_M6_R1_0/CAP_BOTTOM_086 GND nfet_03v3 ad=0 pd=0 as=0 ps=0 w=1.56u l=0.28u
X3273 VREFN A44_DCTRL_STRIP_W_R2_0/CTRL_OUT[4] A44_CDAC_CAP_BANK_ASSEMBLY_R8_M6_0/A44_CAP_CORE128_M6_R1_0/CAP_BOTTOM_086 GND nfet_03v3 ad=0 pd=0 as=0 ps=0 w=1.56u l=0.28u
X3274 VREFN A44_DCTRL_STRIP_W_R2_0/CTRL_OUT[4] A44_CDAC_CAP_BANK_ASSEMBLY_R8_M6_0/A44_CAP_CORE128_M6_R1_0/CAP_BOTTOM_086 GND nfet_03v3 ad=0 pd=0 as=0 ps=0 w=1.56u l=0.28u
X3275 VREFN A44_DCTRL_STRIP_W_R2_0/CTRL_OUT[4] A44_CDAC_CAP_BANK_ASSEMBLY_R8_M6_0/A44_CAP_CORE128_M6_R1_0/CAP_BOTTOM_086 GND nfet_03v3 ad=0 pd=0 as=0 ps=0 w=1.56u l=0.28u
X3276 VREFN A44_DCTRL_STRIP_W_R2_0/CTRL_OUT[4] A44_CDAC_CAP_BANK_ASSEMBLY_R8_M6_0/A44_CAP_CORE128_M6_R1_0/CAP_BOTTOM_086 GND nfet_03v3 ad=0 pd=0 as=0 ps=0 w=1.56u l=0.28u
X3277 VREFN A44_DCTRL_STRIP_W_R2_0/CTRL_OUT[4] A44_CDAC_CAP_BANK_ASSEMBLY_R8_M6_0/A44_CAP_CORE128_M6_R1_0/CAP_BOTTOM_086 GND nfet_03v3 ad=0 pd=0 as=0 ps=0 w=1.56u l=0.28u
X3278 VREFP A44_DCTRL_STRIP_W_R2_0/CTRL_OUT[7] A44_CDAC_CAP_BANK_ASSEMBLY_R8_M6_0/A44_CAP_CORE128_M6_R1_0/CAP_BOTTOM_112 VDD pfet_03v3 ad=0 pd=0 as=16.6842p ps=77.76u w=1.56u l=0.28u
X3279 VREFP A44_DCTRL_STRIP_W_R2_0/CTRL_OUT[7] A44_CDAC_CAP_BANK_ASSEMBLY_R8_M6_0/A44_CAP_CORE128_M6_R1_0/CAP_BOTTOM_112 VDD pfet_03v3 ad=0 pd=0 as=0 ps=0 w=1.56u l=0.28u
X3280 VREFP A44_DCTRL_STRIP_W_R2_0/CTRL_OUT[7] A44_CDAC_CAP_BANK_ASSEMBLY_R8_M6_0/A44_CAP_CORE128_M6_R1_0/CAP_BOTTOM_112 VDD pfet_03v3 ad=0 pd=0 as=0 ps=0 w=1.56u l=0.28u
X3281 VREFP A44_DCTRL_STRIP_W_R2_0/CTRL_OUT[7] A44_CDAC_CAP_BANK_ASSEMBLY_R8_M6_0/A44_CAP_CORE128_M6_R1_0/CAP_BOTTOM_112 VDD pfet_03v3 ad=0 pd=0 as=0 ps=0 w=1.56u l=0.28u
X3282 VREFP A44_DCTRL_STRIP_W_R2_0/CTRL_OUT[7] A44_CDAC_CAP_BANK_ASSEMBLY_R8_M6_0/A44_CAP_CORE128_M6_R1_0/CAP_BOTTOM_112 VDD pfet_03v3 ad=0 pd=0 as=0 ps=0 w=1.56u l=0.28u
X3283 VREFP A44_DCTRL_STRIP_W_R2_0/CTRL_OUT[7] A44_CDAC_CAP_BANK_ASSEMBLY_R8_M6_0/A44_CAP_CORE128_M6_R1_0/CAP_BOTTOM_112 VDD pfet_03v3 ad=0 pd=0 as=0 ps=0 w=1.56u l=0.28u
X3284 VREFP A44_DCTRL_STRIP_W_R2_0/CTRL_OUT[7] A44_CDAC_CAP_BANK_ASSEMBLY_R8_M6_0/A44_CAP_CORE128_M6_R1_0/CAP_BOTTOM_112 VDD pfet_03v3 ad=0 pd=0 as=0 ps=0 w=1.56u l=0.28u
X3285 VREFP A44_DCTRL_STRIP_W_R2_0/CTRL_OUT[7] A44_CDAC_CAP_BANK_ASSEMBLY_R8_M6_0/A44_CAP_CORE128_M6_R1_0/CAP_BOTTOM_112 VDD pfet_03v3 ad=0 pd=0 as=0 ps=0 w=1.56u l=0.28u
X3286 VREFP A44_DCTRL_STRIP_W_R2_0/CTRL_OUT[7] A44_CDAC_CAP_BANK_ASSEMBLY_R8_M6_0/A44_CAP_CORE128_M6_R1_0/CAP_BOTTOM_112 VDD pfet_03v3 ad=0 pd=0 as=0 ps=0 w=1.56u l=0.28u
X3287 VREFP A44_DCTRL_STRIP_W_R2_0/CTRL_OUT[7] A44_CDAC_CAP_BANK_ASSEMBLY_R8_M6_0/A44_CAP_CORE128_M6_R1_0/CAP_BOTTOM_112 VDD pfet_03v3 ad=0 pd=0 as=0 ps=0 w=1.56u l=0.28u
X3288 VREFP A44_DCTRL_STRIP_W_R2_0/CTRL_OUT[7] A44_CDAC_CAP_BANK_ASSEMBLY_R8_M6_0/A44_CAP_CORE128_M6_R1_0/CAP_BOTTOM_112 VDD pfet_03v3 ad=0 pd=0 as=0 ps=0 w=1.56u l=0.28u
X3289 VREFP A44_DCTRL_STRIP_W_R2_0/CTRL_OUT[7] A44_CDAC_CAP_BANK_ASSEMBLY_R8_M6_0/A44_CAP_CORE128_M6_R1_0/CAP_BOTTOM_112 VDD pfet_03v3 ad=0 pd=0 as=0 ps=0 w=1.56u l=0.28u
X3290 VREFP A44_DCTRL_STRIP_W_R2_0/CTRL_OUT[7] A44_CDAC_CAP_BANK_ASSEMBLY_R8_M6_0/A44_CAP_CORE128_M6_R1_0/CAP_BOTTOM_112 VDD pfet_03v3 ad=0 pd=0 as=0 ps=0 w=1.56u l=0.28u
X3291 VREFP A44_DCTRL_STRIP_W_R2_0/CTRL_OUT[7] A44_CDAC_CAP_BANK_ASSEMBLY_R8_M6_0/A44_CAP_CORE128_M6_R1_0/CAP_BOTTOM_112 VDD pfet_03v3 ad=0 pd=0 as=0 ps=0 w=1.56u l=0.28u
X3292 VREFP A44_DCTRL_STRIP_W_R2_0/CTRL_OUT[7] A44_CDAC_CAP_BANK_ASSEMBLY_R8_M6_0/A44_CAP_CORE128_M6_R1_0/CAP_BOTTOM_112 VDD pfet_03v3 ad=0 pd=0 as=0 ps=0 w=1.56u l=0.28u
X3293 VREFP A44_DCTRL_STRIP_W_R2_0/CTRL_OUT[7] A44_CDAC_CAP_BANK_ASSEMBLY_R8_M6_0/A44_CAP_CORE128_M6_R1_0/CAP_BOTTOM_112 VDD pfet_03v3 ad=0 pd=0 as=0 ps=0 w=1.56u l=0.28u
X3294 VREFP A44_DCTRL_STRIP_W_R2_0/CTRL_OUT[7] A44_CDAC_CAP_BANK_ASSEMBLY_R8_M6_0/A44_CAP_CORE128_M6_R1_0/CAP_BOTTOM_112 VDD pfet_03v3 ad=0 pd=0 as=0 ps=0 w=1.56u l=0.28u
X3295 VREFP A44_DCTRL_STRIP_W_R2_0/CTRL_OUT[7] A44_CDAC_CAP_BANK_ASSEMBLY_R8_M6_0/A44_CAP_CORE128_M6_R1_0/CAP_BOTTOM_112 VDD pfet_03v3 ad=0 pd=0 as=0 ps=0 w=1.56u l=0.28u
X3296 VREFN A44_DCTRL_STRIP_W_R2_0/CTRL_OUT[7] A44_CDAC_CAP_BANK_ASSEMBLY_R8_M6_0/A44_CAP_CORE128_M6_R1_0/CAP_BOTTOM_112 GND nfet_03v3 ad=0 pd=0 as=16.6842p ps=77.76u w=1.56u l=0.28u
X3297 VREFN A44_DCTRL_STRIP_W_R2_0/CTRL_OUT[7] A44_CDAC_CAP_BANK_ASSEMBLY_R8_M6_0/A44_CAP_CORE128_M6_R1_0/CAP_BOTTOM_112 GND nfet_03v3 ad=0 pd=0 as=0 ps=0 w=1.56u l=0.28u
X3298 VREFN A44_DCTRL_STRIP_W_R2_0/CTRL_OUT[7] A44_CDAC_CAP_BANK_ASSEMBLY_R8_M6_0/A44_CAP_CORE128_M6_R1_0/CAP_BOTTOM_112 GND nfet_03v3 ad=0 pd=0 as=0 ps=0 w=1.56u l=0.28u
X3299 VREFN A44_DCTRL_STRIP_W_R2_0/CTRL_OUT[7] A44_CDAC_CAP_BANK_ASSEMBLY_R8_M6_0/A44_CAP_CORE128_M6_R1_0/CAP_BOTTOM_112 GND nfet_03v3 ad=0 pd=0 as=0 ps=0 w=1.56u l=0.28u
X3300 VREFN A44_DCTRL_STRIP_W_R2_0/CTRL_OUT[7] A44_CDAC_CAP_BANK_ASSEMBLY_R8_M6_0/A44_CAP_CORE128_M6_R1_0/CAP_BOTTOM_112 GND nfet_03v3 ad=0 pd=0 as=0 ps=0 w=1.56u l=0.28u
X3301 VREFN A44_DCTRL_STRIP_W_R2_0/CTRL_OUT[7] A44_CDAC_CAP_BANK_ASSEMBLY_R8_M6_0/A44_CAP_CORE128_M6_R1_0/CAP_BOTTOM_112 GND nfet_03v3 ad=0 pd=0 as=0 ps=0 w=1.56u l=0.28u
X3302 VREFN A44_DCTRL_STRIP_W_R2_0/CTRL_OUT[7] A44_CDAC_CAP_BANK_ASSEMBLY_R8_M6_0/A44_CAP_CORE128_M6_R1_0/CAP_BOTTOM_112 GND nfet_03v3 ad=0 pd=0 as=0 ps=0 w=1.56u l=0.28u
X3303 VREFN A44_DCTRL_STRIP_W_R2_0/CTRL_OUT[7] A44_CDAC_CAP_BANK_ASSEMBLY_R8_M6_0/A44_CAP_CORE128_M6_R1_0/CAP_BOTTOM_112 GND nfet_03v3 ad=0 pd=0 as=0 ps=0 w=1.56u l=0.28u
X3304 VREFN A44_DCTRL_STRIP_W_R2_0/CTRL_OUT[7] A44_CDAC_CAP_BANK_ASSEMBLY_R8_M6_0/A44_CAP_CORE128_M6_R1_0/CAP_BOTTOM_112 GND nfet_03v3 ad=0 pd=0 as=0 ps=0 w=1.56u l=0.28u
X3305 VREFN A44_DCTRL_STRIP_W_R2_0/CTRL_OUT[7] A44_CDAC_CAP_BANK_ASSEMBLY_R8_M6_0/A44_CAP_CORE128_M6_R1_0/CAP_BOTTOM_112 GND nfet_03v3 ad=0 pd=0 as=0 ps=0 w=1.56u l=0.28u
X3306 VREFN A44_DCTRL_STRIP_W_R2_0/CTRL_OUT[7] A44_CDAC_CAP_BANK_ASSEMBLY_R8_M6_0/A44_CAP_CORE128_M6_R1_0/CAP_BOTTOM_112 GND nfet_03v3 ad=0 pd=0 as=0 ps=0 w=1.56u l=0.28u
X3307 VREFN A44_DCTRL_STRIP_W_R2_0/CTRL_OUT[7] A44_CDAC_CAP_BANK_ASSEMBLY_R8_M6_0/A44_CAP_CORE128_M6_R1_0/CAP_BOTTOM_112 GND nfet_03v3 ad=0 pd=0 as=0 ps=0 w=1.56u l=0.28u
X3308 VREFN A44_DCTRL_STRIP_W_R2_0/CTRL_OUT[7] A44_CDAC_CAP_BANK_ASSEMBLY_R8_M6_0/A44_CAP_CORE128_M6_R1_0/CAP_BOTTOM_112 GND nfet_03v3 ad=0 pd=0 as=0 ps=0 w=1.56u l=0.28u
X3309 VREFN A44_DCTRL_STRIP_W_R2_0/CTRL_OUT[7] A44_CDAC_CAP_BANK_ASSEMBLY_R8_M6_0/A44_CAP_CORE128_M6_R1_0/CAP_BOTTOM_112 GND nfet_03v3 ad=0 pd=0 as=0 ps=0 w=1.56u l=0.28u
X3310 VREFN A44_DCTRL_STRIP_W_R2_0/CTRL_OUT[7] A44_CDAC_CAP_BANK_ASSEMBLY_R8_M6_0/A44_CAP_CORE128_M6_R1_0/CAP_BOTTOM_112 GND nfet_03v3 ad=0 pd=0 as=0 ps=0 w=1.56u l=0.28u
X3311 VREFN A44_DCTRL_STRIP_W_R2_0/CTRL_OUT[7] A44_CDAC_CAP_BANK_ASSEMBLY_R8_M6_0/A44_CAP_CORE128_M6_R1_0/CAP_BOTTOM_112 GND nfet_03v3 ad=0 pd=0 as=0 ps=0 w=1.56u l=0.28u
X3312 VREFN A44_DCTRL_STRIP_W_R2_0/CTRL_OUT[7] A44_CDAC_CAP_BANK_ASSEMBLY_R8_M6_0/A44_CAP_CORE128_M6_R1_0/CAP_BOTTOM_112 GND nfet_03v3 ad=0 pd=0 as=0 ps=0 w=1.56u l=0.28u
X3313 VREFN A44_DCTRL_STRIP_W_R2_0/CTRL_OUT[7] A44_CDAC_CAP_BANK_ASSEMBLY_R8_M6_0/A44_CAP_CORE128_M6_R1_0/CAP_BOTTOM_112 GND nfet_03v3 ad=0 pd=0 as=0 ps=0 w=1.56u l=0.28u
X3314 VREFP A44_DCTRL_STRIP_W_R2_0/CTRL_OUT[7] A44_CDAC_CAP_BANK_ASSEMBLY_R8_M6_0/A44_CAP_CORE128_M6_R1_0/CAP_BOTTOM_076 VDD pfet_03v3 ad=0 pd=0 as=16.6842p ps=77.76u w=1.56u l=0.28u
X3315 VREFP A44_DCTRL_STRIP_W_R2_0/CTRL_OUT[7] A44_CDAC_CAP_BANK_ASSEMBLY_R8_M6_0/A44_CAP_CORE128_M6_R1_0/CAP_BOTTOM_076 VDD pfet_03v3 ad=0 pd=0 as=0 ps=0 w=1.56u l=0.28u
X3316 VREFP A44_DCTRL_STRIP_W_R2_0/CTRL_OUT[7] A44_CDAC_CAP_BANK_ASSEMBLY_R8_M6_0/A44_CAP_CORE128_M6_R1_0/CAP_BOTTOM_076 VDD pfet_03v3 ad=0 pd=0 as=0 ps=0 w=1.56u l=0.28u
X3317 VREFP A44_DCTRL_STRIP_W_R2_0/CTRL_OUT[7] A44_CDAC_CAP_BANK_ASSEMBLY_R8_M6_0/A44_CAP_CORE128_M6_R1_0/CAP_BOTTOM_076 VDD pfet_03v3 ad=0 pd=0 as=0 ps=0 w=1.56u l=0.28u
X3318 VREFP A44_DCTRL_STRIP_W_R2_0/CTRL_OUT[7] A44_CDAC_CAP_BANK_ASSEMBLY_R8_M6_0/A44_CAP_CORE128_M6_R1_0/CAP_BOTTOM_076 VDD pfet_03v3 ad=0 pd=0 as=0 ps=0 w=1.56u l=0.28u
X3319 VREFP A44_DCTRL_STRIP_W_R2_0/CTRL_OUT[7] A44_CDAC_CAP_BANK_ASSEMBLY_R8_M6_0/A44_CAP_CORE128_M6_R1_0/CAP_BOTTOM_076 VDD pfet_03v3 ad=0 pd=0 as=0 ps=0 w=1.56u l=0.28u
X3320 VREFP A44_DCTRL_STRIP_W_R2_0/CTRL_OUT[7] A44_CDAC_CAP_BANK_ASSEMBLY_R8_M6_0/A44_CAP_CORE128_M6_R1_0/CAP_BOTTOM_076 VDD pfet_03v3 ad=0 pd=0 as=0 ps=0 w=1.56u l=0.28u
X3321 VREFP A44_DCTRL_STRIP_W_R2_0/CTRL_OUT[7] A44_CDAC_CAP_BANK_ASSEMBLY_R8_M6_0/A44_CAP_CORE128_M6_R1_0/CAP_BOTTOM_076 VDD pfet_03v3 ad=0 pd=0 as=0 ps=0 w=1.56u l=0.28u
X3322 VREFP A44_DCTRL_STRIP_W_R2_0/CTRL_OUT[7] A44_CDAC_CAP_BANK_ASSEMBLY_R8_M6_0/A44_CAP_CORE128_M6_R1_0/CAP_BOTTOM_076 VDD pfet_03v3 ad=0 pd=0 as=0 ps=0 w=1.56u l=0.28u
X3323 VREFP A44_DCTRL_STRIP_W_R2_0/CTRL_OUT[7] A44_CDAC_CAP_BANK_ASSEMBLY_R8_M6_0/A44_CAP_CORE128_M6_R1_0/CAP_BOTTOM_076 VDD pfet_03v3 ad=0 pd=0 as=0 ps=0 w=1.56u l=0.28u
X3324 VREFP A44_DCTRL_STRIP_W_R2_0/CTRL_OUT[7] A44_CDAC_CAP_BANK_ASSEMBLY_R8_M6_0/A44_CAP_CORE128_M6_R1_0/CAP_BOTTOM_076 VDD pfet_03v3 ad=0 pd=0 as=0 ps=0 w=1.56u l=0.28u
X3325 VREFP A44_DCTRL_STRIP_W_R2_0/CTRL_OUT[7] A44_CDAC_CAP_BANK_ASSEMBLY_R8_M6_0/A44_CAP_CORE128_M6_R1_0/CAP_BOTTOM_076 VDD pfet_03v3 ad=0 pd=0 as=0 ps=0 w=1.56u l=0.28u
X3326 VREFP A44_DCTRL_STRIP_W_R2_0/CTRL_OUT[7] A44_CDAC_CAP_BANK_ASSEMBLY_R8_M6_0/A44_CAP_CORE128_M6_R1_0/CAP_BOTTOM_076 VDD pfet_03v3 ad=0 pd=0 as=0 ps=0 w=1.56u l=0.28u
X3327 VREFP A44_DCTRL_STRIP_W_R2_0/CTRL_OUT[7] A44_CDAC_CAP_BANK_ASSEMBLY_R8_M6_0/A44_CAP_CORE128_M6_R1_0/CAP_BOTTOM_076 VDD pfet_03v3 ad=0 pd=0 as=0 ps=0 w=1.56u l=0.28u
X3328 VREFP A44_DCTRL_STRIP_W_R2_0/CTRL_OUT[7] A44_CDAC_CAP_BANK_ASSEMBLY_R8_M6_0/A44_CAP_CORE128_M6_R1_0/CAP_BOTTOM_076 VDD pfet_03v3 ad=0 pd=0 as=0 ps=0 w=1.56u l=0.28u
X3329 VREFP A44_DCTRL_STRIP_W_R2_0/CTRL_OUT[7] A44_CDAC_CAP_BANK_ASSEMBLY_R8_M6_0/A44_CAP_CORE128_M6_R1_0/CAP_BOTTOM_076 VDD pfet_03v3 ad=0 pd=0 as=0 ps=0 w=1.56u l=0.28u
X3330 VREFP A44_DCTRL_STRIP_W_R2_0/CTRL_OUT[7] A44_CDAC_CAP_BANK_ASSEMBLY_R8_M6_0/A44_CAP_CORE128_M6_R1_0/CAP_BOTTOM_076 VDD pfet_03v3 ad=0 pd=0 as=0 ps=0 w=1.56u l=0.28u
X3331 VREFP A44_DCTRL_STRIP_W_R2_0/CTRL_OUT[7] A44_CDAC_CAP_BANK_ASSEMBLY_R8_M6_0/A44_CAP_CORE128_M6_R1_0/CAP_BOTTOM_076 VDD pfet_03v3 ad=0 pd=0 as=0 ps=0 w=1.56u l=0.28u
X3332 VREFN A44_DCTRL_STRIP_W_R2_0/CTRL_OUT[7] A44_CDAC_CAP_BANK_ASSEMBLY_R8_M6_0/A44_CAP_CORE128_M6_R1_0/CAP_BOTTOM_076 GND nfet_03v3 ad=0 pd=0 as=16.6842p ps=77.76u w=1.56u l=0.28u
X3333 VREFN A44_DCTRL_STRIP_W_R2_0/CTRL_OUT[7] A44_CDAC_CAP_BANK_ASSEMBLY_R8_M6_0/A44_CAP_CORE128_M6_R1_0/CAP_BOTTOM_076 GND nfet_03v3 ad=0 pd=0 as=0 ps=0 w=1.56u l=0.28u
X3334 VREFN A44_DCTRL_STRIP_W_R2_0/CTRL_OUT[7] A44_CDAC_CAP_BANK_ASSEMBLY_R8_M6_0/A44_CAP_CORE128_M6_R1_0/CAP_BOTTOM_076 GND nfet_03v3 ad=0 pd=0 as=0 ps=0 w=1.56u l=0.28u
X3335 VREFN A44_DCTRL_STRIP_W_R2_0/CTRL_OUT[7] A44_CDAC_CAP_BANK_ASSEMBLY_R8_M6_0/A44_CAP_CORE128_M6_R1_0/CAP_BOTTOM_076 GND nfet_03v3 ad=0 pd=0 as=0 ps=0 w=1.56u l=0.28u
X3336 VREFN A44_DCTRL_STRIP_W_R2_0/CTRL_OUT[7] A44_CDAC_CAP_BANK_ASSEMBLY_R8_M6_0/A44_CAP_CORE128_M6_R1_0/CAP_BOTTOM_076 GND nfet_03v3 ad=0 pd=0 as=0 ps=0 w=1.56u l=0.28u
X3337 VREFN A44_DCTRL_STRIP_W_R2_0/CTRL_OUT[7] A44_CDAC_CAP_BANK_ASSEMBLY_R8_M6_0/A44_CAP_CORE128_M6_R1_0/CAP_BOTTOM_076 GND nfet_03v3 ad=0 pd=0 as=0 ps=0 w=1.56u l=0.28u
X3338 VREFN A44_DCTRL_STRIP_W_R2_0/CTRL_OUT[7] A44_CDAC_CAP_BANK_ASSEMBLY_R8_M6_0/A44_CAP_CORE128_M6_R1_0/CAP_BOTTOM_076 GND nfet_03v3 ad=0 pd=0 as=0 ps=0 w=1.56u l=0.28u
X3339 VREFN A44_DCTRL_STRIP_W_R2_0/CTRL_OUT[7] A44_CDAC_CAP_BANK_ASSEMBLY_R8_M6_0/A44_CAP_CORE128_M6_R1_0/CAP_BOTTOM_076 GND nfet_03v3 ad=0 pd=0 as=0 ps=0 w=1.56u l=0.28u
X3340 VREFN A44_DCTRL_STRIP_W_R2_0/CTRL_OUT[7] A44_CDAC_CAP_BANK_ASSEMBLY_R8_M6_0/A44_CAP_CORE128_M6_R1_0/CAP_BOTTOM_076 GND nfet_03v3 ad=0 pd=0 as=0 ps=0 w=1.56u l=0.28u
X3341 VREFN A44_DCTRL_STRIP_W_R2_0/CTRL_OUT[7] A44_CDAC_CAP_BANK_ASSEMBLY_R8_M6_0/A44_CAP_CORE128_M6_R1_0/CAP_BOTTOM_076 GND nfet_03v3 ad=0 pd=0 as=0 ps=0 w=1.56u l=0.28u
X3342 VREFN A44_DCTRL_STRIP_W_R2_0/CTRL_OUT[7] A44_CDAC_CAP_BANK_ASSEMBLY_R8_M6_0/A44_CAP_CORE128_M6_R1_0/CAP_BOTTOM_076 GND nfet_03v3 ad=0 pd=0 as=0 ps=0 w=1.56u l=0.28u
X3343 VREFN A44_DCTRL_STRIP_W_R2_0/CTRL_OUT[7] A44_CDAC_CAP_BANK_ASSEMBLY_R8_M6_0/A44_CAP_CORE128_M6_R1_0/CAP_BOTTOM_076 GND nfet_03v3 ad=0 pd=0 as=0 ps=0 w=1.56u l=0.28u
X3344 VREFN A44_DCTRL_STRIP_W_R2_0/CTRL_OUT[7] A44_CDAC_CAP_BANK_ASSEMBLY_R8_M6_0/A44_CAP_CORE128_M6_R1_0/CAP_BOTTOM_076 GND nfet_03v3 ad=0 pd=0 as=0 ps=0 w=1.56u l=0.28u
X3345 VREFN A44_DCTRL_STRIP_W_R2_0/CTRL_OUT[7] A44_CDAC_CAP_BANK_ASSEMBLY_R8_M6_0/A44_CAP_CORE128_M6_R1_0/CAP_BOTTOM_076 GND nfet_03v3 ad=0 pd=0 as=0 ps=0 w=1.56u l=0.28u
X3346 VREFN A44_DCTRL_STRIP_W_R2_0/CTRL_OUT[7] A44_CDAC_CAP_BANK_ASSEMBLY_R8_M6_0/A44_CAP_CORE128_M6_R1_0/CAP_BOTTOM_076 GND nfet_03v3 ad=0 pd=0 as=0 ps=0 w=1.56u l=0.28u
X3347 VREFN A44_DCTRL_STRIP_W_R2_0/CTRL_OUT[7] A44_CDAC_CAP_BANK_ASSEMBLY_R8_M6_0/A44_CAP_CORE128_M6_R1_0/CAP_BOTTOM_076 GND nfet_03v3 ad=0 pd=0 as=0 ps=0 w=1.56u l=0.28u
X3348 VREFN A44_DCTRL_STRIP_W_R2_0/CTRL_OUT[7] A44_CDAC_CAP_BANK_ASSEMBLY_R8_M6_0/A44_CAP_CORE128_M6_R1_0/CAP_BOTTOM_076 GND nfet_03v3 ad=0 pd=0 as=0 ps=0 w=1.56u l=0.28u
X3349 VREFN A44_DCTRL_STRIP_W_R2_0/CTRL_OUT[7] A44_CDAC_CAP_BANK_ASSEMBLY_R8_M6_0/A44_CAP_CORE128_M6_R1_0/CAP_BOTTOM_076 GND nfet_03v3 ad=0 pd=0 as=0 ps=0 w=1.56u l=0.28u
X3350 VREFP A44_DCTRL_STRIP_W_R2_0/CTRL_OUT[7] A44_CDAC_CAP_BANK_ASSEMBLY_R8_M6_0/A44_CAP_CORE128_M6_R1_0/CAP_BOTTOM_099 VDD pfet_03v3 ad=0 pd=0 as=16.6842p ps=77.76u w=1.56u l=0.28u
X3351 VREFP A44_DCTRL_STRIP_W_R2_0/CTRL_OUT[7] A44_CDAC_CAP_BANK_ASSEMBLY_R8_M6_0/A44_CAP_CORE128_M6_R1_0/CAP_BOTTOM_099 VDD pfet_03v3 ad=0 pd=0 as=0 ps=0 w=1.56u l=0.28u
X3352 VREFP A44_DCTRL_STRIP_W_R2_0/CTRL_OUT[7] A44_CDAC_CAP_BANK_ASSEMBLY_R8_M6_0/A44_CAP_CORE128_M6_R1_0/CAP_BOTTOM_099 VDD pfet_03v3 ad=0 pd=0 as=0 ps=0 w=1.56u l=0.28u
X3353 VREFP A44_DCTRL_STRIP_W_R2_0/CTRL_OUT[7] A44_CDAC_CAP_BANK_ASSEMBLY_R8_M6_0/A44_CAP_CORE128_M6_R1_0/CAP_BOTTOM_099 VDD pfet_03v3 ad=0 pd=0 as=0 ps=0 w=1.56u l=0.28u
X3354 VREFP A44_DCTRL_STRIP_W_R2_0/CTRL_OUT[7] A44_CDAC_CAP_BANK_ASSEMBLY_R8_M6_0/A44_CAP_CORE128_M6_R1_0/CAP_BOTTOM_099 VDD pfet_03v3 ad=0 pd=0 as=0 ps=0 w=1.56u l=0.28u
X3355 VREFP A44_DCTRL_STRIP_W_R2_0/CTRL_OUT[7] A44_CDAC_CAP_BANK_ASSEMBLY_R8_M6_0/A44_CAP_CORE128_M6_R1_0/CAP_BOTTOM_099 VDD pfet_03v3 ad=0 pd=0 as=0 ps=0 w=1.56u l=0.28u
X3356 VREFP A44_DCTRL_STRIP_W_R2_0/CTRL_OUT[7] A44_CDAC_CAP_BANK_ASSEMBLY_R8_M6_0/A44_CAP_CORE128_M6_R1_0/CAP_BOTTOM_099 VDD pfet_03v3 ad=0 pd=0 as=0 ps=0 w=1.56u l=0.28u
X3357 VREFP A44_DCTRL_STRIP_W_R2_0/CTRL_OUT[7] A44_CDAC_CAP_BANK_ASSEMBLY_R8_M6_0/A44_CAP_CORE128_M6_R1_0/CAP_BOTTOM_099 VDD pfet_03v3 ad=0 pd=0 as=0 ps=0 w=1.56u l=0.28u
X3358 VREFP A44_DCTRL_STRIP_W_R2_0/CTRL_OUT[7] A44_CDAC_CAP_BANK_ASSEMBLY_R8_M6_0/A44_CAP_CORE128_M6_R1_0/CAP_BOTTOM_099 VDD pfet_03v3 ad=0 pd=0 as=0 ps=0 w=1.56u l=0.28u
X3359 VREFP A44_DCTRL_STRIP_W_R2_0/CTRL_OUT[7] A44_CDAC_CAP_BANK_ASSEMBLY_R8_M6_0/A44_CAP_CORE128_M6_R1_0/CAP_BOTTOM_099 VDD pfet_03v3 ad=0 pd=0 as=0 ps=0 w=1.56u l=0.28u
X3360 VREFP A44_DCTRL_STRIP_W_R2_0/CTRL_OUT[7] A44_CDAC_CAP_BANK_ASSEMBLY_R8_M6_0/A44_CAP_CORE128_M6_R1_0/CAP_BOTTOM_099 VDD pfet_03v3 ad=0 pd=0 as=0 ps=0 w=1.56u l=0.28u
X3361 VREFP A44_DCTRL_STRIP_W_R2_0/CTRL_OUT[7] A44_CDAC_CAP_BANK_ASSEMBLY_R8_M6_0/A44_CAP_CORE128_M6_R1_0/CAP_BOTTOM_099 VDD pfet_03v3 ad=0 pd=0 as=0 ps=0 w=1.56u l=0.28u
X3362 VREFP A44_DCTRL_STRIP_W_R2_0/CTRL_OUT[7] A44_CDAC_CAP_BANK_ASSEMBLY_R8_M6_0/A44_CAP_CORE128_M6_R1_0/CAP_BOTTOM_099 VDD pfet_03v3 ad=0 pd=0 as=0 ps=0 w=1.56u l=0.28u
X3363 VREFP A44_DCTRL_STRIP_W_R2_0/CTRL_OUT[7] A44_CDAC_CAP_BANK_ASSEMBLY_R8_M6_0/A44_CAP_CORE128_M6_R1_0/CAP_BOTTOM_099 VDD pfet_03v3 ad=0 pd=0 as=0 ps=0 w=1.56u l=0.28u
X3364 VREFP A44_DCTRL_STRIP_W_R2_0/CTRL_OUT[7] A44_CDAC_CAP_BANK_ASSEMBLY_R8_M6_0/A44_CAP_CORE128_M6_R1_0/CAP_BOTTOM_099 VDD pfet_03v3 ad=0 pd=0 as=0 ps=0 w=1.56u l=0.28u
X3365 VREFP A44_DCTRL_STRIP_W_R2_0/CTRL_OUT[7] A44_CDAC_CAP_BANK_ASSEMBLY_R8_M6_0/A44_CAP_CORE128_M6_R1_0/CAP_BOTTOM_099 VDD pfet_03v3 ad=0 pd=0 as=0 ps=0 w=1.56u l=0.28u
X3366 VREFP A44_DCTRL_STRIP_W_R2_0/CTRL_OUT[7] A44_CDAC_CAP_BANK_ASSEMBLY_R8_M6_0/A44_CAP_CORE128_M6_R1_0/CAP_BOTTOM_099 VDD pfet_03v3 ad=0 pd=0 as=0 ps=0 w=1.56u l=0.28u
X3367 VREFP A44_DCTRL_STRIP_W_R2_0/CTRL_OUT[7] A44_CDAC_CAP_BANK_ASSEMBLY_R8_M6_0/A44_CAP_CORE128_M6_R1_0/CAP_BOTTOM_099 VDD pfet_03v3 ad=0 pd=0 as=0 ps=0 w=1.56u l=0.28u
X3368 VREFN A44_DCTRL_STRIP_W_R2_0/CTRL_OUT[7] A44_CDAC_CAP_BANK_ASSEMBLY_R8_M6_0/A44_CAP_CORE128_M6_R1_0/CAP_BOTTOM_099 GND nfet_03v3 ad=0 pd=0 as=16.6842p ps=77.76u w=1.56u l=0.28u
X3369 VREFN A44_DCTRL_STRIP_W_R2_0/CTRL_OUT[7] A44_CDAC_CAP_BANK_ASSEMBLY_R8_M6_0/A44_CAP_CORE128_M6_R1_0/CAP_BOTTOM_099 GND nfet_03v3 ad=0 pd=0 as=0 ps=0 w=1.56u l=0.28u
X3370 VREFN A44_DCTRL_STRIP_W_R2_0/CTRL_OUT[7] A44_CDAC_CAP_BANK_ASSEMBLY_R8_M6_0/A44_CAP_CORE128_M6_R1_0/CAP_BOTTOM_099 GND nfet_03v3 ad=0 pd=0 as=0 ps=0 w=1.56u l=0.28u
X3371 VREFN A44_DCTRL_STRIP_W_R2_0/CTRL_OUT[7] A44_CDAC_CAP_BANK_ASSEMBLY_R8_M6_0/A44_CAP_CORE128_M6_R1_0/CAP_BOTTOM_099 GND nfet_03v3 ad=0 pd=0 as=0 ps=0 w=1.56u l=0.28u
X3372 VREFN A44_DCTRL_STRIP_W_R2_0/CTRL_OUT[7] A44_CDAC_CAP_BANK_ASSEMBLY_R8_M6_0/A44_CAP_CORE128_M6_R1_0/CAP_BOTTOM_099 GND nfet_03v3 ad=0 pd=0 as=0 ps=0 w=1.56u l=0.28u
X3373 VREFN A44_DCTRL_STRIP_W_R2_0/CTRL_OUT[7] A44_CDAC_CAP_BANK_ASSEMBLY_R8_M6_0/A44_CAP_CORE128_M6_R1_0/CAP_BOTTOM_099 GND nfet_03v3 ad=0 pd=0 as=0 ps=0 w=1.56u l=0.28u
X3374 VREFN A44_DCTRL_STRIP_W_R2_0/CTRL_OUT[7] A44_CDAC_CAP_BANK_ASSEMBLY_R8_M6_0/A44_CAP_CORE128_M6_R1_0/CAP_BOTTOM_099 GND nfet_03v3 ad=0 pd=0 as=0 ps=0 w=1.56u l=0.28u
X3375 VREFN A44_DCTRL_STRIP_W_R2_0/CTRL_OUT[7] A44_CDAC_CAP_BANK_ASSEMBLY_R8_M6_0/A44_CAP_CORE128_M6_R1_0/CAP_BOTTOM_099 GND nfet_03v3 ad=0 pd=0 as=0 ps=0 w=1.56u l=0.28u
X3376 VREFN A44_DCTRL_STRIP_W_R2_0/CTRL_OUT[7] A44_CDAC_CAP_BANK_ASSEMBLY_R8_M6_0/A44_CAP_CORE128_M6_R1_0/CAP_BOTTOM_099 GND nfet_03v3 ad=0 pd=0 as=0 ps=0 w=1.56u l=0.28u
X3377 VREFN A44_DCTRL_STRIP_W_R2_0/CTRL_OUT[7] A44_CDAC_CAP_BANK_ASSEMBLY_R8_M6_0/A44_CAP_CORE128_M6_R1_0/CAP_BOTTOM_099 GND nfet_03v3 ad=0 pd=0 as=0 ps=0 w=1.56u l=0.28u
X3378 VREFN A44_DCTRL_STRIP_W_R2_0/CTRL_OUT[7] A44_CDAC_CAP_BANK_ASSEMBLY_R8_M6_0/A44_CAP_CORE128_M6_R1_0/CAP_BOTTOM_099 GND nfet_03v3 ad=0 pd=0 as=0 ps=0 w=1.56u l=0.28u
X3379 VREFN A44_DCTRL_STRIP_W_R2_0/CTRL_OUT[7] A44_CDAC_CAP_BANK_ASSEMBLY_R8_M6_0/A44_CAP_CORE128_M6_R1_0/CAP_BOTTOM_099 GND nfet_03v3 ad=0 pd=0 as=0 ps=0 w=1.56u l=0.28u
X3380 VREFN A44_DCTRL_STRIP_W_R2_0/CTRL_OUT[7] A44_CDAC_CAP_BANK_ASSEMBLY_R8_M6_0/A44_CAP_CORE128_M6_R1_0/CAP_BOTTOM_099 GND nfet_03v3 ad=0 pd=0 as=0 ps=0 w=1.56u l=0.28u
X3381 VREFN A44_DCTRL_STRIP_W_R2_0/CTRL_OUT[7] A44_CDAC_CAP_BANK_ASSEMBLY_R8_M6_0/A44_CAP_CORE128_M6_R1_0/CAP_BOTTOM_099 GND nfet_03v3 ad=0 pd=0 as=0 ps=0 w=1.56u l=0.28u
X3382 VREFN A44_DCTRL_STRIP_W_R2_0/CTRL_OUT[7] A44_CDAC_CAP_BANK_ASSEMBLY_R8_M6_0/A44_CAP_CORE128_M6_R1_0/CAP_BOTTOM_099 GND nfet_03v3 ad=0 pd=0 as=0 ps=0 w=1.56u l=0.28u
X3383 VREFN A44_DCTRL_STRIP_W_R2_0/CTRL_OUT[7] A44_CDAC_CAP_BANK_ASSEMBLY_R8_M6_0/A44_CAP_CORE128_M6_R1_0/CAP_BOTTOM_099 GND nfet_03v3 ad=0 pd=0 as=0 ps=0 w=1.56u l=0.28u
X3384 VREFN A44_DCTRL_STRIP_W_R2_0/CTRL_OUT[7] A44_CDAC_CAP_BANK_ASSEMBLY_R8_M6_0/A44_CAP_CORE128_M6_R1_0/CAP_BOTTOM_099 GND nfet_03v3 ad=0 pd=0 as=0 ps=0 w=1.56u l=0.28u
X3385 VREFN A44_DCTRL_STRIP_W_R2_0/CTRL_OUT[7] A44_CDAC_CAP_BANK_ASSEMBLY_R8_M6_0/A44_CAP_CORE128_M6_R1_0/CAP_BOTTOM_099 GND nfet_03v3 ad=0 pd=0 as=0 ps=0 w=1.56u l=0.28u
X3386 VREFP A44_DCTRL_STRIP_W_R2_0/CTRL_OUT[6] A44_CDAC_CAP_BANK_ASSEMBLY_R8_M6_0/A44_CAP_CORE128_M6_R1_0/CAP_BOTTOM_123 VDD pfet_03v3 ad=0 pd=0 as=16.6842p ps=77.76u w=1.56u l=0.28u
X3387 VREFP A44_DCTRL_STRIP_W_R2_0/CTRL_OUT[6] A44_CDAC_CAP_BANK_ASSEMBLY_R8_M6_0/A44_CAP_CORE128_M6_R1_0/CAP_BOTTOM_123 VDD pfet_03v3 ad=0 pd=0 as=0 ps=0 w=1.56u l=0.28u
X3388 VREFP A44_DCTRL_STRIP_W_R2_0/CTRL_OUT[6] A44_CDAC_CAP_BANK_ASSEMBLY_R8_M6_0/A44_CAP_CORE128_M6_R1_0/CAP_BOTTOM_123 VDD pfet_03v3 ad=0 pd=0 as=0 ps=0 w=1.56u l=0.28u
X3389 VREFP A44_DCTRL_STRIP_W_R2_0/CTRL_OUT[6] A44_CDAC_CAP_BANK_ASSEMBLY_R8_M6_0/A44_CAP_CORE128_M6_R1_0/CAP_BOTTOM_123 VDD pfet_03v3 ad=0 pd=0 as=0 ps=0 w=1.56u l=0.28u
X3390 VREFP A44_DCTRL_STRIP_W_R2_0/CTRL_OUT[6] A44_CDAC_CAP_BANK_ASSEMBLY_R8_M6_0/A44_CAP_CORE128_M6_R1_0/CAP_BOTTOM_123 VDD pfet_03v3 ad=0 pd=0 as=0 ps=0 w=1.56u l=0.28u
X3391 VREFP A44_DCTRL_STRIP_W_R2_0/CTRL_OUT[6] A44_CDAC_CAP_BANK_ASSEMBLY_R8_M6_0/A44_CAP_CORE128_M6_R1_0/CAP_BOTTOM_123 VDD pfet_03v3 ad=0 pd=0 as=0 ps=0 w=1.56u l=0.28u
X3392 VREFP A44_DCTRL_STRIP_W_R2_0/CTRL_OUT[6] A44_CDAC_CAP_BANK_ASSEMBLY_R8_M6_0/A44_CAP_CORE128_M6_R1_0/CAP_BOTTOM_123 VDD pfet_03v3 ad=0 pd=0 as=0 ps=0 w=1.56u l=0.28u
X3393 VREFP A44_DCTRL_STRIP_W_R2_0/CTRL_OUT[6] A44_CDAC_CAP_BANK_ASSEMBLY_R8_M6_0/A44_CAP_CORE128_M6_R1_0/CAP_BOTTOM_123 VDD pfet_03v3 ad=0 pd=0 as=0 ps=0 w=1.56u l=0.28u
X3394 VREFP A44_DCTRL_STRIP_W_R2_0/CTRL_OUT[6] A44_CDAC_CAP_BANK_ASSEMBLY_R8_M6_0/A44_CAP_CORE128_M6_R1_0/CAP_BOTTOM_123 VDD pfet_03v3 ad=0 pd=0 as=0 ps=0 w=1.56u l=0.28u
X3395 VREFP A44_DCTRL_STRIP_W_R2_0/CTRL_OUT[6] A44_CDAC_CAP_BANK_ASSEMBLY_R8_M6_0/A44_CAP_CORE128_M6_R1_0/CAP_BOTTOM_123 VDD pfet_03v3 ad=0 pd=0 as=0 ps=0 w=1.56u l=0.28u
X3396 VREFP A44_DCTRL_STRIP_W_R2_0/CTRL_OUT[6] A44_CDAC_CAP_BANK_ASSEMBLY_R8_M6_0/A44_CAP_CORE128_M6_R1_0/CAP_BOTTOM_123 VDD pfet_03v3 ad=0 pd=0 as=0 ps=0 w=1.56u l=0.28u
X3397 VREFP A44_DCTRL_STRIP_W_R2_0/CTRL_OUT[6] A44_CDAC_CAP_BANK_ASSEMBLY_R8_M6_0/A44_CAP_CORE128_M6_R1_0/CAP_BOTTOM_123 VDD pfet_03v3 ad=0 pd=0 as=0 ps=0 w=1.56u l=0.28u
X3398 VREFP A44_DCTRL_STRIP_W_R2_0/CTRL_OUT[6] A44_CDAC_CAP_BANK_ASSEMBLY_R8_M6_0/A44_CAP_CORE128_M6_R1_0/CAP_BOTTOM_123 VDD pfet_03v3 ad=0 pd=0 as=0 ps=0 w=1.56u l=0.28u
X3399 VREFP A44_DCTRL_STRIP_W_R2_0/CTRL_OUT[6] A44_CDAC_CAP_BANK_ASSEMBLY_R8_M6_0/A44_CAP_CORE128_M6_R1_0/CAP_BOTTOM_123 VDD pfet_03v3 ad=0 pd=0 as=0 ps=0 w=1.56u l=0.28u
X3400 VREFP A44_DCTRL_STRIP_W_R2_0/CTRL_OUT[6] A44_CDAC_CAP_BANK_ASSEMBLY_R8_M6_0/A44_CAP_CORE128_M6_R1_0/CAP_BOTTOM_123 VDD pfet_03v3 ad=0 pd=0 as=0 ps=0 w=1.56u l=0.28u
X3401 VREFP A44_DCTRL_STRIP_W_R2_0/CTRL_OUT[6] A44_CDAC_CAP_BANK_ASSEMBLY_R8_M6_0/A44_CAP_CORE128_M6_R1_0/CAP_BOTTOM_123 VDD pfet_03v3 ad=0 pd=0 as=0 ps=0 w=1.56u l=0.28u
X3402 VREFP A44_DCTRL_STRIP_W_R2_0/CTRL_OUT[6] A44_CDAC_CAP_BANK_ASSEMBLY_R8_M6_0/A44_CAP_CORE128_M6_R1_0/CAP_BOTTOM_123 VDD pfet_03v3 ad=0 pd=0 as=0 ps=0 w=1.56u l=0.28u
X3403 VREFP A44_DCTRL_STRIP_W_R2_0/CTRL_OUT[6] A44_CDAC_CAP_BANK_ASSEMBLY_R8_M6_0/A44_CAP_CORE128_M6_R1_0/CAP_BOTTOM_123 VDD pfet_03v3 ad=0 pd=0 as=0 ps=0 w=1.56u l=0.28u
X3404 VREFN A44_DCTRL_STRIP_W_R2_0/CTRL_OUT[6] A44_CDAC_CAP_BANK_ASSEMBLY_R8_M6_0/A44_CAP_CORE128_M6_R1_0/CAP_BOTTOM_123 GND nfet_03v3 ad=0 pd=0 as=16.6842p ps=77.76u w=1.56u l=0.28u
X3405 VREFN A44_DCTRL_STRIP_W_R2_0/CTRL_OUT[6] A44_CDAC_CAP_BANK_ASSEMBLY_R8_M6_0/A44_CAP_CORE128_M6_R1_0/CAP_BOTTOM_123 GND nfet_03v3 ad=0 pd=0 as=0 ps=0 w=1.56u l=0.28u
X3406 VREFN A44_DCTRL_STRIP_W_R2_0/CTRL_OUT[6] A44_CDAC_CAP_BANK_ASSEMBLY_R8_M6_0/A44_CAP_CORE128_M6_R1_0/CAP_BOTTOM_123 GND nfet_03v3 ad=0 pd=0 as=0 ps=0 w=1.56u l=0.28u
X3407 VREFN A44_DCTRL_STRIP_W_R2_0/CTRL_OUT[6] A44_CDAC_CAP_BANK_ASSEMBLY_R8_M6_0/A44_CAP_CORE128_M6_R1_0/CAP_BOTTOM_123 GND nfet_03v3 ad=0 pd=0 as=0 ps=0 w=1.56u l=0.28u
X3408 VREFN A44_DCTRL_STRIP_W_R2_0/CTRL_OUT[6] A44_CDAC_CAP_BANK_ASSEMBLY_R8_M6_0/A44_CAP_CORE128_M6_R1_0/CAP_BOTTOM_123 GND nfet_03v3 ad=0 pd=0 as=0 ps=0 w=1.56u l=0.28u
X3409 VREFN A44_DCTRL_STRIP_W_R2_0/CTRL_OUT[6] A44_CDAC_CAP_BANK_ASSEMBLY_R8_M6_0/A44_CAP_CORE128_M6_R1_0/CAP_BOTTOM_123 GND nfet_03v3 ad=0 pd=0 as=0 ps=0 w=1.56u l=0.28u
X3410 VREFN A44_DCTRL_STRIP_W_R2_0/CTRL_OUT[6] A44_CDAC_CAP_BANK_ASSEMBLY_R8_M6_0/A44_CAP_CORE128_M6_R1_0/CAP_BOTTOM_123 GND nfet_03v3 ad=0 pd=0 as=0 ps=0 w=1.56u l=0.28u
X3411 VREFN A44_DCTRL_STRIP_W_R2_0/CTRL_OUT[6] A44_CDAC_CAP_BANK_ASSEMBLY_R8_M6_0/A44_CAP_CORE128_M6_R1_0/CAP_BOTTOM_123 GND nfet_03v3 ad=0 pd=0 as=0 ps=0 w=1.56u l=0.28u
X3412 VREFN A44_DCTRL_STRIP_W_R2_0/CTRL_OUT[6] A44_CDAC_CAP_BANK_ASSEMBLY_R8_M6_0/A44_CAP_CORE128_M6_R1_0/CAP_BOTTOM_123 GND nfet_03v3 ad=0 pd=0 as=0 ps=0 w=1.56u l=0.28u
X3413 VREFN A44_DCTRL_STRIP_W_R2_0/CTRL_OUT[6] A44_CDAC_CAP_BANK_ASSEMBLY_R8_M6_0/A44_CAP_CORE128_M6_R1_0/CAP_BOTTOM_123 GND nfet_03v3 ad=0 pd=0 as=0 ps=0 w=1.56u l=0.28u
X3414 VREFN A44_DCTRL_STRIP_W_R2_0/CTRL_OUT[6] A44_CDAC_CAP_BANK_ASSEMBLY_R8_M6_0/A44_CAP_CORE128_M6_R1_0/CAP_BOTTOM_123 GND nfet_03v3 ad=0 pd=0 as=0 ps=0 w=1.56u l=0.28u
X3415 VREFN A44_DCTRL_STRIP_W_R2_0/CTRL_OUT[6] A44_CDAC_CAP_BANK_ASSEMBLY_R8_M6_0/A44_CAP_CORE128_M6_R1_0/CAP_BOTTOM_123 GND nfet_03v3 ad=0 pd=0 as=0 ps=0 w=1.56u l=0.28u
X3416 VREFN A44_DCTRL_STRIP_W_R2_0/CTRL_OUT[6] A44_CDAC_CAP_BANK_ASSEMBLY_R8_M6_0/A44_CAP_CORE128_M6_R1_0/CAP_BOTTOM_123 GND nfet_03v3 ad=0 pd=0 as=0 ps=0 w=1.56u l=0.28u
X3417 VREFN A44_DCTRL_STRIP_W_R2_0/CTRL_OUT[6] A44_CDAC_CAP_BANK_ASSEMBLY_R8_M6_0/A44_CAP_CORE128_M6_R1_0/CAP_BOTTOM_123 GND nfet_03v3 ad=0 pd=0 as=0 ps=0 w=1.56u l=0.28u
X3418 VREFN A44_DCTRL_STRIP_W_R2_0/CTRL_OUT[6] A44_CDAC_CAP_BANK_ASSEMBLY_R8_M6_0/A44_CAP_CORE128_M6_R1_0/CAP_BOTTOM_123 GND nfet_03v3 ad=0 pd=0 as=0 ps=0 w=1.56u l=0.28u
X3419 VREFN A44_DCTRL_STRIP_W_R2_0/CTRL_OUT[6] A44_CDAC_CAP_BANK_ASSEMBLY_R8_M6_0/A44_CAP_CORE128_M6_R1_0/CAP_BOTTOM_123 GND nfet_03v3 ad=0 pd=0 as=0 ps=0 w=1.56u l=0.28u
X3420 VREFN A44_DCTRL_STRIP_W_R2_0/CTRL_OUT[6] A44_CDAC_CAP_BANK_ASSEMBLY_R8_M6_0/A44_CAP_CORE128_M6_R1_0/CAP_BOTTOM_123 GND nfet_03v3 ad=0 pd=0 as=0 ps=0 w=1.56u l=0.28u
X3421 VREFN A44_DCTRL_STRIP_W_R2_0/CTRL_OUT[6] A44_CDAC_CAP_BANK_ASSEMBLY_R8_M6_0/A44_CAP_CORE128_M6_R1_0/CAP_BOTTOM_123 GND nfet_03v3 ad=0 pd=0 as=0 ps=0 w=1.56u l=0.28u
X3422 VREFP A44_DCTRL_STRIP_W_R2_0/CTRL_OUT[7] A44_CDAC_CAP_BANK_ASSEMBLY_R8_M6_0/A44_CAP_CORE128_M6_R1_0/CAP_BOTTOM_083 VDD pfet_03v3 ad=0 pd=0 as=16.6842p ps=77.76u w=1.56u l=0.28u
X3423 VREFP A44_DCTRL_STRIP_W_R2_0/CTRL_OUT[7] A44_CDAC_CAP_BANK_ASSEMBLY_R8_M6_0/A44_CAP_CORE128_M6_R1_0/CAP_BOTTOM_083 VDD pfet_03v3 ad=0 pd=0 as=0 ps=0 w=1.56u l=0.28u
X3424 VREFP A44_DCTRL_STRIP_W_R2_0/CTRL_OUT[7] A44_CDAC_CAP_BANK_ASSEMBLY_R8_M6_0/A44_CAP_CORE128_M6_R1_0/CAP_BOTTOM_083 VDD pfet_03v3 ad=0 pd=0 as=0 ps=0 w=1.56u l=0.28u
X3425 VREFP A44_DCTRL_STRIP_W_R2_0/CTRL_OUT[7] A44_CDAC_CAP_BANK_ASSEMBLY_R8_M6_0/A44_CAP_CORE128_M6_R1_0/CAP_BOTTOM_083 VDD pfet_03v3 ad=0 pd=0 as=0 ps=0 w=1.56u l=0.28u
X3426 VREFP A44_DCTRL_STRIP_W_R2_0/CTRL_OUT[7] A44_CDAC_CAP_BANK_ASSEMBLY_R8_M6_0/A44_CAP_CORE128_M6_R1_0/CAP_BOTTOM_083 VDD pfet_03v3 ad=0 pd=0 as=0 ps=0 w=1.56u l=0.28u
X3427 VREFP A44_DCTRL_STRIP_W_R2_0/CTRL_OUT[7] A44_CDAC_CAP_BANK_ASSEMBLY_R8_M6_0/A44_CAP_CORE128_M6_R1_0/CAP_BOTTOM_083 VDD pfet_03v3 ad=0 pd=0 as=0 ps=0 w=1.56u l=0.28u
X3428 VREFP A44_DCTRL_STRIP_W_R2_0/CTRL_OUT[7] A44_CDAC_CAP_BANK_ASSEMBLY_R8_M6_0/A44_CAP_CORE128_M6_R1_0/CAP_BOTTOM_083 VDD pfet_03v3 ad=0 pd=0 as=0 ps=0 w=1.56u l=0.28u
X3429 VREFP A44_DCTRL_STRIP_W_R2_0/CTRL_OUT[7] A44_CDAC_CAP_BANK_ASSEMBLY_R8_M6_0/A44_CAP_CORE128_M6_R1_0/CAP_BOTTOM_083 VDD pfet_03v3 ad=0 pd=0 as=0 ps=0 w=1.56u l=0.28u
X3430 VREFP A44_DCTRL_STRIP_W_R2_0/CTRL_OUT[7] A44_CDAC_CAP_BANK_ASSEMBLY_R8_M6_0/A44_CAP_CORE128_M6_R1_0/CAP_BOTTOM_083 VDD pfet_03v3 ad=0 pd=0 as=0 ps=0 w=1.56u l=0.28u
X3431 VREFP A44_DCTRL_STRIP_W_R2_0/CTRL_OUT[7] A44_CDAC_CAP_BANK_ASSEMBLY_R8_M6_0/A44_CAP_CORE128_M6_R1_0/CAP_BOTTOM_083 VDD pfet_03v3 ad=0 pd=0 as=0 ps=0 w=1.56u l=0.28u
X3432 VREFP A44_DCTRL_STRIP_W_R2_0/CTRL_OUT[7] A44_CDAC_CAP_BANK_ASSEMBLY_R8_M6_0/A44_CAP_CORE128_M6_R1_0/CAP_BOTTOM_083 VDD pfet_03v3 ad=0 pd=0 as=0 ps=0 w=1.56u l=0.28u
X3433 VREFP A44_DCTRL_STRIP_W_R2_0/CTRL_OUT[7] A44_CDAC_CAP_BANK_ASSEMBLY_R8_M6_0/A44_CAP_CORE128_M6_R1_0/CAP_BOTTOM_083 VDD pfet_03v3 ad=0 pd=0 as=0 ps=0 w=1.56u l=0.28u
X3434 VREFP A44_DCTRL_STRIP_W_R2_0/CTRL_OUT[7] A44_CDAC_CAP_BANK_ASSEMBLY_R8_M6_0/A44_CAP_CORE128_M6_R1_0/CAP_BOTTOM_083 VDD pfet_03v3 ad=0 pd=0 as=0 ps=0 w=1.56u l=0.28u
X3435 VREFP A44_DCTRL_STRIP_W_R2_0/CTRL_OUT[7] A44_CDAC_CAP_BANK_ASSEMBLY_R8_M6_0/A44_CAP_CORE128_M6_R1_0/CAP_BOTTOM_083 VDD pfet_03v3 ad=0 pd=0 as=0 ps=0 w=1.56u l=0.28u
X3436 VREFP A44_DCTRL_STRIP_W_R2_0/CTRL_OUT[7] A44_CDAC_CAP_BANK_ASSEMBLY_R8_M6_0/A44_CAP_CORE128_M6_R1_0/CAP_BOTTOM_083 VDD pfet_03v3 ad=0 pd=0 as=0 ps=0 w=1.56u l=0.28u
X3437 VREFP A44_DCTRL_STRIP_W_R2_0/CTRL_OUT[7] A44_CDAC_CAP_BANK_ASSEMBLY_R8_M6_0/A44_CAP_CORE128_M6_R1_0/CAP_BOTTOM_083 VDD pfet_03v3 ad=0 pd=0 as=0 ps=0 w=1.56u l=0.28u
X3438 VREFP A44_DCTRL_STRIP_W_R2_0/CTRL_OUT[7] A44_CDAC_CAP_BANK_ASSEMBLY_R8_M6_0/A44_CAP_CORE128_M6_R1_0/CAP_BOTTOM_083 VDD pfet_03v3 ad=0 pd=0 as=0 ps=0 w=1.56u l=0.28u
X3439 VREFP A44_DCTRL_STRIP_W_R2_0/CTRL_OUT[7] A44_CDAC_CAP_BANK_ASSEMBLY_R8_M6_0/A44_CAP_CORE128_M6_R1_0/CAP_BOTTOM_083 VDD pfet_03v3 ad=0 pd=0 as=0 ps=0 w=1.56u l=0.28u
X3440 VREFN A44_DCTRL_STRIP_W_R2_0/CTRL_OUT[7] A44_CDAC_CAP_BANK_ASSEMBLY_R8_M6_0/A44_CAP_CORE128_M6_R1_0/CAP_BOTTOM_083 GND nfet_03v3 ad=0 pd=0 as=16.6842p ps=77.76u w=1.56u l=0.28u
X3441 VREFN A44_DCTRL_STRIP_W_R2_0/CTRL_OUT[7] A44_CDAC_CAP_BANK_ASSEMBLY_R8_M6_0/A44_CAP_CORE128_M6_R1_0/CAP_BOTTOM_083 GND nfet_03v3 ad=0 pd=0 as=0 ps=0 w=1.56u l=0.28u
X3442 VREFN A44_DCTRL_STRIP_W_R2_0/CTRL_OUT[7] A44_CDAC_CAP_BANK_ASSEMBLY_R8_M6_0/A44_CAP_CORE128_M6_R1_0/CAP_BOTTOM_083 GND nfet_03v3 ad=0 pd=0 as=0 ps=0 w=1.56u l=0.28u
X3443 VREFN A44_DCTRL_STRIP_W_R2_0/CTRL_OUT[7] A44_CDAC_CAP_BANK_ASSEMBLY_R8_M6_0/A44_CAP_CORE128_M6_R1_0/CAP_BOTTOM_083 GND nfet_03v3 ad=0 pd=0 as=0 ps=0 w=1.56u l=0.28u
X3444 VREFN A44_DCTRL_STRIP_W_R2_0/CTRL_OUT[7] A44_CDAC_CAP_BANK_ASSEMBLY_R8_M6_0/A44_CAP_CORE128_M6_R1_0/CAP_BOTTOM_083 GND nfet_03v3 ad=0 pd=0 as=0 ps=0 w=1.56u l=0.28u
X3445 VREFN A44_DCTRL_STRIP_W_R2_0/CTRL_OUT[7] A44_CDAC_CAP_BANK_ASSEMBLY_R8_M6_0/A44_CAP_CORE128_M6_R1_0/CAP_BOTTOM_083 GND nfet_03v3 ad=0 pd=0 as=0 ps=0 w=1.56u l=0.28u
X3446 VREFN A44_DCTRL_STRIP_W_R2_0/CTRL_OUT[7] A44_CDAC_CAP_BANK_ASSEMBLY_R8_M6_0/A44_CAP_CORE128_M6_R1_0/CAP_BOTTOM_083 GND nfet_03v3 ad=0 pd=0 as=0 ps=0 w=1.56u l=0.28u
X3447 VREFN A44_DCTRL_STRIP_W_R2_0/CTRL_OUT[7] A44_CDAC_CAP_BANK_ASSEMBLY_R8_M6_0/A44_CAP_CORE128_M6_R1_0/CAP_BOTTOM_083 GND nfet_03v3 ad=0 pd=0 as=0 ps=0 w=1.56u l=0.28u
X3448 VREFN A44_DCTRL_STRIP_W_R2_0/CTRL_OUT[7] A44_CDAC_CAP_BANK_ASSEMBLY_R8_M6_0/A44_CAP_CORE128_M6_R1_0/CAP_BOTTOM_083 GND nfet_03v3 ad=0 pd=0 as=0 ps=0 w=1.56u l=0.28u
X3449 VREFN A44_DCTRL_STRIP_W_R2_0/CTRL_OUT[7] A44_CDAC_CAP_BANK_ASSEMBLY_R8_M6_0/A44_CAP_CORE128_M6_R1_0/CAP_BOTTOM_083 GND nfet_03v3 ad=0 pd=0 as=0 ps=0 w=1.56u l=0.28u
X3450 VREFN A44_DCTRL_STRIP_W_R2_0/CTRL_OUT[7] A44_CDAC_CAP_BANK_ASSEMBLY_R8_M6_0/A44_CAP_CORE128_M6_R1_0/CAP_BOTTOM_083 GND nfet_03v3 ad=0 pd=0 as=0 ps=0 w=1.56u l=0.28u
X3451 VREFN A44_DCTRL_STRIP_W_R2_0/CTRL_OUT[7] A44_CDAC_CAP_BANK_ASSEMBLY_R8_M6_0/A44_CAP_CORE128_M6_R1_0/CAP_BOTTOM_083 GND nfet_03v3 ad=0 pd=0 as=0 ps=0 w=1.56u l=0.28u
X3452 VREFN A44_DCTRL_STRIP_W_R2_0/CTRL_OUT[7] A44_CDAC_CAP_BANK_ASSEMBLY_R8_M6_0/A44_CAP_CORE128_M6_R1_0/CAP_BOTTOM_083 GND nfet_03v3 ad=0 pd=0 as=0 ps=0 w=1.56u l=0.28u
X3453 VREFN A44_DCTRL_STRIP_W_R2_0/CTRL_OUT[7] A44_CDAC_CAP_BANK_ASSEMBLY_R8_M6_0/A44_CAP_CORE128_M6_R1_0/CAP_BOTTOM_083 GND nfet_03v3 ad=0 pd=0 as=0 ps=0 w=1.56u l=0.28u
X3454 VREFN A44_DCTRL_STRIP_W_R2_0/CTRL_OUT[7] A44_CDAC_CAP_BANK_ASSEMBLY_R8_M6_0/A44_CAP_CORE128_M6_R1_0/CAP_BOTTOM_083 GND nfet_03v3 ad=0 pd=0 as=0 ps=0 w=1.56u l=0.28u
X3455 VREFN A44_DCTRL_STRIP_W_R2_0/CTRL_OUT[7] A44_CDAC_CAP_BANK_ASSEMBLY_R8_M6_0/A44_CAP_CORE128_M6_R1_0/CAP_BOTTOM_083 GND nfet_03v3 ad=0 pd=0 as=0 ps=0 w=1.56u l=0.28u
X3456 VREFN A44_DCTRL_STRIP_W_R2_0/CTRL_OUT[7] A44_CDAC_CAP_BANK_ASSEMBLY_R8_M6_0/A44_CAP_CORE128_M6_R1_0/CAP_BOTTOM_083 GND nfet_03v3 ad=0 pd=0 as=0 ps=0 w=1.56u l=0.28u
X3457 VREFN A44_DCTRL_STRIP_W_R2_0/CTRL_OUT[7] A44_CDAC_CAP_BANK_ASSEMBLY_R8_M6_0/A44_CAP_CORE128_M6_R1_0/CAP_BOTTOM_083 GND nfet_03v3 ad=0 pd=0 as=0 ps=0 w=1.56u l=0.28u
X3458 VREFP A44_DCTRL_STRIP_W_R2_0/CTRL_OUT[7] A44_CDAC_CAP_BANK_ASSEMBLY_R8_M6_0/A44_CAP_CORE128_M6_R1_0/CAP_BOTTOM_109 VDD pfet_03v3 ad=0 pd=0 as=16.6842p ps=77.76u w=1.56u l=0.28u
X3459 VREFP A44_DCTRL_STRIP_W_R2_0/CTRL_OUT[7] A44_CDAC_CAP_BANK_ASSEMBLY_R8_M6_0/A44_CAP_CORE128_M6_R1_0/CAP_BOTTOM_109 VDD pfet_03v3 ad=0 pd=0 as=0 ps=0 w=1.56u l=0.28u
X3460 VREFP A44_DCTRL_STRIP_W_R2_0/CTRL_OUT[7] A44_CDAC_CAP_BANK_ASSEMBLY_R8_M6_0/A44_CAP_CORE128_M6_R1_0/CAP_BOTTOM_109 VDD pfet_03v3 ad=0 pd=0 as=0 ps=0 w=1.56u l=0.28u
X3461 VREFP A44_DCTRL_STRIP_W_R2_0/CTRL_OUT[7] A44_CDAC_CAP_BANK_ASSEMBLY_R8_M6_0/A44_CAP_CORE128_M6_R1_0/CAP_BOTTOM_109 VDD pfet_03v3 ad=0 pd=0 as=0 ps=0 w=1.56u l=0.28u
X3462 VREFP A44_DCTRL_STRIP_W_R2_0/CTRL_OUT[7] A44_CDAC_CAP_BANK_ASSEMBLY_R8_M6_0/A44_CAP_CORE128_M6_R1_0/CAP_BOTTOM_109 VDD pfet_03v3 ad=0 pd=0 as=0 ps=0 w=1.56u l=0.28u
X3463 VREFP A44_DCTRL_STRIP_W_R2_0/CTRL_OUT[7] A44_CDAC_CAP_BANK_ASSEMBLY_R8_M6_0/A44_CAP_CORE128_M6_R1_0/CAP_BOTTOM_109 VDD pfet_03v3 ad=0 pd=0 as=0 ps=0 w=1.56u l=0.28u
X3464 VREFP A44_DCTRL_STRIP_W_R2_0/CTRL_OUT[7] A44_CDAC_CAP_BANK_ASSEMBLY_R8_M6_0/A44_CAP_CORE128_M6_R1_0/CAP_BOTTOM_109 VDD pfet_03v3 ad=0 pd=0 as=0 ps=0 w=1.56u l=0.28u
X3465 VREFP A44_DCTRL_STRIP_W_R2_0/CTRL_OUT[7] A44_CDAC_CAP_BANK_ASSEMBLY_R8_M6_0/A44_CAP_CORE128_M6_R1_0/CAP_BOTTOM_109 VDD pfet_03v3 ad=0 pd=0 as=0 ps=0 w=1.56u l=0.28u
X3466 VREFP A44_DCTRL_STRIP_W_R2_0/CTRL_OUT[7] A44_CDAC_CAP_BANK_ASSEMBLY_R8_M6_0/A44_CAP_CORE128_M6_R1_0/CAP_BOTTOM_109 VDD pfet_03v3 ad=0 pd=0 as=0 ps=0 w=1.56u l=0.28u
X3467 VREFP A44_DCTRL_STRIP_W_R2_0/CTRL_OUT[7] A44_CDAC_CAP_BANK_ASSEMBLY_R8_M6_0/A44_CAP_CORE128_M6_R1_0/CAP_BOTTOM_109 VDD pfet_03v3 ad=0 pd=0 as=0 ps=0 w=1.56u l=0.28u
X3468 VREFP A44_DCTRL_STRIP_W_R2_0/CTRL_OUT[7] A44_CDAC_CAP_BANK_ASSEMBLY_R8_M6_0/A44_CAP_CORE128_M6_R1_0/CAP_BOTTOM_109 VDD pfet_03v3 ad=0 pd=0 as=0 ps=0 w=1.56u l=0.28u
X3469 VREFP A44_DCTRL_STRIP_W_R2_0/CTRL_OUT[7] A44_CDAC_CAP_BANK_ASSEMBLY_R8_M6_0/A44_CAP_CORE128_M6_R1_0/CAP_BOTTOM_109 VDD pfet_03v3 ad=0 pd=0 as=0 ps=0 w=1.56u l=0.28u
X3470 VREFP A44_DCTRL_STRIP_W_R2_0/CTRL_OUT[7] A44_CDAC_CAP_BANK_ASSEMBLY_R8_M6_0/A44_CAP_CORE128_M6_R1_0/CAP_BOTTOM_109 VDD pfet_03v3 ad=0 pd=0 as=0 ps=0 w=1.56u l=0.28u
X3471 VREFP A44_DCTRL_STRIP_W_R2_0/CTRL_OUT[7] A44_CDAC_CAP_BANK_ASSEMBLY_R8_M6_0/A44_CAP_CORE128_M6_R1_0/CAP_BOTTOM_109 VDD pfet_03v3 ad=0 pd=0 as=0 ps=0 w=1.56u l=0.28u
X3472 VREFP A44_DCTRL_STRIP_W_R2_0/CTRL_OUT[7] A44_CDAC_CAP_BANK_ASSEMBLY_R8_M6_0/A44_CAP_CORE128_M6_R1_0/CAP_BOTTOM_109 VDD pfet_03v3 ad=0 pd=0 as=0 ps=0 w=1.56u l=0.28u
X3473 VREFP A44_DCTRL_STRIP_W_R2_0/CTRL_OUT[7] A44_CDAC_CAP_BANK_ASSEMBLY_R8_M6_0/A44_CAP_CORE128_M6_R1_0/CAP_BOTTOM_109 VDD pfet_03v3 ad=0 pd=0 as=0 ps=0 w=1.56u l=0.28u
X3474 VREFP A44_DCTRL_STRIP_W_R2_0/CTRL_OUT[7] A44_CDAC_CAP_BANK_ASSEMBLY_R8_M6_0/A44_CAP_CORE128_M6_R1_0/CAP_BOTTOM_109 VDD pfet_03v3 ad=0 pd=0 as=0 ps=0 w=1.56u l=0.28u
X3475 VREFP A44_DCTRL_STRIP_W_R2_0/CTRL_OUT[7] A44_CDAC_CAP_BANK_ASSEMBLY_R8_M6_0/A44_CAP_CORE128_M6_R1_0/CAP_BOTTOM_109 VDD pfet_03v3 ad=0 pd=0 as=0 ps=0 w=1.56u l=0.28u
X3476 VREFN A44_DCTRL_STRIP_W_R2_0/CTRL_OUT[7] A44_CDAC_CAP_BANK_ASSEMBLY_R8_M6_0/A44_CAP_CORE128_M6_R1_0/CAP_BOTTOM_109 GND nfet_03v3 ad=0 pd=0 as=16.6842p ps=77.76u w=1.56u l=0.28u
X3477 VREFN A44_DCTRL_STRIP_W_R2_0/CTRL_OUT[7] A44_CDAC_CAP_BANK_ASSEMBLY_R8_M6_0/A44_CAP_CORE128_M6_R1_0/CAP_BOTTOM_109 GND nfet_03v3 ad=0 pd=0 as=0 ps=0 w=1.56u l=0.28u
X3478 VREFN A44_DCTRL_STRIP_W_R2_0/CTRL_OUT[7] A44_CDAC_CAP_BANK_ASSEMBLY_R8_M6_0/A44_CAP_CORE128_M6_R1_0/CAP_BOTTOM_109 GND nfet_03v3 ad=0 pd=0 as=0 ps=0 w=1.56u l=0.28u
X3479 VREFN A44_DCTRL_STRIP_W_R2_0/CTRL_OUT[7] A44_CDAC_CAP_BANK_ASSEMBLY_R8_M6_0/A44_CAP_CORE128_M6_R1_0/CAP_BOTTOM_109 GND nfet_03v3 ad=0 pd=0 as=0 ps=0 w=1.56u l=0.28u
X3480 VREFN A44_DCTRL_STRIP_W_R2_0/CTRL_OUT[7] A44_CDAC_CAP_BANK_ASSEMBLY_R8_M6_0/A44_CAP_CORE128_M6_R1_0/CAP_BOTTOM_109 GND nfet_03v3 ad=0 pd=0 as=0 ps=0 w=1.56u l=0.28u
X3481 VREFN A44_DCTRL_STRIP_W_R2_0/CTRL_OUT[7] A44_CDAC_CAP_BANK_ASSEMBLY_R8_M6_0/A44_CAP_CORE128_M6_R1_0/CAP_BOTTOM_109 GND nfet_03v3 ad=0 pd=0 as=0 ps=0 w=1.56u l=0.28u
X3482 VREFN A44_DCTRL_STRIP_W_R2_0/CTRL_OUT[7] A44_CDAC_CAP_BANK_ASSEMBLY_R8_M6_0/A44_CAP_CORE128_M6_R1_0/CAP_BOTTOM_109 GND nfet_03v3 ad=0 pd=0 as=0 ps=0 w=1.56u l=0.28u
X3483 VREFN A44_DCTRL_STRIP_W_R2_0/CTRL_OUT[7] A44_CDAC_CAP_BANK_ASSEMBLY_R8_M6_0/A44_CAP_CORE128_M6_R1_0/CAP_BOTTOM_109 GND nfet_03v3 ad=0 pd=0 as=0 ps=0 w=1.56u l=0.28u
X3484 VREFN A44_DCTRL_STRIP_W_R2_0/CTRL_OUT[7] A44_CDAC_CAP_BANK_ASSEMBLY_R8_M6_0/A44_CAP_CORE128_M6_R1_0/CAP_BOTTOM_109 GND nfet_03v3 ad=0 pd=0 as=0 ps=0 w=1.56u l=0.28u
X3485 VREFN A44_DCTRL_STRIP_W_R2_0/CTRL_OUT[7] A44_CDAC_CAP_BANK_ASSEMBLY_R8_M6_0/A44_CAP_CORE128_M6_R1_0/CAP_BOTTOM_109 GND nfet_03v3 ad=0 pd=0 as=0 ps=0 w=1.56u l=0.28u
X3486 VREFN A44_DCTRL_STRIP_W_R2_0/CTRL_OUT[7] A44_CDAC_CAP_BANK_ASSEMBLY_R8_M6_0/A44_CAP_CORE128_M6_R1_0/CAP_BOTTOM_109 GND nfet_03v3 ad=0 pd=0 as=0 ps=0 w=1.56u l=0.28u
X3487 VREFN A44_DCTRL_STRIP_W_R2_0/CTRL_OUT[7] A44_CDAC_CAP_BANK_ASSEMBLY_R8_M6_0/A44_CAP_CORE128_M6_R1_0/CAP_BOTTOM_109 GND nfet_03v3 ad=0 pd=0 as=0 ps=0 w=1.56u l=0.28u
X3488 VREFN A44_DCTRL_STRIP_W_R2_0/CTRL_OUT[7] A44_CDAC_CAP_BANK_ASSEMBLY_R8_M6_0/A44_CAP_CORE128_M6_R1_0/CAP_BOTTOM_109 GND nfet_03v3 ad=0 pd=0 as=0 ps=0 w=1.56u l=0.28u
X3489 VREFN A44_DCTRL_STRIP_W_R2_0/CTRL_OUT[7] A44_CDAC_CAP_BANK_ASSEMBLY_R8_M6_0/A44_CAP_CORE128_M6_R1_0/CAP_BOTTOM_109 GND nfet_03v3 ad=0 pd=0 as=0 ps=0 w=1.56u l=0.28u
X3490 VREFN A44_DCTRL_STRIP_W_R2_0/CTRL_OUT[7] A44_CDAC_CAP_BANK_ASSEMBLY_R8_M6_0/A44_CAP_CORE128_M6_R1_0/CAP_BOTTOM_109 GND nfet_03v3 ad=0 pd=0 as=0 ps=0 w=1.56u l=0.28u
X3491 VREFN A44_DCTRL_STRIP_W_R2_0/CTRL_OUT[7] A44_CDAC_CAP_BANK_ASSEMBLY_R8_M6_0/A44_CAP_CORE128_M6_R1_0/CAP_BOTTOM_109 GND nfet_03v3 ad=0 pd=0 as=0 ps=0 w=1.56u l=0.28u
X3492 VREFN A44_DCTRL_STRIP_W_R2_0/CTRL_OUT[7] A44_CDAC_CAP_BANK_ASSEMBLY_R8_M6_0/A44_CAP_CORE128_M6_R1_0/CAP_BOTTOM_109 GND nfet_03v3 ad=0 pd=0 as=0 ps=0 w=1.56u l=0.28u
X3493 VREFN A44_DCTRL_STRIP_W_R2_0/CTRL_OUT[7] A44_CDAC_CAP_BANK_ASSEMBLY_R8_M6_0/A44_CAP_CORE128_M6_R1_0/CAP_BOTTOM_109 GND nfet_03v3 ad=0 pd=0 as=0 ps=0 w=1.56u l=0.28u
X3494 VREFP A44_DCTRL_STRIP_W_R2_0/CTRL_OUT[6] A44_CDAC_CAP_BANK_ASSEMBLY_R8_M6_0/A44_CAP_CORE128_M6_R1_0/CAP_BOTTOM_073 VDD pfet_03v3 ad=0 pd=0 as=16.6842p ps=77.76u w=1.56u l=0.28u
X3495 VREFP A44_DCTRL_STRIP_W_R2_0/CTRL_OUT[6] A44_CDAC_CAP_BANK_ASSEMBLY_R8_M6_0/A44_CAP_CORE128_M6_R1_0/CAP_BOTTOM_073 VDD pfet_03v3 ad=0 pd=0 as=0 ps=0 w=1.56u l=0.28u
X3496 VREFP A44_DCTRL_STRIP_W_R2_0/CTRL_OUT[6] A44_CDAC_CAP_BANK_ASSEMBLY_R8_M6_0/A44_CAP_CORE128_M6_R1_0/CAP_BOTTOM_073 VDD pfet_03v3 ad=0 pd=0 as=0 ps=0 w=1.56u l=0.28u
X3497 VREFP A44_DCTRL_STRIP_W_R2_0/CTRL_OUT[6] A44_CDAC_CAP_BANK_ASSEMBLY_R8_M6_0/A44_CAP_CORE128_M6_R1_0/CAP_BOTTOM_073 VDD pfet_03v3 ad=0 pd=0 as=0 ps=0 w=1.56u l=0.28u
X3498 VREFP A44_DCTRL_STRIP_W_R2_0/CTRL_OUT[6] A44_CDAC_CAP_BANK_ASSEMBLY_R8_M6_0/A44_CAP_CORE128_M6_R1_0/CAP_BOTTOM_073 VDD pfet_03v3 ad=0 pd=0 as=0 ps=0 w=1.56u l=0.28u
X3499 VREFP A44_DCTRL_STRIP_W_R2_0/CTRL_OUT[6] A44_CDAC_CAP_BANK_ASSEMBLY_R8_M6_0/A44_CAP_CORE128_M6_R1_0/CAP_BOTTOM_073 VDD pfet_03v3 ad=0 pd=0 as=0 ps=0 w=1.56u l=0.28u
X3500 VREFP A44_DCTRL_STRIP_W_R2_0/CTRL_OUT[6] A44_CDAC_CAP_BANK_ASSEMBLY_R8_M6_0/A44_CAP_CORE128_M6_R1_0/CAP_BOTTOM_073 VDD pfet_03v3 ad=0 pd=0 as=0 ps=0 w=1.56u l=0.28u
X3501 VREFP A44_DCTRL_STRIP_W_R2_0/CTRL_OUT[6] A44_CDAC_CAP_BANK_ASSEMBLY_R8_M6_0/A44_CAP_CORE128_M6_R1_0/CAP_BOTTOM_073 VDD pfet_03v3 ad=0 pd=0 as=0 ps=0 w=1.56u l=0.28u
X3502 VREFP A44_DCTRL_STRIP_W_R2_0/CTRL_OUT[6] A44_CDAC_CAP_BANK_ASSEMBLY_R8_M6_0/A44_CAP_CORE128_M6_R1_0/CAP_BOTTOM_073 VDD pfet_03v3 ad=0 pd=0 as=0 ps=0 w=1.56u l=0.28u
X3503 VREFP A44_DCTRL_STRIP_W_R2_0/CTRL_OUT[6] A44_CDAC_CAP_BANK_ASSEMBLY_R8_M6_0/A44_CAP_CORE128_M6_R1_0/CAP_BOTTOM_073 VDD pfet_03v3 ad=0 pd=0 as=0 ps=0 w=1.56u l=0.28u
X3504 VREFP A44_DCTRL_STRIP_W_R2_0/CTRL_OUT[6] A44_CDAC_CAP_BANK_ASSEMBLY_R8_M6_0/A44_CAP_CORE128_M6_R1_0/CAP_BOTTOM_073 VDD pfet_03v3 ad=0 pd=0 as=0 ps=0 w=1.56u l=0.28u
X3505 VREFP A44_DCTRL_STRIP_W_R2_0/CTRL_OUT[6] A44_CDAC_CAP_BANK_ASSEMBLY_R8_M6_0/A44_CAP_CORE128_M6_R1_0/CAP_BOTTOM_073 VDD pfet_03v3 ad=0 pd=0 as=0 ps=0 w=1.56u l=0.28u
X3506 VREFP A44_DCTRL_STRIP_W_R2_0/CTRL_OUT[6] A44_CDAC_CAP_BANK_ASSEMBLY_R8_M6_0/A44_CAP_CORE128_M6_R1_0/CAP_BOTTOM_073 VDD pfet_03v3 ad=0 pd=0 as=0 ps=0 w=1.56u l=0.28u
X3507 VREFP A44_DCTRL_STRIP_W_R2_0/CTRL_OUT[6] A44_CDAC_CAP_BANK_ASSEMBLY_R8_M6_0/A44_CAP_CORE128_M6_R1_0/CAP_BOTTOM_073 VDD pfet_03v3 ad=0 pd=0 as=0 ps=0 w=1.56u l=0.28u
X3508 VREFP A44_DCTRL_STRIP_W_R2_0/CTRL_OUT[6] A44_CDAC_CAP_BANK_ASSEMBLY_R8_M6_0/A44_CAP_CORE128_M6_R1_0/CAP_BOTTOM_073 VDD pfet_03v3 ad=0 pd=0 as=0 ps=0 w=1.56u l=0.28u
X3509 VREFP A44_DCTRL_STRIP_W_R2_0/CTRL_OUT[6] A44_CDAC_CAP_BANK_ASSEMBLY_R8_M6_0/A44_CAP_CORE128_M6_R1_0/CAP_BOTTOM_073 VDD pfet_03v3 ad=0 pd=0 as=0 ps=0 w=1.56u l=0.28u
X3510 VREFP A44_DCTRL_STRIP_W_R2_0/CTRL_OUT[6] A44_CDAC_CAP_BANK_ASSEMBLY_R8_M6_0/A44_CAP_CORE128_M6_R1_0/CAP_BOTTOM_073 VDD pfet_03v3 ad=0 pd=0 as=0 ps=0 w=1.56u l=0.28u
X3511 VREFP A44_DCTRL_STRIP_W_R2_0/CTRL_OUT[6] A44_CDAC_CAP_BANK_ASSEMBLY_R8_M6_0/A44_CAP_CORE128_M6_R1_0/CAP_BOTTOM_073 VDD pfet_03v3 ad=0 pd=0 as=0 ps=0 w=1.56u l=0.28u
X3512 VREFN A44_DCTRL_STRIP_W_R2_0/CTRL_OUT[6] A44_CDAC_CAP_BANK_ASSEMBLY_R8_M6_0/A44_CAP_CORE128_M6_R1_0/CAP_BOTTOM_073 GND nfet_03v3 ad=0 pd=0 as=16.6842p ps=77.76u w=1.56u l=0.28u
X3513 VREFN A44_DCTRL_STRIP_W_R2_0/CTRL_OUT[6] A44_CDAC_CAP_BANK_ASSEMBLY_R8_M6_0/A44_CAP_CORE128_M6_R1_0/CAP_BOTTOM_073 GND nfet_03v3 ad=0 pd=0 as=0 ps=0 w=1.56u l=0.28u
X3514 VREFN A44_DCTRL_STRIP_W_R2_0/CTRL_OUT[6] A44_CDAC_CAP_BANK_ASSEMBLY_R8_M6_0/A44_CAP_CORE128_M6_R1_0/CAP_BOTTOM_073 GND nfet_03v3 ad=0 pd=0 as=0 ps=0 w=1.56u l=0.28u
X3515 VREFN A44_DCTRL_STRIP_W_R2_0/CTRL_OUT[6] A44_CDAC_CAP_BANK_ASSEMBLY_R8_M6_0/A44_CAP_CORE128_M6_R1_0/CAP_BOTTOM_073 GND nfet_03v3 ad=0 pd=0 as=0 ps=0 w=1.56u l=0.28u
X3516 VREFN A44_DCTRL_STRIP_W_R2_0/CTRL_OUT[6] A44_CDAC_CAP_BANK_ASSEMBLY_R8_M6_0/A44_CAP_CORE128_M6_R1_0/CAP_BOTTOM_073 GND nfet_03v3 ad=0 pd=0 as=0 ps=0 w=1.56u l=0.28u
X3517 VREFN A44_DCTRL_STRIP_W_R2_0/CTRL_OUT[6] A44_CDAC_CAP_BANK_ASSEMBLY_R8_M6_0/A44_CAP_CORE128_M6_R1_0/CAP_BOTTOM_073 GND nfet_03v3 ad=0 pd=0 as=0 ps=0 w=1.56u l=0.28u
X3518 VREFN A44_DCTRL_STRIP_W_R2_0/CTRL_OUT[6] A44_CDAC_CAP_BANK_ASSEMBLY_R8_M6_0/A44_CAP_CORE128_M6_R1_0/CAP_BOTTOM_073 GND nfet_03v3 ad=0 pd=0 as=0 ps=0 w=1.56u l=0.28u
X3519 VREFN A44_DCTRL_STRIP_W_R2_0/CTRL_OUT[6] A44_CDAC_CAP_BANK_ASSEMBLY_R8_M6_0/A44_CAP_CORE128_M6_R1_0/CAP_BOTTOM_073 GND nfet_03v3 ad=0 pd=0 as=0 ps=0 w=1.56u l=0.28u
X3520 VREFN A44_DCTRL_STRIP_W_R2_0/CTRL_OUT[6] A44_CDAC_CAP_BANK_ASSEMBLY_R8_M6_0/A44_CAP_CORE128_M6_R1_0/CAP_BOTTOM_073 GND nfet_03v3 ad=0 pd=0 as=0 ps=0 w=1.56u l=0.28u
X3521 VREFN A44_DCTRL_STRIP_W_R2_0/CTRL_OUT[6] A44_CDAC_CAP_BANK_ASSEMBLY_R8_M6_0/A44_CAP_CORE128_M6_R1_0/CAP_BOTTOM_073 GND nfet_03v3 ad=0 pd=0 as=0 ps=0 w=1.56u l=0.28u
X3522 VREFN A44_DCTRL_STRIP_W_R2_0/CTRL_OUT[6] A44_CDAC_CAP_BANK_ASSEMBLY_R8_M6_0/A44_CAP_CORE128_M6_R1_0/CAP_BOTTOM_073 GND nfet_03v3 ad=0 pd=0 as=0 ps=0 w=1.56u l=0.28u
X3523 VREFN A44_DCTRL_STRIP_W_R2_0/CTRL_OUT[6] A44_CDAC_CAP_BANK_ASSEMBLY_R8_M6_0/A44_CAP_CORE128_M6_R1_0/CAP_BOTTOM_073 GND nfet_03v3 ad=0 pd=0 as=0 ps=0 w=1.56u l=0.28u
X3524 VREFN A44_DCTRL_STRIP_W_R2_0/CTRL_OUT[6] A44_CDAC_CAP_BANK_ASSEMBLY_R8_M6_0/A44_CAP_CORE128_M6_R1_0/CAP_BOTTOM_073 GND nfet_03v3 ad=0 pd=0 as=0 ps=0 w=1.56u l=0.28u
X3525 VREFN A44_DCTRL_STRIP_W_R2_0/CTRL_OUT[6] A44_CDAC_CAP_BANK_ASSEMBLY_R8_M6_0/A44_CAP_CORE128_M6_R1_0/CAP_BOTTOM_073 GND nfet_03v3 ad=0 pd=0 as=0 ps=0 w=1.56u l=0.28u
X3526 VREFN A44_DCTRL_STRIP_W_R2_0/CTRL_OUT[6] A44_CDAC_CAP_BANK_ASSEMBLY_R8_M6_0/A44_CAP_CORE128_M6_R1_0/CAP_BOTTOM_073 GND nfet_03v3 ad=0 pd=0 as=0 ps=0 w=1.56u l=0.28u
X3527 VREFN A44_DCTRL_STRIP_W_R2_0/CTRL_OUT[6] A44_CDAC_CAP_BANK_ASSEMBLY_R8_M6_0/A44_CAP_CORE128_M6_R1_0/CAP_BOTTOM_073 GND nfet_03v3 ad=0 pd=0 as=0 ps=0 w=1.56u l=0.28u
X3528 VREFN A44_DCTRL_STRIP_W_R2_0/CTRL_OUT[6] A44_CDAC_CAP_BANK_ASSEMBLY_R8_M6_0/A44_CAP_CORE128_M6_R1_0/CAP_BOTTOM_073 GND nfet_03v3 ad=0 pd=0 as=0 ps=0 w=1.56u l=0.28u
X3529 VREFN A44_DCTRL_STRIP_W_R2_0/CTRL_OUT[6] A44_CDAC_CAP_BANK_ASSEMBLY_R8_M6_0/A44_CAP_CORE128_M6_R1_0/CAP_BOTTOM_073 GND nfet_03v3 ad=0 pd=0 as=0 ps=0 w=1.56u l=0.28u
X3530 VREFP A44_DCTRL_STRIP_W_R2_0/CTRL_OUT[7] A44_CDAC_CAP_BANK_ASSEMBLY_R8_M6_0/A44_CAP_CORE128_M6_R1_0/CAP_BOTTOM_071 VDD pfet_03v3 ad=0 pd=0 as=16.6842p ps=77.76u w=1.56u l=0.28u
X3531 VREFP A44_DCTRL_STRIP_W_R2_0/CTRL_OUT[7] A44_CDAC_CAP_BANK_ASSEMBLY_R8_M6_0/A44_CAP_CORE128_M6_R1_0/CAP_BOTTOM_071 VDD pfet_03v3 ad=0 pd=0 as=0 ps=0 w=1.56u l=0.28u
X3532 VREFP A44_DCTRL_STRIP_W_R2_0/CTRL_OUT[7] A44_CDAC_CAP_BANK_ASSEMBLY_R8_M6_0/A44_CAP_CORE128_M6_R1_0/CAP_BOTTOM_071 VDD pfet_03v3 ad=0 pd=0 as=0 ps=0 w=1.56u l=0.28u
X3533 VREFP A44_DCTRL_STRIP_W_R2_0/CTRL_OUT[7] A44_CDAC_CAP_BANK_ASSEMBLY_R8_M6_0/A44_CAP_CORE128_M6_R1_0/CAP_BOTTOM_071 VDD pfet_03v3 ad=0 pd=0 as=0 ps=0 w=1.56u l=0.28u
X3534 VREFP A44_DCTRL_STRIP_W_R2_0/CTRL_OUT[7] A44_CDAC_CAP_BANK_ASSEMBLY_R8_M6_0/A44_CAP_CORE128_M6_R1_0/CAP_BOTTOM_071 VDD pfet_03v3 ad=0 pd=0 as=0 ps=0 w=1.56u l=0.28u
X3535 VREFP A44_DCTRL_STRIP_W_R2_0/CTRL_OUT[7] A44_CDAC_CAP_BANK_ASSEMBLY_R8_M6_0/A44_CAP_CORE128_M6_R1_0/CAP_BOTTOM_071 VDD pfet_03v3 ad=0 pd=0 as=0 ps=0 w=1.56u l=0.28u
X3536 VREFP A44_DCTRL_STRIP_W_R2_0/CTRL_OUT[7] A44_CDAC_CAP_BANK_ASSEMBLY_R8_M6_0/A44_CAP_CORE128_M6_R1_0/CAP_BOTTOM_071 VDD pfet_03v3 ad=0 pd=0 as=0 ps=0 w=1.56u l=0.28u
X3537 VREFP A44_DCTRL_STRIP_W_R2_0/CTRL_OUT[7] A44_CDAC_CAP_BANK_ASSEMBLY_R8_M6_0/A44_CAP_CORE128_M6_R1_0/CAP_BOTTOM_071 VDD pfet_03v3 ad=0 pd=0 as=0 ps=0 w=1.56u l=0.28u
X3538 VREFP A44_DCTRL_STRIP_W_R2_0/CTRL_OUT[7] A44_CDAC_CAP_BANK_ASSEMBLY_R8_M6_0/A44_CAP_CORE128_M6_R1_0/CAP_BOTTOM_071 VDD pfet_03v3 ad=0 pd=0 as=0 ps=0 w=1.56u l=0.28u
X3539 VREFP A44_DCTRL_STRIP_W_R2_0/CTRL_OUT[7] A44_CDAC_CAP_BANK_ASSEMBLY_R8_M6_0/A44_CAP_CORE128_M6_R1_0/CAP_BOTTOM_071 VDD pfet_03v3 ad=0 pd=0 as=0 ps=0 w=1.56u l=0.28u
X3540 VREFP A44_DCTRL_STRIP_W_R2_0/CTRL_OUT[7] A44_CDAC_CAP_BANK_ASSEMBLY_R8_M6_0/A44_CAP_CORE128_M6_R1_0/CAP_BOTTOM_071 VDD pfet_03v3 ad=0 pd=0 as=0 ps=0 w=1.56u l=0.28u
X3541 VREFP A44_DCTRL_STRIP_W_R2_0/CTRL_OUT[7] A44_CDAC_CAP_BANK_ASSEMBLY_R8_M6_0/A44_CAP_CORE128_M6_R1_0/CAP_BOTTOM_071 VDD pfet_03v3 ad=0 pd=0 as=0 ps=0 w=1.56u l=0.28u
X3542 VREFP A44_DCTRL_STRIP_W_R2_0/CTRL_OUT[7] A44_CDAC_CAP_BANK_ASSEMBLY_R8_M6_0/A44_CAP_CORE128_M6_R1_0/CAP_BOTTOM_071 VDD pfet_03v3 ad=0 pd=0 as=0 ps=0 w=1.56u l=0.28u
X3543 VREFP A44_DCTRL_STRIP_W_R2_0/CTRL_OUT[7] A44_CDAC_CAP_BANK_ASSEMBLY_R8_M6_0/A44_CAP_CORE128_M6_R1_0/CAP_BOTTOM_071 VDD pfet_03v3 ad=0 pd=0 as=0 ps=0 w=1.56u l=0.28u
X3544 VREFP A44_DCTRL_STRIP_W_R2_0/CTRL_OUT[7] A44_CDAC_CAP_BANK_ASSEMBLY_R8_M6_0/A44_CAP_CORE128_M6_R1_0/CAP_BOTTOM_071 VDD pfet_03v3 ad=0 pd=0 as=0 ps=0 w=1.56u l=0.28u
X3545 VREFP A44_DCTRL_STRIP_W_R2_0/CTRL_OUT[7] A44_CDAC_CAP_BANK_ASSEMBLY_R8_M6_0/A44_CAP_CORE128_M6_R1_0/CAP_BOTTOM_071 VDD pfet_03v3 ad=0 pd=0 as=0 ps=0 w=1.56u l=0.28u
X3546 VREFP A44_DCTRL_STRIP_W_R2_0/CTRL_OUT[7] A44_CDAC_CAP_BANK_ASSEMBLY_R8_M6_0/A44_CAP_CORE128_M6_R1_0/CAP_BOTTOM_071 VDD pfet_03v3 ad=0 pd=0 as=0 ps=0 w=1.56u l=0.28u
X3547 VREFP A44_DCTRL_STRIP_W_R2_0/CTRL_OUT[7] A44_CDAC_CAP_BANK_ASSEMBLY_R8_M6_0/A44_CAP_CORE128_M6_R1_0/CAP_BOTTOM_071 VDD pfet_03v3 ad=0 pd=0 as=0 ps=0 w=1.56u l=0.28u
X3548 VREFN A44_DCTRL_STRIP_W_R2_0/CTRL_OUT[7] A44_CDAC_CAP_BANK_ASSEMBLY_R8_M6_0/A44_CAP_CORE128_M6_R1_0/CAP_BOTTOM_071 GND nfet_03v3 ad=0 pd=0 as=16.6842p ps=77.76u w=1.56u l=0.28u
X3549 VREFN A44_DCTRL_STRIP_W_R2_0/CTRL_OUT[7] A44_CDAC_CAP_BANK_ASSEMBLY_R8_M6_0/A44_CAP_CORE128_M6_R1_0/CAP_BOTTOM_071 GND nfet_03v3 ad=0 pd=0 as=0 ps=0 w=1.56u l=0.28u
X3550 VREFN A44_DCTRL_STRIP_W_R2_0/CTRL_OUT[7] A44_CDAC_CAP_BANK_ASSEMBLY_R8_M6_0/A44_CAP_CORE128_M6_R1_0/CAP_BOTTOM_071 GND nfet_03v3 ad=0 pd=0 as=0 ps=0 w=1.56u l=0.28u
X3551 VREFN A44_DCTRL_STRIP_W_R2_0/CTRL_OUT[7] A44_CDAC_CAP_BANK_ASSEMBLY_R8_M6_0/A44_CAP_CORE128_M6_R1_0/CAP_BOTTOM_071 GND nfet_03v3 ad=0 pd=0 as=0 ps=0 w=1.56u l=0.28u
X3552 VREFN A44_DCTRL_STRIP_W_R2_0/CTRL_OUT[7] A44_CDAC_CAP_BANK_ASSEMBLY_R8_M6_0/A44_CAP_CORE128_M6_R1_0/CAP_BOTTOM_071 GND nfet_03v3 ad=0 pd=0 as=0 ps=0 w=1.56u l=0.28u
X3553 VREFN A44_DCTRL_STRIP_W_R2_0/CTRL_OUT[7] A44_CDAC_CAP_BANK_ASSEMBLY_R8_M6_0/A44_CAP_CORE128_M6_R1_0/CAP_BOTTOM_071 GND nfet_03v3 ad=0 pd=0 as=0 ps=0 w=1.56u l=0.28u
X3554 VREFN A44_DCTRL_STRIP_W_R2_0/CTRL_OUT[7] A44_CDAC_CAP_BANK_ASSEMBLY_R8_M6_0/A44_CAP_CORE128_M6_R1_0/CAP_BOTTOM_071 GND nfet_03v3 ad=0 pd=0 as=0 ps=0 w=1.56u l=0.28u
X3555 VREFN A44_DCTRL_STRIP_W_R2_0/CTRL_OUT[7] A44_CDAC_CAP_BANK_ASSEMBLY_R8_M6_0/A44_CAP_CORE128_M6_R1_0/CAP_BOTTOM_071 GND nfet_03v3 ad=0 pd=0 as=0 ps=0 w=1.56u l=0.28u
X3556 VREFN A44_DCTRL_STRIP_W_R2_0/CTRL_OUT[7] A44_CDAC_CAP_BANK_ASSEMBLY_R8_M6_0/A44_CAP_CORE128_M6_R1_0/CAP_BOTTOM_071 GND nfet_03v3 ad=0 pd=0 as=0 ps=0 w=1.56u l=0.28u
X3557 VREFN A44_DCTRL_STRIP_W_R2_0/CTRL_OUT[7] A44_CDAC_CAP_BANK_ASSEMBLY_R8_M6_0/A44_CAP_CORE128_M6_R1_0/CAP_BOTTOM_071 GND nfet_03v3 ad=0 pd=0 as=0 ps=0 w=1.56u l=0.28u
X3558 VREFN A44_DCTRL_STRIP_W_R2_0/CTRL_OUT[7] A44_CDAC_CAP_BANK_ASSEMBLY_R8_M6_0/A44_CAP_CORE128_M6_R1_0/CAP_BOTTOM_071 GND nfet_03v3 ad=0 pd=0 as=0 ps=0 w=1.56u l=0.28u
X3559 VREFN A44_DCTRL_STRIP_W_R2_0/CTRL_OUT[7] A44_CDAC_CAP_BANK_ASSEMBLY_R8_M6_0/A44_CAP_CORE128_M6_R1_0/CAP_BOTTOM_071 GND nfet_03v3 ad=0 pd=0 as=0 ps=0 w=1.56u l=0.28u
X3560 VREFN A44_DCTRL_STRIP_W_R2_0/CTRL_OUT[7] A44_CDAC_CAP_BANK_ASSEMBLY_R8_M6_0/A44_CAP_CORE128_M6_R1_0/CAP_BOTTOM_071 GND nfet_03v3 ad=0 pd=0 as=0 ps=0 w=1.56u l=0.28u
X3561 VREFN A44_DCTRL_STRIP_W_R2_0/CTRL_OUT[7] A44_CDAC_CAP_BANK_ASSEMBLY_R8_M6_0/A44_CAP_CORE128_M6_R1_0/CAP_BOTTOM_071 GND nfet_03v3 ad=0 pd=0 as=0 ps=0 w=1.56u l=0.28u
X3562 VREFN A44_DCTRL_STRIP_W_R2_0/CTRL_OUT[7] A44_CDAC_CAP_BANK_ASSEMBLY_R8_M6_0/A44_CAP_CORE128_M6_R1_0/CAP_BOTTOM_071 GND nfet_03v3 ad=0 pd=0 as=0 ps=0 w=1.56u l=0.28u
X3563 VREFN A44_DCTRL_STRIP_W_R2_0/CTRL_OUT[7] A44_CDAC_CAP_BANK_ASSEMBLY_R8_M6_0/A44_CAP_CORE128_M6_R1_0/CAP_BOTTOM_071 GND nfet_03v3 ad=0 pd=0 as=0 ps=0 w=1.56u l=0.28u
X3564 VREFN A44_DCTRL_STRIP_W_R2_0/CTRL_OUT[7] A44_CDAC_CAP_BANK_ASSEMBLY_R8_M6_0/A44_CAP_CORE128_M6_R1_0/CAP_BOTTOM_071 GND nfet_03v3 ad=0 pd=0 as=0 ps=0 w=1.56u l=0.28u
X3565 VREFN A44_DCTRL_STRIP_W_R2_0/CTRL_OUT[7] A44_CDAC_CAP_BANK_ASSEMBLY_R8_M6_0/A44_CAP_CORE128_M6_R1_0/CAP_BOTTOM_071 GND nfet_03v3 ad=0 pd=0 as=0 ps=0 w=1.56u l=0.28u
X3566 VREFP A44_DCTRL_STRIP_W_R2_0/CTRL_OUT[4] A44_CDAC_CAP_BANK_ASSEMBLY_R8_M6_0/A44_CAP_CORE128_M6_R1_0/CAP_BOTTOM_096 VDD pfet_03v3 ad=0 pd=0 as=16.6842p ps=77.76u w=1.56u l=0.28u
X3567 VREFP A44_DCTRL_STRIP_W_R2_0/CTRL_OUT[4] A44_CDAC_CAP_BANK_ASSEMBLY_R8_M6_0/A44_CAP_CORE128_M6_R1_0/CAP_BOTTOM_096 VDD pfet_03v3 ad=0 pd=0 as=0 ps=0 w=1.56u l=0.28u
X3568 VREFP A44_DCTRL_STRIP_W_R2_0/CTRL_OUT[4] A44_CDAC_CAP_BANK_ASSEMBLY_R8_M6_0/A44_CAP_CORE128_M6_R1_0/CAP_BOTTOM_096 VDD pfet_03v3 ad=0 pd=0 as=0 ps=0 w=1.56u l=0.28u
X3569 VREFP A44_DCTRL_STRIP_W_R2_0/CTRL_OUT[4] A44_CDAC_CAP_BANK_ASSEMBLY_R8_M6_0/A44_CAP_CORE128_M6_R1_0/CAP_BOTTOM_096 VDD pfet_03v3 ad=0 pd=0 as=0 ps=0 w=1.56u l=0.28u
X3570 VREFP A44_DCTRL_STRIP_W_R2_0/CTRL_OUT[4] A44_CDAC_CAP_BANK_ASSEMBLY_R8_M6_0/A44_CAP_CORE128_M6_R1_0/CAP_BOTTOM_096 VDD pfet_03v3 ad=0 pd=0 as=0 ps=0 w=1.56u l=0.28u
X3571 VREFP A44_DCTRL_STRIP_W_R2_0/CTRL_OUT[4] A44_CDAC_CAP_BANK_ASSEMBLY_R8_M6_0/A44_CAP_CORE128_M6_R1_0/CAP_BOTTOM_096 VDD pfet_03v3 ad=0 pd=0 as=0 ps=0 w=1.56u l=0.28u
X3572 VREFP A44_DCTRL_STRIP_W_R2_0/CTRL_OUT[4] A44_CDAC_CAP_BANK_ASSEMBLY_R8_M6_0/A44_CAP_CORE128_M6_R1_0/CAP_BOTTOM_096 VDD pfet_03v3 ad=0 pd=0 as=0 ps=0 w=1.56u l=0.28u
X3573 VREFP A44_DCTRL_STRIP_W_R2_0/CTRL_OUT[4] A44_CDAC_CAP_BANK_ASSEMBLY_R8_M6_0/A44_CAP_CORE128_M6_R1_0/CAP_BOTTOM_096 VDD pfet_03v3 ad=0 pd=0 as=0 ps=0 w=1.56u l=0.28u
X3574 VREFP A44_DCTRL_STRIP_W_R2_0/CTRL_OUT[4] A44_CDAC_CAP_BANK_ASSEMBLY_R8_M6_0/A44_CAP_CORE128_M6_R1_0/CAP_BOTTOM_096 VDD pfet_03v3 ad=0 pd=0 as=0 ps=0 w=1.56u l=0.28u
X3575 VREFP A44_DCTRL_STRIP_W_R2_0/CTRL_OUT[4] A44_CDAC_CAP_BANK_ASSEMBLY_R8_M6_0/A44_CAP_CORE128_M6_R1_0/CAP_BOTTOM_096 VDD pfet_03v3 ad=0 pd=0 as=0 ps=0 w=1.56u l=0.28u
X3576 VREFP A44_DCTRL_STRIP_W_R2_0/CTRL_OUT[4] A44_CDAC_CAP_BANK_ASSEMBLY_R8_M6_0/A44_CAP_CORE128_M6_R1_0/CAP_BOTTOM_096 VDD pfet_03v3 ad=0 pd=0 as=0 ps=0 w=1.56u l=0.28u
X3577 VREFP A44_DCTRL_STRIP_W_R2_0/CTRL_OUT[4] A44_CDAC_CAP_BANK_ASSEMBLY_R8_M6_0/A44_CAP_CORE128_M6_R1_0/CAP_BOTTOM_096 VDD pfet_03v3 ad=0 pd=0 as=0 ps=0 w=1.56u l=0.28u
X3578 VREFP A44_DCTRL_STRIP_W_R2_0/CTRL_OUT[4] A44_CDAC_CAP_BANK_ASSEMBLY_R8_M6_0/A44_CAP_CORE128_M6_R1_0/CAP_BOTTOM_096 VDD pfet_03v3 ad=0 pd=0 as=0 ps=0 w=1.56u l=0.28u
X3579 VREFP A44_DCTRL_STRIP_W_R2_0/CTRL_OUT[4] A44_CDAC_CAP_BANK_ASSEMBLY_R8_M6_0/A44_CAP_CORE128_M6_R1_0/CAP_BOTTOM_096 VDD pfet_03v3 ad=0 pd=0 as=0 ps=0 w=1.56u l=0.28u
X3580 VREFP A44_DCTRL_STRIP_W_R2_0/CTRL_OUT[4] A44_CDAC_CAP_BANK_ASSEMBLY_R8_M6_0/A44_CAP_CORE128_M6_R1_0/CAP_BOTTOM_096 VDD pfet_03v3 ad=0 pd=0 as=0 ps=0 w=1.56u l=0.28u
X3581 VREFP A44_DCTRL_STRIP_W_R2_0/CTRL_OUT[4] A44_CDAC_CAP_BANK_ASSEMBLY_R8_M6_0/A44_CAP_CORE128_M6_R1_0/CAP_BOTTOM_096 VDD pfet_03v3 ad=0 pd=0 as=0 ps=0 w=1.56u l=0.28u
X3582 VREFP A44_DCTRL_STRIP_W_R2_0/CTRL_OUT[4] A44_CDAC_CAP_BANK_ASSEMBLY_R8_M6_0/A44_CAP_CORE128_M6_R1_0/CAP_BOTTOM_096 VDD pfet_03v3 ad=0 pd=0 as=0 ps=0 w=1.56u l=0.28u
X3583 VREFP A44_DCTRL_STRIP_W_R2_0/CTRL_OUT[4] A44_CDAC_CAP_BANK_ASSEMBLY_R8_M6_0/A44_CAP_CORE128_M6_R1_0/CAP_BOTTOM_096 VDD pfet_03v3 ad=0 pd=0 as=0 ps=0 w=1.56u l=0.28u
X3584 VREFN A44_DCTRL_STRIP_W_R2_0/CTRL_OUT[4] A44_CDAC_CAP_BANK_ASSEMBLY_R8_M6_0/A44_CAP_CORE128_M6_R1_0/CAP_BOTTOM_096 GND nfet_03v3 ad=0 pd=0 as=16.6842p ps=77.76u w=1.56u l=0.28u
X3585 VREFN A44_DCTRL_STRIP_W_R2_0/CTRL_OUT[4] A44_CDAC_CAP_BANK_ASSEMBLY_R8_M6_0/A44_CAP_CORE128_M6_R1_0/CAP_BOTTOM_096 GND nfet_03v3 ad=0 pd=0 as=0 ps=0 w=1.56u l=0.28u
X3586 VREFN A44_DCTRL_STRIP_W_R2_0/CTRL_OUT[4] A44_CDAC_CAP_BANK_ASSEMBLY_R8_M6_0/A44_CAP_CORE128_M6_R1_0/CAP_BOTTOM_096 GND nfet_03v3 ad=0 pd=0 as=0 ps=0 w=1.56u l=0.28u
X3587 VREFN A44_DCTRL_STRIP_W_R2_0/CTRL_OUT[4] A44_CDAC_CAP_BANK_ASSEMBLY_R8_M6_0/A44_CAP_CORE128_M6_R1_0/CAP_BOTTOM_096 GND nfet_03v3 ad=0 pd=0 as=0 ps=0 w=1.56u l=0.28u
X3588 VREFN A44_DCTRL_STRIP_W_R2_0/CTRL_OUT[4] A44_CDAC_CAP_BANK_ASSEMBLY_R8_M6_0/A44_CAP_CORE128_M6_R1_0/CAP_BOTTOM_096 GND nfet_03v3 ad=0 pd=0 as=0 ps=0 w=1.56u l=0.28u
X3589 VREFN A44_DCTRL_STRIP_W_R2_0/CTRL_OUT[4] A44_CDAC_CAP_BANK_ASSEMBLY_R8_M6_0/A44_CAP_CORE128_M6_R1_0/CAP_BOTTOM_096 GND nfet_03v3 ad=0 pd=0 as=0 ps=0 w=1.56u l=0.28u
X3590 VREFN A44_DCTRL_STRIP_W_R2_0/CTRL_OUT[4] A44_CDAC_CAP_BANK_ASSEMBLY_R8_M6_0/A44_CAP_CORE128_M6_R1_0/CAP_BOTTOM_096 GND nfet_03v3 ad=0 pd=0 as=0 ps=0 w=1.56u l=0.28u
X3591 VREFN A44_DCTRL_STRIP_W_R2_0/CTRL_OUT[4] A44_CDAC_CAP_BANK_ASSEMBLY_R8_M6_0/A44_CAP_CORE128_M6_R1_0/CAP_BOTTOM_096 GND nfet_03v3 ad=0 pd=0 as=0 ps=0 w=1.56u l=0.28u
X3592 VREFN A44_DCTRL_STRIP_W_R2_0/CTRL_OUT[4] A44_CDAC_CAP_BANK_ASSEMBLY_R8_M6_0/A44_CAP_CORE128_M6_R1_0/CAP_BOTTOM_096 GND nfet_03v3 ad=0 pd=0 as=0 ps=0 w=1.56u l=0.28u
X3593 VREFN A44_DCTRL_STRIP_W_R2_0/CTRL_OUT[4] A44_CDAC_CAP_BANK_ASSEMBLY_R8_M6_0/A44_CAP_CORE128_M6_R1_0/CAP_BOTTOM_096 GND nfet_03v3 ad=0 pd=0 as=0 ps=0 w=1.56u l=0.28u
X3594 VREFN A44_DCTRL_STRIP_W_R2_0/CTRL_OUT[4] A44_CDAC_CAP_BANK_ASSEMBLY_R8_M6_0/A44_CAP_CORE128_M6_R1_0/CAP_BOTTOM_096 GND nfet_03v3 ad=0 pd=0 as=0 ps=0 w=1.56u l=0.28u
X3595 VREFN A44_DCTRL_STRIP_W_R2_0/CTRL_OUT[4] A44_CDAC_CAP_BANK_ASSEMBLY_R8_M6_0/A44_CAP_CORE128_M6_R1_0/CAP_BOTTOM_096 GND nfet_03v3 ad=0 pd=0 as=0 ps=0 w=1.56u l=0.28u
X3596 VREFN A44_DCTRL_STRIP_W_R2_0/CTRL_OUT[4] A44_CDAC_CAP_BANK_ASSEMBLY_R8_M6_0/A44_CAP_CORE128_M6_R1_0/CAP_BOTTOM_096 GND nfet_03v3 ad=0 pd=0 as=0 ps=0 w=1.56u l=0.28u
X3597 VREFN A44_DCTRL_STRIP_W_R2_0/CTRL_OUT[4] A44_CDAC_CAP_BANK_ASSEMBLY_R8_M6_0/A44_CAP_CORE128_M6_R1_0/CAP_BOTTOM_096 GND nfet_03v3 ad=0 pd=0 as=0 ps=0 w=1.56u l=0.28u
X3598 VREFN A44_DCTRL_STRIP_W_R2_0/CTRL_OUT[4] A44_CDAC_CAP_BANK_ASSEMBLY_R8_M6_0/A44_CAP_CORE128_M6_R1_0/CAP_BOTTOM_096 GND nfet_03v3 ad=0 pd=0 as=0 ps=0 w=1.56u l=0.28u
X3599 VREFN A44_DCTRL_STRIP_W_R2_0/CTRL_OUT[4] A44_CDAC_CAP_BANK_ASSEMBLY_R8_M6_0/A44_CAP_CORE128_M6_R1_0/CAP_BOTTOM_096 GND nfet_03v3 ad=0 pd=0 as=0 ps=0 w=1.56u l=0.28u
X3600 VREFN A44_DCTRL_STRIP_W_R2_0/CTRL_OUT[4] A44_CDAC_CAP_BANK_ASSEMBLY_R8_M6_0/A44_CAP_CORE128_M6_R1_0/CAP_BOTTOM_096 GND nfet_03v3 ad=0 pd=0 as=0 ps=0 w=1.56u l=0.28u
X3601 VREFN A44_DCTRL_STRIP_W_R2_0/CTRL_OUT[4] A44_CDAC_CAP_BANK_ASSEMBLY_R8_M6_0/A44_CAP_CORE128_M6_R1_0/CAP_BOTTOM_096 GND nfet_03v3 ad=0 pd=0 as=0 ps=0 w=1.56u l=0.28u
X3602 VREFP A44_DCTRL_STRIP_W_R2_0/CTRL_OUT[7] A44_CDAC_CAP_BANK_ASSEMBLY_R8_M6_0/A44_CAP_CORE128_M6_R1_0/CAP_BOTTOM_093 VDD pfet_03v3 ad=0 pd=0 as=16.6842p ps=77.76u w=1.56u l=0.28u
X3603 VREFP A44_DCTRL_STRIP_W_R2_0/CTRL_OUT[7] A44_CDAC_CAP_BANK_ASSEMBLY_R8_M6_0/A44_CAP_CORE128_M6_R1_0/CAP_BOTTOM_093 VDD pfet_03v3 ad=0 pd=0 as=0 ps=0 w=1.56u l=0.28u
X3604 VREFP A44_DCTRL_STRIP_W_R2_0/CTRL_OUT[7] A44_CDAC_CAP_BANK_ASSEMBLY_R8_M6_0/A44_CAP_CORE128_M6_R1_0/CAP_BOTTOM_093 VDD pfet_03v3 ad=0 pd=0 as=0 ps=0 w=1.56u l=0.28u
X3605 VREFP A44_DCTRL_STRIP_W_R2_0/CTRL_OUT[7] A44_CDAC_CAP_BANK_ASSEMBLY_R8_M6_0/A44_CAP_CORE128_M6_R1_0/CAP_BOTTOM_093 VDD pfet_03v3 ad=0 pd=0 as=0 ps=0 w=1.56u l=0.28u
X3606 VREFP A44_DCTRL_STRIP_W_R2_0/CTRL_OUT[7] A44_CDAC_CAP_BANK_ASSEMBLY_R8_M6_0/A44_CAP_CORE128_M6_R1_0/CAP_BOTTOM_093 VDD pfet_03v3 ad=0 pd=0 as=0 ps=0 w=1.56u l=0.28u
X3607 VREFP A44_DCTRL_STRIP_W_R2_0/CTRL_OUT[7] A44_CDAC_CAP_BANK_ASSEMBLY_R8_M6_0/A44_CAP_CORE128_M6_R1_0/CAP_BOTTOM_093 VDD pfet_03v3 ad=0 pd=0 as=0 ps=0 w=1.56u l=0.28u
X3608 VREFP A44_DCTRL_STRIP_W_R2_0/CTRL_OUT[7] A44_CDAC_CAP_BANK_ASSEMBLY_R8_M6_0/A44_CAP_CORE128_M6_R1_0/CAP_BOTTOM_093 VDD pfet_03v3 ad=0 pd=0 as=0 ps=0 w=1.56u l=0.28u
X3609 VREFP A44_DCTRL_STRIP_W_R2_0/CTRL_OUT[7] A44_CDAC_CAP_BANK_ASSEMBLY_R8_M6_0/A44_CAP_CORE128_M6_R1_0/CAP_BOTTOM_093 VDD pfet_03v3 ad=0 pd=0 as=0 ps=0 w=1.56u l=0.28u
X3610 VREFP A44_DCTRL_STRIP_W_R2_0/CTRL_OUT[7] A44_CDAC_CAP_BANK_ASSEMBLY_R8_M6_0/A44_CAP_CORE128_M6_R1_0/CAP_BOTTOM_093 VDD pfet_03v3 ad=0 pd=0 as=0 ps=0 w=1.56u l=0.28u
X3611 VREFP A44_DCTRL_STRIP_W_R2_0/CTRL_OUT[7] A44_CDAC_CAP_BANK_ASSEMBLY_R8_M6_0/A44_CAP_CORE128_M6_R1_0/CAP_BOTTOM_093 VDD pfet_03v3 ad=0 pd=0 as=0 ps=0 w=1.56u l=0.28u
X3612 VREFP A44_DCTRL_STRIP_W_R2_0/CTRL_OUT[7] A44_CDAC_CAP_BANK_ASSEMBLY_R8_M6_0/A44_CAP_CORE128_M6_R1_0/CAP_BOTTOM_093 VDD pfet_03v3 ad=0 pd=0 as=0 ps=0 w=1.56u l=0.28u
X3613 VREFP A44_DCTRL_STRIP_W_R2_0/CTRL_OUT[7] A44_CDAC_CAP_BANK_ASSEMBLY_R8_M6_0/A44_CAP_CORE128_M6_R1_0/CAP_BOTTOM_093 VDD pfet_03v3 ad=0 pd=0 as=0 ps=0 w=1.56u l=0.28u
X3614 VREFP A44_DCTRL_STRIP_W_R2_0/CTRL_OUT[7] A44_CDAC_CAP_BANK_ASSEMBLY_R8_M6_0/A44_CAP_CORE128_M6_R1_0/CAP_BOTTOM_093 VDD pfet_03v3 ad=0 pd=0 as=0 ps=0 w=1.56u l=0.28u
X3615 VREFP A44_DCTRL_STRIP_W_R2_0/CTRL_OUT[7] A44_CDAC_CAP_BANK_ASSEMBLY_R8_M6_0/A44_CAP_CORE128_M6_R1_0/CAP_BOTTOM_093 VDD pfet_03v3 ad=0 pd=0 as=0 ps=0 w=1.56u l=0.28u
X3616 VREFP A44_DCTRL_STRIP_W_R2_0/CTRL_OUT[7] A44_CDAC_CAP_BANK_ASSEMBLY_R8_M6_0/A44_CAP_CORE128_M6_R1_0/CAP_BOTTOM_093 VDD pfet_03v3 ad=0 pd=0 as=0 ps=0 w=1.56u l=0.28u
X3617 VREFP A44_DCTRL_STRIP_W_R2_0/CTRL_OUT[7] A44_CDAC_CAP_BANK_ASSEMBLY_R8_M6_0/A44_CAP_CORE128_M6_R1_0/CAP_BOTTOM_093 VDD pfet_03v3 ad=0 pd=0 as=0 ps=0 w=1.56u l=0.28u
X3618 VREFP A44_DCTRL_STRIP_W_R2_0/CTRL_OUT[7] A44_CDAC_CAP_BANK_ASSEMBLY_R8_M6_0/A44_CAP_CORE128_M6_R1_0/CAP_BOTTOM_093 VDD pfet_03v3 ad=0 pd=0 as=0 ps=0 w=1.56u l=0.28u
X3619 VREFP A44_DCTRL_STRIP_W_R2_0/CTRL_OUT[7] A44_CDAC_CAP_BANK_ASSEMBLY_R8_M6_0/A44_CAP_CORE128_M6_R1_0/CAP_BOTTOM_093 VDD pfet_03v3 ad=0 pd=0 as=0 ps=0 w=1.56u l=0.28u
X3620 VREFN A44_DCTRL_STRIP_W_R2_0/CTRL_OUT[7] A44_CDAC_CAP_BANK_ASSEMBLY_R8_M6_0/A44_CAP_CORE128_M6_R1_0/CAP_BOTTOM_093 GND nfet_03v3 ad=0 pd=0 as=16.6842p ps=77.76u w=1.56u l=0.28u
X3621 VREFN A44_DCTRL_STRIP_W_R2_0/CTRL_OUT[7] A44_CDAC_CAP_BANK_ASSEMBLY_R8_M6_0/A44_CAP_CORE128_M6_R1_0/CAP_BOTTOM_093 GND nfet_03v3 ad=0 pd=0 as=0 ps=0 w=1.56u l=0.28u
X3622 VREFN A44_DCTRL_STRIP_W_R2_0/CTRL_OUT[7] A44_CDAC_CAP_BANK_ASSEMBLY_R8_M6_0/A44_CAP_CORE128_M6_R1_0/CAP_BOTTOM_093 GND nfet_03v3 ad=0 pd=0 as=0 ps=0 w=1.56u l=0.28u
X3623 VREFN A44_DCTRL_STRIP_W_R2_0/CTRL_OUT[7] A44_CDAC_CAP_BANK_ASSEMBLY_R8_M6_0/A44_CAP_CORE128_M6_R1_0/CAP_BOTTOM_093 GND nfet_03v3 ad=0 pd=0 as=0 ps=0 w=1.56u l=0.28u
X3624 VREFN A44_DCTRL_STRIP_W_R2_0/CTRL_OUT[7] A44_CDAC_CAP_BANK_ASSEMBLY_R8_M6_0/A44_CAP_CORE128_M6_R1_0/CAP_BOTTOM_093 GND nfet_03v3 ad=0 pd=0 as=0 ps=0 w=1.56u l=0.28u
X3625 VREFN A44_DCTRL_STRIP_W_R2_0/CTRL_OUT[7] A44_CDAC_CAP_BANK_ASSEMBLY_R8_M6_0/A44_CAP_CORE128_M6_R1_0/CAP_BOTTOM_093 GND nfet_03v3 ad=0 pd=0 as=0 ps=0 w=1.56u l=0.28u
X3626 VREFN A44_DCTRL_STRIP_W_R2_0/CTRL_OUT[7] A44_CDAC_CAP_BANK_ASSEMBLY_R8_M6_0/A44_CAP_CORE128_M6_R1_0/CAP_BOTTOM_093 GND nfet_03v3 ad=0 pd=0 as=0 ps=0 w=1.56u l=0.28u
X3627 VREFN A44_DCTRL_STRIP_W_R2_0/CTRL_OUT[7] A44_CDAC_CAP_BANK_ASSEMBLY_R8_M6_0/A44_CAP_CORE128_M6_R1_0/CAP_BOTTOM_093 GND nfet_03v3 ad=0 pd=0 as=0 ps=0 w=1.56u l=0.28u
X3628 VREFN A44_DCTRL_STRIP_W_R2_0/CTRL_OUT[7] A44_CDAC_CAP_BANK_ASSEMBLY_R8_M6_0/A44_CAP_CORE128_M6_R1_0/CAP_BOTTOM_093 GND nfet_03v3 ad=0 pd=0 as=0 ps=0 w=1.56u l=0.28u
X3629 VREFN A44_DCTRL_STRIP_W_R2_0/CTRL_OUT[7] A44_CDAC_CAP_BANK_ASSEMBLY_R8_M6_0/A44_CAP_CORE128_M6_R1_0/CAP_BOTTOM_093 GND nfet_03v3 ad=0 pd=0 as=0 ps=0 w=1.56u l=0.28u
X3630 VREFN A44_DCTRL_STRIP_W_R2_0/CTRL_OUT[7] A44_CDAC_CAP_BANK_ASSEMBLY_R8_M6_0/A44_CAP_CORE128_M6_R1_0/CAP_BOTTOM_093 GND nfet_03v3 ad=0 pd=0 as=0 ps=0 w=1.56u l=0.28u
X3631 VREFN A44_DCTRL_STRIP_W_R2_0/CTRL_OUT[7] A44_CDAC_CAP_BANK_ASSEMBLY_R8_M6_0/A44_CAP_CORE128_M6_R1_0/CAP_BOTTOM_093 GND nfet_03v3 ad=0 pd=0 as=0 ps=0 w=1.56u l=0.28u
X3632 VREFN A44_DCTRL_STRIP_W_R2_0/CTRL_OUT[7] A44_CDAC_CAP_BANK_ASSEMBLY_R8_M6_0/A44_CAP_CORE128_M6_R1_0/CAP_BOTTOM_093 GND nfet_03v3 ad=0 pd=0 as=0 ps=0 w=1.56u l=0.28u
X3633 VREFN A44_DCTRL_STRIP_W_R2_0/CTRL_OUT[7] A44_CDAC_CAP_BANK_ASSEMBLY_R8_M6_0/A44_CAP_CORE128_M6_R1_0/CAP_BOTTOM_093 GND nfet_03v3 ad=0 pd=0 as=0 ps=0 w=1.56u l=0.28u
X3634 VREFN A44_DCTRL_STRIP_W_R2_0/CTRL_OUT[7] A44_CDAC_CAP_BANK_ASSEMBLY_R8_M6_0/A44_CAP_CORE128_M6_R1_0/CAP_BOTTOM_093 GND nfet_03v3 ad=0 pd=0 as=0 ps=0 w=1.56u l=0.28u
X3635 VREFN A44_DCTRL_STRIP_W_R2_0/CTRL_OUT[7] A44_CDAC_CAP_BANK_ASSEMBLY_R8_M6_0/A44_CAP_CORE128_M6_R1_0/CAP_BOTTOM_093 GND nfet_03v3 ad=0 pd=0 as=0 ps=0 w=1.56u l=0.28u
X3636 VREFN A44_DCTRL_STRIP_W_R2_0/CTRL_OUT[7] A44_CDAC_CAP_BANK_ASSEMBLY_R8_M6_0/A44_CAP_CORE128_M6_R1_0/CAP_BOTTOM_093 GND nfet_03v3 ad=0 pd=0 as=0 ps=0 w=1.56u l=0.28u
X3637 VREFN A44_DCTRL_STRIP_W_R2_0/CTRL_OUT[7] A44_CDAC_CAP_BANK_ASSEMBLY_R8_M6_0/A44_CAP_CORE128_M6_R1_0/CAP_BOTTOM_093 GND nfet_03v3 ad=0 pd=0 as=0 ps=0 w=1.56u l=0.28u
X3638 VREFP A44_DCTRL_STRIP_W_R2_0/CTRL_OUT[7] A44_CDAC_CAP_BANK_ASSEMBLY_R8_M6_0/A44_CAP_CORE128_M6_R1_0/CAP_BOTTOM_091 VDD pfet_03v3 ad=0 pd=0 as=16.6842p ps=77.76u w=1.56u l=0.28u
X3639 VREFP A44_DCTRL_STRIP_W_R2_0/CTRL_OUT[7] A44_CDAC_CAP_BANK_ASSEMBLY_R8_M6_0/A44_CAP_CORE128_M6_R1_0/CAP_BOTTOM_091 VDD pfet_03v3 ad=0 pd=0 as=0 ps=0 w=1.56u l=0.28u
X3640 VREFP A44_DCTRL_STRIP_W_R2_0/CTRL_OUT[7] A44_CDAC_CAP_BANK_ASSEMBLY_R8_M6_0/A44_CAP_CORE128_M6_R1_0/CAP_BOTTOM_091 VDD pfet_03v3 ad=0 pd=0 as=0 ps=0 w=1.56u l=0.28u
X3641 VREFP A44_DCTRL_STRIP_W_R2_0/CTRL_OUT[7] A44_CDAC_CAP_BANK_ASSEMBLY_R8_M6_0/A44_CAP_CORE128_M6_R1_0/CAP_BOTTOM_091 VDD pfet_03v3 ad=0 pd=0 as=0 ps=0 w=1.56u l=0.28u
X3642 VREFP A44_DCTRL_STRIP_W_R2_0/CTRL_OUT[7] A44_CDAC_CAP_BANK_ASSEMBLY_R8_M6_0/A44_CAP_CORE128_M6_R1_0/CAP_BOTTOM_091 VDD pfet_03v3 ad=0 pd=0 as=0 ps=0 w=1.56u l=0.28u
X3643 VREFP A44_DCTRL_STRIP_W_R2_0/CTRL_OUT[7] A44_CDAC_CAP_BANK_ASSEMBLY_R8_M6_0/A44_CAP_CORE128_M6_R1_0/CAP_BOTTOM_091 VDD pfet_03v3 ad=0 pd=0 as=0 ps=0 w=1.56u l=0.28u
X3644 VREFP A44_DCTRL_STRIP_W_R2_0/CTRL_OUT[7] A44_CDAC_CAP_BANK_ASSEMBLY_R8_M6_0/A44_CAP_CORE128_M6_R1_0/CAP_BOTTOM_091 VDD pfet_03v3 ad=0 pd=0 as=0 ps=0 w=1.56u l=0.28u
X3645 VREFP A44_DCTRL_STRIP_W_R2_0/CTRL_OUT[7] A44_CDAC_CAP_BANK_ASSEMBLY_R8_M6_0/A44_CAP_CORE128_M6_R1_0/CAP_BOTTOM_091 VDD pfet_03v3 ad=0 pd=0 as=0 ps=0 w=1.56u l=0.28u
X3646 VREFP A44_DCTRL_STRIP_W_R2_0/CTRL_OUT[7] A44_CDAC_CAP_BANK_ASSEMBLY_R8_M6_0/A44_CAP_CORE128_M6_R1_0/CAP_BOTTOM_091 VDD pfet_03v3 ad=0 pd=0 as=0 ps=0 w=1.56u l=0.28u
X3647 VREFP A44_DCTRL_STRIP_W_R2_0/CTRL_OUT[7] A44_CDAC_CAP_BANK_ASSEMBLY_R8_M6_0/A44_CAP_CORE128_M6_R1_0/CAP_BOTTOM_091 VDD pfet_03v3 ad=0 pd=0 as=0 ps=0 w=1.56u l=0.28u
X3648 VREFP A44_DCTRL_STRIP_W_R2_0/CTRL_OUT[7] A44_CDAC_CAP_BANK_ASSEMBLY_R8_M6_0/A44_CAP_CORE128_M6_R1_0/CAP_BOTTOM_091 VDD pfet_03v3 ad=0 pd=0 as=0 ps=0 w=1.56u l=0.28u
X3649 VREFP A44_DCTRL_STRIP_W_R2_0/CTRL_OUT[7] A44_CDAC_CAP_BANK_ASSEMBLY_R8_M6_0/A44_CAP_CORE128_M6_R1_0/CAP_BOTTOM_091 VDD pfet_03v3 ad=0 pd=0 as=0 ps=0 w=1.56u l=0.28u
X3650 VREFP A44_DCTRL_STRIP_W_R2_0/CTRL_OUT[7] A44_CDAC_CAP_BANK_ASSEMBLY_R8_M6_0/A44_CAP_CORE128_M6_R1_0/CAP_BOTTOM_091 VDD pfet_03v3 ad=0 pd=0 as=0 ps=0 w=1.56u l=0.28u
X3651 VREFP A44_DCTRL_STRIP_W_R2_0/CTRL_OUT[7] A44_CDAC_CAP_BANK_ASSEMBLY_R8_M6_0/A44_CAP_CORE128_M6_R1_0/CAP_BOTTOM_091 VDD pfet_03v3 ad=0 pd=0 as=0 ps=0 w=1.56u l=0.28u
X3652 VREFP A44_DCTRL_STRIP_W_R2_0/CTRL_OUT[7] A44_CDAC_CAP_BANK_ASSEMBLY_R8_M6_0/A44_CAP_CORE128_M6_R1_0/CAP_BOTTOM_091 VDD pfet_03v3 ad=0 pd=0 as=0 ps=0 w=1.56u l=0.28u
X3653 VREFP A44_DCTRL_STRIP_W_R2_0/CTRL_OUT[7] A44_CDAC_CAP_BANK_ASSEMBLY_R8_M6_0/A44_CAP_CORE128_M6_R1_0/CAP_BOTTOM_091 VDD pfet_03v3 ad=0 pd=0 as=0 ps=0 w=1.56u l=0.28u
X3654 VREFP A44_DCTRL_STRIP_W_R2_0/CTRL_OUT[7] A44_CDAC_CAP_BANK_ASSEMBLY_R8_M6_0/A44_CAP_CORE128_M6_R1_0/CAP_BOTTOM_091 VDD pfet_03v3 ad=0 pd=0 as=0 ps=0 w=1.56u l=0.28u
X3655 VREFP A44_DCTRL_STRIP_W_R2_0/CTRL_OUT[7] A44_CDAC_CAP_BANK_ASSEMBLY_R8_M6_0/A44_CAP_CORE128_M6_R1_0/CAP_BOTTOM_091 VDD pfet_03v3 ad=0 pd=0 as=0 ps=0 w=1.56u l=0.28u
X3656 VREFN A44_DCTRL_STRIP_W_R2_0/CTRL_OUT[7] A44_CDAC_CAP_BANK_ASSEMBLY_R8_M6_0/A44_CAP_CORE128_M6_R1_0/CAP_BOTTOM_091 GND nfet_03v3 ad=0 pd=0 as=16.6842p ps=77.76u w=1.56u l=0.28u
X3657 VREFN A44_DCTRL_STRIP_W_R2_0/CTRL_OUT[7] A44_CDAC_CAP_BANK_ASSEMBLY_R8_M6_0/A44_CAP_CORE128_M6_R1_0/CAP_BOTTOM_091 GND nfet_03v3 ad=0 pd=0 as=0 ps=0 w=1.56u l=0.28u
X3658 VREFN A44_DCTRL_STRIP_W_R2_0/CTRL_OUT[7] A44_CDAC_CAP_BANK_ASSEMBLY_R8_M6_0/A44_CAP_CORE128_M6_R1_0/CAP_BOTTOM_091 GND nfet_03v3 ad=0 pd=0 as=0 ps=0 w=1.56u l=0.28u
X3659 VREFN A44_DCTRL_STRIP_W_R2_0/CTRL_OUT[7] A44_CDAC_CAP_BANK_ASSEMBLY_R8_M6_0/A44_CAP_CORE128_M6_R1_0/CAP_BOTTOM_091 GND nfet_03v3 ad=0 pd=0 as=0 ps=0 w=1.56u l=0.28u
X3660 VREFN A44_DCTRL_STRIP_W_R2_0/CTRL_OUT[7] A44_CDAC_CAP_BANK_ASSEMBLY_R8_M6_0/A44_CAP_CORE128_M6_R1_0/CAP_BOTTOM_091 GND nfet_03v3 ad=0 pd=0 as=0 ps=0 w=1.56u l=0.28u
X3661 VREFN A44_DCTRL_STRIP_W_R2_0/CTRL_OUT[7] A44_CDAC_CAP_BANK_ASSEMBLY_R8_M6_0/A44_CAP_CORE128_M6_R1_0/CAP_BOTTOM_091 GND nfet_03v3 ad=0 pd=0 as=0 ps=0 w=1.56u l=0.28u
X3662 VREFN A44_DCTRL_STRIP_W_R2_0/CTRL_OUT[7] A44_CDAC_CAP_BANK_ASSEMBLY_R8_M6_0/A44_CAP_CORE128_M6_R1_0/CAP_BOTTOM_091 GND nfet_03v3 ad=0 pd=0 as=0 ps=0 w=1.56u l=0.28u
X3663 VREFN A44_DCTRL_STRIP_W_R2_0/CTRL_OUT[7] A44_CDAC_CAP_BANK_ASSEMBLY_R8_M6_0/A44_CAP_CORE128_M6_R1_0/CAP_BOTTOM_091 GND nfet_03v3 ad=0 pd=0 as=0 ps=0 w=1.56u l=0.28u
X3664 VREFN A44_DCTRL_STRIP_W_R2_0/CTRL_OUT[7] A44_CDAC_CAP_BANK_ASSEMBLY_R8_M6_0/A44_CAP_CORE128_M6_R1_0/CAP_BOTTOM_091 GND nfet_03v3 ad=0 pd=0 as=0 ps=0 w=1.56u l=0.28u
X3665 VREFN A44_DCTRL_STRIP_W_R2_0/CTRL_OUT[7] A44_CDAC_CAP_BANK_ASSEMBLY_R8_M6_0/A44_CAP_CORE128_M6_R1_0/CAP_BOTTOM_091 GND nfet_03v3 ad=0 pd=0 as=0 ps=0 w=1.56u l=0.28u
X3666 VREFN A44_DCTRL_STRIP_W_R2_0/CTRL_OUT[7] A44_CDAC_CAP_BANK_ASSEMBLY_R8_M6_0/A44_CAP_CORE128_M6_R1_0/CAP_BOTTOM_091 GND nfet_03v3 ad=0 pd=0 as=0 ps=0 w=1.56u l=0.28u
X3667 VREFN A44_DCTRL_STRIP_W_R2_0/CTRL_OUT[7] A44_CDAC_CAP_BANK_ASSEMBLY_R8_M6_0/A44_CAP_CORE128_M6_R1_0/CAP_BOTTOM_091 GND nfet_03v3 ad=0 pd=0 as=0 ps=0 w=1.56u l=0.28u
X3668 VREFN A44_DCTRL_STRIP_W_R2_0/CTRL_OUT[7] A44_CDAC_CAP_BANK_ASSEMBLY_R8_M6_0/A44_CAP_CORE128_M6_R1_0/CAP_BOTTOM_091 GND nfet_03v3 ad=0 pd=0 as=0 ps=0 w=1.56u l=0.28u
X3669 VREFN A44_DCTRL_STRIP_W_R2_0/CTRL_OUT[7] A44_CDAC_CAP_BANK_ASSEMBLY_R8_M6_0/A44_CAP_CORE128_M6_R1_0/CAP_BOTTOM_091 GND nfet_03v3 ad=0 pd=0 as=0 ps=0 w=1.56u l=0.28u
X3670 VREFN A44_DCTRL_STRIP_W_R2_0/CTRL_OUT[7] A44_CDAC_CAP_BANK_ASSEMBLY_R8_M6_0/A44_CAP_CORE128_M6_R1_0/CAP_BOTTOM_091 GND nfet_03v3 ad=0 pd=0 as=0 ps=0 w=1.56u l=0.28u
X3671 VREFN A44_DCTRL_STRIP_W_R2_0/CTRL_OUT[7] A44_CDAC_CAP_BANK_ASSEMBLY_R8_M6_0/A44_CAP_CORE128_M6_R1_0/CAP_BOTTOM_091 GND nfet_03v3 ad=0 pd=0 as=0 ps=0 w=1.56u l=0.28u
X3672 VREFN A44_DCTRL_STRIP_W_R2_0/CTRL_OUT[7] A44_CDAC_CAP_BANK_ASSEMBLY_R8_M6_0/A44_CAP_CORE128_M6_R1_0/CAP_BOTTOM_091 GND nfet_03v3 ad=0 pd=0 as=0 ps=0 w=1.56u l=0.28u
X3673 VREFN A44_DCTRL_STRIP_W_R2_0/CTRL_OUT[7] A44_CDAC_CAP_BANK_ASSEMBLY_R8_M6_0/A44_CAP_CORE128_M6_R1_0/CAP_BOTTOM_091 GND nfet_03v3 ad=0 pd=0 as=0 ps=0 w=1.56u l=0.28u
X3674 VREFP A44_DCTRL_STRIP_W_R2_0/CTRL_OUT[7] A44_CDAC_CAP_BANK_ASSEMBLY_R8_M6_0/A44_CAP_CORE128_M6_R1_0/CAP_BOTTOM_120 VDD pfet_03v3 ad=0 pd=0 as=16.6842p ps=77.76u w=1.56u l=0.28u
X3675 VREFP A44_DCTRL_STRIP_W_R2_0/CTRL_OUT[7] A44_CDAC_CAP_BANK_ASSEMBLY_R8_M6_0/A44_CAP_CORE128_M6_R1_0/CAP_BOTTOM_120 VDD pfet_03v3 ad=0 pd=0 as=0 ps=0 w=1.56u l=0.28u
X3676 VREFP A44_DCTRL_STRIP_W_R2_0/CTRL_OUT[7] A44_CDAC_CAP_BANK_ASSEMBLY_R8_M6_0/A44_CAP_CORE128_M6_R1_0/CAP_BOTTOM_120 VDD pfet_03v3 ad=0 pd=0 as=0 ps=0 w=1.56u l=0.28u
X3677 VREFP A44_DCTRL_STRIP_W_R2_0/CTRL_OUT[7] A44_CDAC_CAP_BANK_ASSEMBLY_R8_M6_0/A44_CAP_CORE128_M6_R1_0/CAP_BOTTOM_120 VDD pfet_03v3 ad=0 pd=0 as=0 ps=0 w=1.56u l=0.28u
X3678 VREFP A44_DCTRL_STRIP_W_R2_0/CTRL_OUT[7] A44_CDAC_CAP_BANK_ASSEMBLY_R8_M6_0/A44_CAP_CORE128_M6_R1_0/CAP_BOTTOM_120 VDD pfet_03v3 ad=0 pd=0 as=0 ps=0 w=1.56u l=0.28u
X3679 VREFP A44_DCTRL_STRIP_W_R2_0/CTRL_OUT[7] A44_CDAC_CAP_BANK_ASSEMBLY_R8_M6_0/A44_CAP_CORE128_M6_R1_0/CAP_BOTTOM_120 VDD pfet_03v3 ad=0 pd=0 as=0 ps=0 w=1.56u l=0.28u
X3680 VREFP A44_DCTRL_STRIP_W_R2_0/CTRL_OUT[7] A44_CDAC_CAP_BANK_ASSEMBLY_R8_M6_0/A44_CAP_CORE128_M6_R1_0/CAP_BOTTOM_120 VDD pfet_03v3 ad=0 pd=0 as=0 ps=0 w=1.56u l=0.28u
X3681 VREFP A44_DCTRL_STRIP_W_R2_0/CTRL_OUT[7] A44_CDAC_CAP_BANK_ASSEMBLY_R8_M6_0/A44_CAP_CORE128_M6_R1_0/CAP_BOTTOM_120 VDD pfet_03v3 ad=0 pd=0 as=0 ps=0 w=1.56u l=0.28u
X3682 VREFP A44_DCTRL_STRIP_W_R2_0/CTRL_OUT[7] A44_CDAC_CAP_BANK_ASSEMBLY_R8_M6_0/A44_CAP_CORE128_M6_R1_0/CAP_BOTTOM_120 VDD pfet_03v3 ad=0 pd=0 as=0 ps=0 w=1.56u l=0.28u
X3683 VREFP A44_DCTRL_STRIP_W_R2_0/CTRL_OUT[7] A44_CDAC_CAP_BANK_ASSEMBLY_R8_M6_0/A44_CAP_CORE128_M6_R1_0/CAP_BOTTOM_120 VDD pfet_03v3 ad=0 pd=0 as=0 ps=0 w=1.56u l=0.28u
X3684 VREFP A44_DCTRL_STRIP_W_R2_0/CTRL_OUT[7] A44_CDAC_CAP_BANK_ASSEMBLY_R8_M6_0/A44_CAP_CORE128_M6_R1_0/CAP_BOTTOM_120 VDD pfet_03v3 ad=0 pd=0 as=0 ps=0 w=1.56u l=0.28u
X3685 VREFP A44_DCTRL_STRIP_W_R2_0/CTRL_OUT[7] A44_CDAC_CAP_BANK_ASSEMBLY_R8_M6_0/A44_CAP_CORE128_M6_R1_0/CAP_BOTTOM_120 VDD pfet_03v3 ad=0 pd=0 as=0 ps=0 w=1.56u l=0.28u
X3686 VREFP A44_DCTRL_STRIP_W_R2_0/CTRL_OUT[7] A44_CDAC_CAP_BANK_ASSEMBLY_R8_M6_0/A44_CAP_CORE128_M6_R1_0/CAP_BOTTOM_120 VDD pfet_03v3 ad=0 pd=0 as=0 ps=0 w=1.56u l=0.28u
X3687 VREFP A44_DCTRL_STRIP_W_R2_0/CTRL_OUT[7] A44_CDAC_CAP_BANK_ASSEMBLY_R8_M6_0/A44_CAP_CORE128_M6_R1_0/CAP_BOTTOM_120 VDD pfet_03v3 ad=0 pd=0 as=0 ps=0 w=1.56u l=0.28u
X3688 VREFP A44_DCTRL_STRIP_W_R2_0/CTRL_OUT[7] A44_CDAC_CAP_BANK_ASSEMBLY_R8_M6_0/A44_CAP_CORE128_M6_R1_0/CAP_BOTTOM_120 VDD pfet_03v3 ad=0 pd=0 as=0 ps=0 w=1.56u l=0.28u
X3689 VREFP A44_DCTRL_STRIP_W_R2_0/CTRL_OUT[7] A44_CDAC_CAP_BANK_ASSEMBLY_R8_M6_0/A44_CAP_CORE128_M6_R1_0/CAP_BOTTOM_120 VDD pfet_03v3 ad=0 pd=0 as=0 ps=0 w=1.56u l=0.28u
X3690 VREFP A44_DCTRL_STRIP_W_R2_0/CTRL_OUT[7] A44_CDAC_CAP_BANK_ASSEMBLY_R8_M6_0/A44_CAP_CORE128_M6_R1_0/CAP_BOTTOM_120 VDD pfet_03v3 ad=0 pd=0 as=0 ps=0 w=1.56u l=0.28u
X3691 VREFP A44_DCTRL_STRIP_W_R2_0/CTRL_OUT[7] A44_CDAC_CAP_BANK_ASSEMBLY_R8_M6_0/A44_CAP_CORE128_M6_R1_0/CAP_BOTTOM_120 VDD pfet_03v3 ad=0 pd=0 as=0 ps=0 w=1.56u l=0.28u
X3692 VREFN A44_DCTRL_STRIP_W_R2_0/CTRL_OUT[7] A44_CDAC_CAP_BANK_ASSEMBLY_R8_M6_0/A44_CAP_CORE128_M6_R1_0/CAP_BOTTOM_120 GND nfet_03v3 ad=0 pd=0 as=16.6842p ps=77.76u w=1.56u l=0.28u
X3693 VREFN A44_DCTRL_STRIP_W_R2_0/CTRL_OUT[7] A44_CDAC_CAP_BANK_ASSEMBLY_R8_M6_0/A44_CAP_CORE128_M6_R1_0/CAP_BOTTOM_120 GND nfet_03v3 ad=0 pd=0 as=0 ps=0 w=1.56u l=0.28u
X3694 VREFN A44_DCTRL_STRIP_W_R2_0/CTRL_OUT[7] A44_CDAC_CAP_BANK_ASSEMBLY_R8_M6_0/A44_CAP_CORE128_M6_R1_0/CAP_BOTTOM_120 GND nfet_03v3 ad=0 pd=0 as=0 ps=0 w=1.56u l=0.28u
X3695 VREFN A44_DCTRL_STRIP_W_R2_0/CTRL_OUT[7] A44_CDAC_CAP_BANK_ASSEMBLY_R8_M6_0/A44_CAP_CORE128_M6_R1_0/CAP_BOTTOM_120 GND nfet_03v3 ad=0 pd=0 as=0 ps=0 w=1.56u l=0.28u
X3696 VREFN A44_DCTRL_STRIP_W_R2_0/CTRL_OUT[7] A44_CDAC_CAP_BANK_ASSEMBLY_R8_M6_0/A44_CAP_CORE128_M6_R1_0/CAP_BOTTOM_120 GND nfet_03v3 ad=0 pd=0 as=0 ps=0 w=1.56u l=0.28u
X3697 VREFN A44_DCTRL_STRIP_W_R2_0/CTRL_OUT[7] A44_CDAC_CAP_BANK_ASSEMBLY_R8_M6_0/A44_CAP_CORE128_M6_R1_0/CAP_BOTTOM_120 GND nfet_03v3 ad=0 pd=0 as=0 ps=0 w=1.56u l=0.28u
X3698 VREFN A44_DCTRL_STRIP_W_R2_0/CTRL_OUT[7] A44_CDAC_CAP_BANK_ASSEMBLY_R8_M6_0/A44_CAP_CORE128_M6_R1_0/CAP_BOTTOM_120 GND nfet_03v3 ad=0 pd=0 as=0 ps=0 w=1.56u l=0.28u
X3699 VREFN A44_DCTRL_STRIP_W_R2_0/CTRL_OUT[7] A44_CDAC_CAP_BANK_ASSEMBLY_R8_M6_0/A44_CAP_CORE128_M6_R1_0/CAP_BOTTOM_120 GND nfet_03v3 ad=0 pd=0 as=0 ps=0 w=1.56u l=0.28u
X3700 VREFN A44_DCTRL_STRIP_W_R2_0/CTRL_OUT[7] A44_CDAC_CAP_BANK_ASSEMBLY_R8_M6_0/A44_CAP_CORE128_M6_R1_0/CAP_BOTTOM_120 GND nfet_03v3 ad=0 pd=0 as=0 ps=0 w=1.56u l=0.28u
X3701 VREFN A44_DCTRL_STRIP_W_R2_0/CTRL_OUT[7] A44_CDAC_CAP_BANK_ASSEMBLY_R8_M6_0/A44_CAP_CORE128_M6_R1_0/CAP_BOTTOM_120 GND nfet_03v3 ad=0 pd=0 as=0 ps=0 w=1.56u l=0.28u
X3702 VREFN A44_DCTRL_STRIP_W_R2_0/CTRL_OUT[7] A44_CDAC_CAP_BANK_ASSEMBLY_R8_M6_0/A44_CAP_CORE128_M6_R1_0/CAP_BOTTOM_120 GND nfet_03v3 ad=0 pd=0 as=0 ps=0 w=1.56u l=0.28u
X3703 VREFN A44_DCTRL_STRIP_W_R2_0/CTRL_OUT[7] A44_CDAC_CAP_BANK_ASSEMBLY_R8_M6_0/A44_CAP_CORE128_M6_R1_0/CAP_BOTTOM_120 GND nfet_03v3 ad=0 pd=0 as=0 ps=0 w=1.56u l=0.28u
X3704 VREFN A44_DCTRL_STRIP_W_R2_0/CTRL_OUT[7] A44_CDAC_CAP_BANK_ASSEMBLY_R8_M6_0/A44_CAP_CORE128_M6_R1_0/CAP_BOTTOM_120 GND nfet_03v3 ad=0 pd=0 as=0 ps=0 w=1.56u l=0.28u
X3705 VREFN A44_DCTRL_STRIP_W_R2_0/CTRL_OUT[7] A44_CDAC_CAP_BANK_ASSEMBLY_R8_M6_0/A44_CAP_CORE128_M6_R1_0/CAP_BOTTOM_120 GND nfet_03v3 ad=0 pd=0 as=0 ps=0 w=1.56u l=0.28u
X3706 VREFN A44_DCTRL_STRIP_W_R2_0/CTRL_OUT[7] A44_CDAC_CAP_BANK_ASSEMBLY_R8_M6_0/A44_CAP_CORE128_M6_R1_0/CAP_BOTTOM_120 GND nfet_03v3 ad=0 pd=0 as=0 ps=0 w=1.56u l=0.28u
X3707 VREFN A44_DCTRL_STRIP_W_R2_0/CTRL_OUT[7] A44_CDAC_CAP_BANK_ASSEMBLY_R8_M6_0/A44_CAP_CORE128_M6_R1_0/CAP_BOTTOM_120 GND nfet_03v3 ad=0 pd=0 as=0 ps=0 w=1.56u l=0.28u
X3708 VREFN A44_DCTRL_STRIP_W_R2_0/CTRL_OUT[7] A44_CDAC_CAP_BANK_ASSEMBLY_R8_M6_0/A44_CAP_CORE128_M6_R1_0/CAP_BOTTOM_120 GND nfet_03v3 ad=0 pd=0 as=0 ps=0 w=1.56u l=0.28u
X3709 VREFN A44_DCTRL_STRIP_W_R2_0/CTRL_OUT[7] A44_CDAC_CAP_BANK_ASSEMBLY_R8_M6_0/A44_CAP_CORE128_M6_R1_0/CAP_BOTTOM_120 GND nfet_03v3 ad=0 pd=0 as=0 ps=0 w=1.56u l=0.28u
X3710 VREFP A44_DCTRL_STRIP_W_R2_0/CTRL_OUT[5] A44_CDAC_CAP_BANK_ASSEMBLY_R8_M6_0/A44_CAP_CORE128_M6_R1_0/CAP_BOTTOM_117 VDD pfet_03v3 ad=0 pd=0 as=16.6842p ps=77.76u w=1.56u l=0.28u
X3711 VREFP A44_DCTRL_STRIP_W_R2_0/CTRL_OUT[5] A44_CDAC_CAP_BANK_ASSEMBLY_R8_M6_0/A44_CAP_CORE128_M6_R1_0/CAP_BOTTOM_117 VDD pfet_03v3 ad=0 pd=0 as=0 ps=0 w=1.56u l=0.28u
X3712 VREFP A44_DCTRL_STRIP_W_R2_0/CTRL_OUT[5] A44_CDAC_CAP_BANK_ASSEMBLY_R8_M6_0/A44_CAP_CORE128_M6_R1_0/CAP_BOTTOM_117 VDD pfet_03v3 ad=0 pd=0 as=0 ps=0 w=1.56u l=0.28u
X3713 VREFP A44_DCTRL_STRIP_W_R2_0/CTRL_OUT[5] A44_CDAC_CAP_BANK_ASSEMBLY_R8_M6_0/A44_CAP_CORE128_M6_R1_0/CAP_BOTTOM_117 VDD pfet_03v3 ad=0 pd=0 as=0 ps=0 w=1.56u l=0.28u
X3714 VREFP A44_DCTRL_STRIP_W_R2_0/CTRL_OUT[5] A44_CDAC_CAP_BANK_ASSEMBLY_R8_M6_0/A44_CAP_CORE128_M6_R1_0/CAP_BOTTOM_117 VDD pfet_03v3 ad=0 pd=0 as=0 ps=0 w=1.56u l=0.28u
X3715 VREFP A44_DCTRL_STRIP_W_R2_0/CTRL_OUT[5] A44_CDAC_CAP_BANK_ASSEMBLY_R8_M6_0/A44_CAP_CORE128_M6_R1_0/CAP_BOTTOM_117 VDD pfet_03v3 ad=0 pd=0 as=0 ps=0 w=1.56u l=0.28u
X3716 VREFP A44_DCTRL_STRIP_W_R2_0/CTRL_OUT[5] A44_CDAC_CAP_BANK_ASSEMBLY_R8_M6_0/A44_CAP_CORE128_M6_R1_0/CAP_BOTTOM_117 VDD pfet_03v3 ad=0 pd=0 as=0 ps=0 w=1.56u l=0.28u
X3717 VREFP A44_DCTRL_STRIP_W_R2_0/CTRL_OUT[5] A44_CDAC_CAP_BANK_ASSEMBLY_R8_M6_0/A44_CAP_CORE128_M6_R1_0/CAP_BOTTOM_117 VDD pfet_03v3 ad=0 pd=0 as=0 ps=0 w=1.56u l=0.28u
X3718 VREFP A44_DCTRL_STRIP_W_R2_0/CTRL_OUT[5] A44_CDAC_CAP_BANK_ASSEMBLY_R8_M6_0/A44_CAP_CORE128_M6_R1_0/CAP_BOTTOM_117 VDD pfet_03v3 ad=0 pd=0 as=0 ps=0 w=1.56u l=0.28u
X3719 VREFP A44_DCTRL_STRIP_W_R2_0/CTRL_OUT[5] A44_CDAC_CAP_BANK_ASSEMBLY_R8_M6_0/A44_CAP_CORE128_M6_R1_0/CAP_BOTTOM_117 VDD pfet_03v3 ad=0 pd=0 as=0 ps=0 w=1.56u l=0.28u
X3720 VREFP A44_DCTRL_STRIP_W_R2_0/CTRL_OUT[5] A44_CDAC_CAP_BANK_ASSEMBLY_R8_M6_0/A44_CAP_CORE128_M6_R1_0/CAP_BOTTOM_117 VDD pfet_03v3 ad=0 pd=0 as=0 ps=0 w=1.56u l=0.28u
X3721 VREFP A44_DCTRL_STRIP_W_R2_0/CTRL_OUT[5] A44_CDAC_CAP_BANK_ASSEMBLY_R8_M6_0/A44_CAP_CORE128_M6_R1_0/CAP_BOTTOM_117 VDD pfet_03v3 ad=0 pd=0 as=0 ps=0 w=1.56u l=0.28u
X3722 VREFP A44_DCTRL_STRIP_W_R2_0/CTRL_OUT[5] A44_CDAC_CAP_BANK_ASSEMBLY_R8_M6_0/A44_CAP_CORE128_M6_R1_0/CAP_BOTTOM_117 VDD pfet_03v3 ad=0 pd=0 as=0 ps=0 w=1.56u l=0.28u
X3723 VREFP A44_DCTRL_STRIP_W_R2_0/CTRL_OUT[5] A44_CDAC_CAP_BANK_ASSEMBLY_R8_M6_0/A44_CAP_CORE128_M6_R1_0/CAP_BOTTOM_117 VDD pfet_03v3 ad=0 pd=0 as=0 ps=0 w=1.56u l=0.28u
X3724 VREFP A44_DCTRL_STRIP_W_R2_0/CTRL_OUT[5] A44_CDAC_CAP_BANK_ASSEMBLY_R8_M6_0/A44_CAP_CORE128_M6_R1_0/CAP_BOTTOM_117 VDD pfet_03v3 ad=0 pd=0 as=0 ps=0 w=1.56u l=0.28u
X3725 VREFP A44_DCTRL_STRIP_W_R2_0/CTRL_OUT[5] A44_CDAC_CAP_BANK_ASSEMBLY_R8_M6_0/A44_CAP_CORE128_M6_R1_0/CAP_BOTTOM_117 VDD pfet_03v3 ad=0 pd=0 as=0 ps=0 w=1.56u l=0.28u
X3726 VREFP A44_DCTRL_STRIP_W_R2_0/CTRL_OUT[5] A44_CDAC_CAP_BANK_ASSEMBLY_R8_M6_0/A44_CAP_CORE128_M6_R1_0/CAP_BOTTOM_117 VDD pfet_03v3 ad=0 pd=0 as=0 ps=0 w=1.56u l=0.28u
X3727 VREFP A44_DCTRL_STRIP_W_R2_0/CTRL_OUT[5] A44_CDAC_CAP_BANK_ASSEMBLY_R8_M6_0/A44_CAP_CORE128_M6_R1_0/CAP_BOTTOM_117 VDD pfet_03v3 ad=0 pd=0 as=0 ps=0 w=1.56u l=0.28u
X3728 VREFN A44_DCTRL_STRIP_W_R2_0/CTRL_OUT[5] A44_CDAC_CAP_BANK_ASSEMBLY_R8_M6_0/A44_CAP_CORE128_M6_R1_0/CAP_BOTTOM_117 GND nfet_03v3 ad=0 pd=0 as=16.6842p ps=77.76u w=1.56u l=0.28u
X3729 VREFN A44_DCTRL_STRIP_W_R2_0/CTRL_OUT[5] A44_CDAC_CAP_BANK_ASSEMBLY_R8_M6_0/A44_CAP_CORE128_M6_R1_0/CAP_BOTTOM_117 GND nfet_03v3 ad=0 pd=0 as=0 ps=0 w=1.56u l=0.28u
X3730 VREFN A44_DCTRL_STRIP_W_R2_0/CTRL_OUT[5] A44_CDAC_CAP_BANK_ASSEMBLY_R8_M6_0/A44_CAP_CORE128_M6_R1_0/CAP_BOTTOM_117 GND nfet_03v3 ad=0 pd=0 as=0 ps=0 w=1.56u l=0.28u
X3731 VREFN A44_DCTRL_STRIP_W_R2_0/CTRL_OUT[5] A44_CDAC_CAP_BANK_ASSEMBLY_R8_M6_0/A44_CAP_CORE128_M6_R1_0/CAP_BOTTOM_117 GND nfet_03v3 ad=0 pd=0 as=0 ps=0 w=1.56u l=0.28u
X3732 VREFN A44_DCTRL_STRIP_W_R2_0/CTRL_OUT[5] A44_CDAC_CAP_BANK_ASSEMBLY_R8_M6_0/A44_CAP_CORE128_M6_R1_0/CAP_BOTTOM_117 GND nfet_03v3 ad=0 pd=0 as=0 ps=0 w=1.56u l=0.28u
X3733 VREFN A44_DCTRL_STRIP_W_R2_0/CTRL_OUT[5] A44_CDAC_CAP_BANK_ASSEMBLY_R8_M6_0/A44_CAP_CORE128_M6_R1_0/CAP_BOTTOM_117 GND nfet_03v3 ad=0 pd=0 as=0 ps=0 w=1.56u l=0.28u
X3734 VREFN A44_DCTRL_STRIP_W_R2_0/CTRL_OUT[5] A44_CDAC_CAP_BANK_ASSEMBLY_R8_M6_0/A44_CAP_CORE128_M6_R1_0/CAP_BOTTOM_117 GND nfet_03v3 ad=0 pd=0 as=0 ps=0 w=1.56u l=0.28u
X3735 VREFN A44_DCTRL_STRIP_W_R2_0/CTRL_OUT[5] A44_CDAC_CAP_BANK_ASSEMBLY_R8_M6_0/A44_CAP_CORE128_M6_R1_0/CAP_BOTTOM_117 GND nfet_03v3 ad=0 pd=0 as=0 ps=0 w=1.56u l=0.28u
X3736 VREFN A44_DCTRL_STRIP_W_R2_0/CTRL_OUT[5] A44_CDAC_CAP_BANK_ASSEMBLY_R8_M6_0/A44_CAP_CORE128_M6_R1_0/CAP_BOTTOM_117 GND nfet_03v3 ad=0 pd=0 as=0 ps=0 w=1.56u l=0.28u
X3737 VREFN A44_DCTRL_STRIP_W_R2_0/CTRL_OUT[5] A44_CDAC_CAP_BANK_ASSEMBLY_R8_M6_0/A44_CAP_CORE128_M6_R1_0/CAP_BOTTOM_117 GND nfet_03v3 ad=0 pd=0 as=0 ps=0 w=1.56u l=0.28u
X3738 VREFN A44_DCTRL_STRIP_W_R2_0/CTRL_OUT[5] A44_CDAC_CAP_BANK_ASSEMBLY_R8_M6_0/A44_CAP_CORE128_M6_R1_0/CAP_BOTTOM_117 GND nfet_03v3 ad=0 pd=0 as=0 ps=0 w=1.56u l=0.28u
X3739 VREFN A44_DCTRL_STRIP_W_R2_0/CTRL_OUT[5] A44_CDAC_CAP_BANK_ASSEMBLY_R8_M6_0/A44_CAP_CORE128_M6_R1_0/CAP_BOTTOM_117 GND nfet_03v3 ad=0 pd=0 as=0 ps=0 w=1.56u l=0.28u
X3740 VREFN A44_DCTRL_STRIP_W_R2_0/CTRL_OUT[5] A44_CDAC_CAP_BANK_ASSEMBLY_R8_M6_0/A44_CAP_CORE128_M6_R1_0/CAP_BOTTOM_117 GND nfet_03v3 ad=0 pd=0 as=0 ps=0 w=1.56u l=0.28u
X3741 VREFN A44_DCTRL_STRIP_W_R2_0/CTRL_OUT[5] A44_CDAC_CAP_BANK_ASSEMBLY_R8_M6_0/A44_CAP_CORE128_M6_R1_0/CAP_BOTTOM_117 GND nfet_03v3 ad=0 pd=0 as=0 ps=0 w=1.56u l=0.28u
X3742 VREFN A44_DCTRL_STRIP_W_R2_0/CTRL_OUT[5] A44_CDAC_CAP_BANK_ASSEMBLY_R8_M6_0/A44_CAP_CORE128_M6_R1_0/CAP_BOTTOM_117 GND nfet_03v3 ad=0 pd=0 as=0 ps=0 w=1.56u l=0.28u
X3743 VREFN A44_DCTRL_STRIP_W_R2_0/CTRL_OUT[5] A44_CDAC_CAP_BANK_ASSEMBLY_R8_M6_0/A44_CAP_CORE128_M6_R1_0/CAP_BOTTOM_117 GND nfet_03v3 ad=0 pd=0 as=0 ps=0 w=1.56u l=0.28u
X3744 VREFN A44_DCTRL_STRIP_W_R2_0/CTRL_OUT[5] A44_CDAC_CAP_BANK_ASSEMBLY_R8_M6_0/A44_CAP_CORE128_M6_R1_0/CAP_BOTTOM_117 GND nfet_03v3 ad=0 pd=0 as=0 ps=0 w=1.56u l=0.28u
X3745 VREFN A44_DCTRL_STRIP_W_R2_0/CTRL_OUT[5] A44_CDAC_CAP_BANK_ASSEMBLY_R8_M6_0/A44_CAP_CORE128_M6_R1_0/CAP_BOTTOM_117 GND nfet_03v3 ad=0 pd=0 as=0 ps=0 w=1.56u l=0.28u
X3746 VREFP A44_DCTRL_STRIP_W_R2_0/CTRL_OUT[7] A44_CDAC_CAP_BANK_ASSEMBLY_R8_M6_0/A44_CAP_CORE128_M6_R1_0/CAP_BOTTOM_114 VDD pfet_03v3 ad=0 pd=0 as=16.6842p ps=77.76u w=1.56u l=0.28u
X3747 VREFP A44_DCTRL_STRIP_W_R2_0/CTRL_OUT[7] A44_CDAC_CAP_BANK_ASSEMBLY_R8_M6_0/A44_CAP_CORE128_M6_R1_0/CAP_BOTTOM_114 VDD pfet_03v3 ad=0 pd=0 as=0 ps=0 w=1.56u l=0.28u
X3748 VREFP A44_DCTRL_STRIP_W_R2_0/CTRL_OUT[7] A44_CDAC_CAP_BANK_ASSEMBLY_R8_M6_0/A44_CAP_CORE128_M6_R1_0/CAP_BOTTOM_114 VDD pfet_03v3 ad=0 pd=0 as=0 ps=0 w=1.56u l=0.28u
X3749 VREFP A44_DCTRL_STRIP_W_R2_0/CTRL_OUT[7] A44_CDAC_CAP_BANK_ASSEMBLY_R8_M6_0/A44_CAP_CORE128_M6_R1_0/CAP_BOTTOM_114 VDD pfet_03v3 ad=0 pd=0 as=0 ps=0 w=1.56u l=0.28u
X3750 VREFP A44_DCTRL_STRIP_W_R2_0/CTRL_OUT[7] A44_CDAC_CAP_BANK_ASSEMBLY_R8_M6_0/A44_CAP_CORE128_M6_R1_0/CAP_BOTTOM_114 VDD pfet_03v3 ad=0 pd=0 as=0 ps=0 w=1.56u l=0.28u
X3751 VREFP A44_DCTRL_STRIP_W_R2_0/CTRL_OUT[7] A44_CDAC_CAP_BANK_ASSEMBLY_R8_M6_0/A44_CAP_CORE128_M6_R1_0/CAP_BOTTOM_114 VDD pfet_03v3 ad=0 pd=0 as=0 ps=0 w=1.56u l=0.28u
X3752 VREFP A44_DCTRL_STRIP_W_R2_0/CTRL_OUT[7] A44_CDAC_CAP_BANK_ASSEMBLY_R8_M6_0/A44_CAP_CORE128_M6_R1_0/CAP_BOTTOM_114 VDD pfet_03v3 ad=0 pd=0 as=0 ps=0 w=1.56u l=0.28u
X3753 VREFP A44_DCTRL_STRIP_W_R2_0/CTRL_OUT[7] A44_CDAC_CAP_BANK_ASSEMBLY_R8_M6_0/A44_CAP_CORE128_M6_R1_0/CAP_BOTTOM_114 VDD pfet_03v3 ad=0 pd=0 as=0 ps=0 w=1.56u l=0.28u
X3754 VREFP A44_DCTRL_STRIP_W_R2_0/CTRL_OUT[7] A44_CDAC_CAP_BANK_ASSEMBLY_R8_M6_0/A44_CAP_CORE128_M6_R1_0/CAP_BOTTOM_114 VDD pfet_03v3 ad=0 pd=0 as=0 ps=0 w=1.56u l=0.28u
X3755 VREFP A44_DCTRL_STRIP_W_R2_0/CTRL_OUT[7] A44_CDAC_CAP_BANK_ASSEMBLY_R8_M6_0/A44_CAP_CORE128_M6_R1_0/CAP_BOTTOM_114 VDD pfet_03v3 ad=0 pd=0 as=0 ps=0 w=1.56u l=0.28u
X3756 VREFP A44_DCTRL_STRIP_W_R2_0/CTRL_OUT[7] A44_CDAC_CAP_BANK_ASSEMBLY_R8_M6_0/A44_CAP_CORE128_M6_R1_0/CAP_BOTTOM_114 VDD pfet_03v3 ad=0 pd=0 as=0 ps=0 w=1.56u l=0.28u
X3757 VREFP A44_DCTRL_STRIP_W_R2_0/CTRL_OUT[7] A44_CDAC_CAP_BANK_ASSEMBLY_R8_M6_0/A44_CAP_CORE128_M6_R1_0/CAP_BOTTOM_114 VDD pfet_03v3 ad=0 pd=0 as=0 ps=0 w=1.56u l=0.28u
X3758 VREFP A44_DCTRL_STRIP_W_R2_0/CTRL_OUT[7] A44_CDAC_CAP_BANK_ASSEMBLY_R8_M6_0/A44_CAP_CORE128_M6_R1_0/CAP_BOTTOM_114 VDD pfet_03v3 ad=0 pd=0 as=0 ps=0 w=1.56u l=0.28u
X3759 VREFP A44_DCTRL_STRIP_W_R2_0/CTRL_OUT[7] A44_CDAC_CAP_BANK_ASSEMBLY_R8_M6_0/A44_CAP_CORE128_M6_R1_0/CAP_BOTTOM_114 VDD pfet_03v3 ad=0 pd=0 as=0 ps=0 w=1.56u l=0.28u
X3760 VREFP A44_DCTRL_STRIP_W_R2_0/CTRL_OUT[7] A44_CDAC_CAP_BANK_ASSEMBLY_R8_M6_0/A44_CAP_CORE128_M6_R1_0/CAP_BOTTOM_114 VDD pfet_03v3 ad=0 pd=0 as=0 ps=0 w=1.56u l=0.28u
X3761 VREFP A44_DCTRL_STRIP_W_R2_0/CTRL_OUT[7] A44_CDAC_CAP_BANK_ASSEMBLY_R8_M6_0/A44_CAP_CORE128_M6_R1_0/CAP_BOTTOM_114 VDD pfet_03v3 ad=0 pd=0 as=0 ps=0 w=1.56u l=0.28u
X3762 VREFP A44_DCTRL_STRIP_W_R2_0/CTRL_OUT[7] A44_CDAC_CAP_BANK_ASSEMBLY_R8_M6_0/A44_CAP_CORE128_M6_R1_0/CAP_BOTTOM_114 VDD pfet_03v3 ad=0 pd=0 as=0 ps=0 w=1.56u l=0.28u
X3763 VREFP A44_DCTRL_STRIP_W_R2_0/CTRL_OUT[7] A44_CDAC_CAP_BANK_ASSEMBLY_R8_M6_0/A44_CAP_CORE128_M6_R1_0/CAP_BOTTOM_114 VDD pfet_03v3 ad=0 pd=0 as=0 ps=0 w=1.56u l=0.28u
X3764 VREFN A44_DCTRL_STRIP_W_R2_0/CTRL_OUT[7] A44_CDAC_CAP_BANK_ASSEMBLY_R8_M6_0/A44_CAP_CORE128_M6_R1_0/CAP_BOTTOM_114 GND nfet_03v3 ad=0 pd=0 as=16.6842p ps=77.76u w=1.56u l=0.28u
X3765 VREFN A44_DCTRL_STRIP_W_R2_0/CTRL_OUT[7] A44_CDAC_CAP_BANK_ASSEMBLY_R8_M6_0/A44_CAP_CORE128_M6_R1_0/CAP_BOTTOM_114 GND nfet_03v3 ad=0 pd=0 as=0 ps=0 w=1.56u l=0.28u
X3766 VREFN A44_DCTRL_STRIP_W_R2_0/CTRL_OUT[7] A44_CDAC_CAP_BANK_ASSEMBLY_R8_M6_0/A44_CAP_CORE128_M6_R1_0/CAP_BOTTOM_114 GND nfet_03v3 ad=0 pd=0 as=0 ps=0 w=1.56u l=0.28u
X3767 VREFN A44_DCTRL_STRIP_W_R2_0/CTRL_OUT[7] A44_CDAC_CAP_BANK_ASSEMBLY_R8_M6_0/A44_CAP_CORE128_M6_R1_0/CAP_BOTTOM_114 GND nfet_03v3 ad=0 pd=0 as=0 ps=0 w=1.56u l=0.28u
X3768 VREFN A44_DCTRL_STRIP_W_R2_0/CTRL_OUT[7] A44_CDAC_CAP_BANK_ASSEMBLY_R8_M6_0/A44_CAP_CORE128_M6_R1_0/CAP_BOTTOM_114 GND nfet_03v3 ad=0 pd=0 as=0 ps=0 w=1.56u l=0.28u
X3769 VREFN A44_DCTRL_STRIP_W_R2_0/CTRL_OUT[7] A44_CDAC_CAP_BANK_ASSEMBLY_R8_M6_0/A44_CAP_CORE128_M6_R1_0/CAP_BOTTOM_114 GND nfet_03v3 ad=0 pd=0 as=0 ps=0 w=1.56u l=0.28u
X3770 VREFN A44_DCTRL_STRIP_W_R2_0/CTRL_OUT[7] A44_CDAC_CAP_BANK_ASSEMBLY_R8_M6_0/A44_CAP_CORE128_M6_R1_0/CAP_BOTTOM_114 GND nfet_03v3 ad=0 pd=0 as=0 ps=0 w=1.56u l=0.28u
X3771 VREFN A44_DCTRL_STRIP_W_R2_0/CTRL_OUT[7] A44_CDAC_CAP_BANK_ASSEMBLY_R8_M6_0/A44_CAP_CORE128_M6_R1_0/CAP_BOTTOM_114 GND nfet_03v3 ad=0 pd=0 as=0 ps=0 w=1.56u l=0.28u
X3772 VREFN A44_DCTRL_STRIP_W_R2_0/CTRL_OUT[7] A44_CDAC_CAP_BANK_ASSEMBLY_R8_M6_0/A44_CAP_CORE128_M6_R1_0/CAP_BOTTOM_114 GND nfet_03v3 ad=0 pd=0 as=0 ps=0 w=1.56u l=0.28u
X3773 VREFN A44_DCTRL_STRIP_W_R2_0/CTRL_OUT[7] A44_CDAC_CAP_BANK_ASSEMBLY_R8_M6_0/A44_CAP_CORE128_M6_R1_0/CAP_BOTTOM_114 GND nfet_03v3 ad=0 pd=0 as=0 ps=0 w=1.56u l=0.28u
X3774 VREFN A44_DCTRL_STRIP_W_R2_0/CTRL_OUT[7] A44_CDAC_CAP_BANK_ASSEMBLY_R8_M6_0/A44_CAP_CORE128_M6_R1_0/CAP_BOTTOM_114 GND nfet_03v3 ad=0 pd=0 as=0 ps=0 w=1.56u l=0.28u
X3775 VREFN A44_DCTRL_STRIP_W_R2_0/CTRL_OUT[7] A44_CDAC_CAP_BANK_ASSEMBLY_R8_M6_0/A44_CAP_CORE128_M6_R1_0/CAP_BOTTOM_114 GND nfet_03v3 ad=0 pd=0 as=0 ps=0 w=1.56u l=0.28u
X3776 VREFN A44_DCTRL_STRIP_W_R2_0/CTRL_OUT[7] A44_CDAC_CAP_BANK_ASSEMBLY_R8_M6_0/A44_CAP_CORE128_M6_R1_0/CAP_BOTTOM_114 GND nfet_03v3 ad=0 pd=0 as=0 ps=0 w=1.56u l=0.28u
X3777 VREFN A44_DCTRL_STRIP_W_R2_0/CTRL_OUT[7] A44_CDAC_CAP_BANK_ASSEMBLY_R8_M6_0/A44_CAP_CORE128_M6_R1_0/CAP_BOTTOM_114 GND nfet_03v3 ad=0 pd=0 as=0 ps=0 w=1.56u l=0.28u
X3778 VREFN A44_DCTRL_STRIP_W_R2_0/CTRL_OUT[7] A44_CDAC_CAP_BANK_ASSEMBLY_R8_M6_0/A44_CAP_CORE128_M6_R1_0/CAP_BOTTOM_114 GND nfet_03v3 ad=0 pd=0 as=0 ps=0 w=1.56u l=0.28u
X3779 VREFN A44_DCTRL_STRIP_W_R2_0/CTRL_OUT[7] A44_CDAC_CAP_BANK_ASSEMBLY_R8_M6_0/A44_CAP_CORE128_M6_R1_0/CAP_BOTTOM_114 GND nfet_03v3 ad=0 pd=0 as=0 ps=0 w=1.56u l=0.28u
X3780 VREFN A44_DCTRL_STRIP_W_R2_0/CTRL_OUT[7] A44_CDAC_CAP_BANK_ASSEMBLY_R8_M6_0/A44_CAP_CORE128_M6_R1_0/CAP_BOTTOM_114 GND nfet_03v3 ad=0 pd=0 as=0 ps=0 w=1.56u l=0.28u
X3781 VREFN A44_DCTRL_STRIP_W_R2_0/CTRL_OUT[7] A44_CDAC_CAP_BANK_ASSEMBLY_R8_M6_0/A44_CAP_CORE128_M6_R1_0/CAP_BOTTOM_114 GND nfet_03v3 ad=0 pd=0 as=0 ps=0 w=1.56u l=0.28u
X3782 VREFP A44_DCTRL_STRIP_W_R2_0/CTRL_OUT[6] A44_CDAC_CAP_BANK_ASSEMBLY_R8_M6_0/A44_CAP_CORE128_M6_R1_0/CAP_BOTTOM_080 VDD pfet_03v3 ad=0 pd=0 as=16.6842p ps=77.76u w=1.56u l=0.28u
X3783 VREFP A44_DCTRL_STRIP_W_R2_0/CTRL_OUT[6] A44_CDAC_CAP_BANK_ASSEMBLY_R8_M6_0/A44_CAP_CORE128_M6_R1_0/CAP_BOTTOM_080 VDD pfet_03v3 ad=0 pd=0 as=0 ps=0 w=1.56u l=0.28u
X3784 VREFP A44_DCTRL_STRIP_W_R2_0/CTRL_OUT[6] A44_CDAC_CAP_BANK_ASSEMBLY_R8_M6_0/A44_CAP_CORE128_M6_R1_0/CAP_BOTTOM_080 VDD pfet_03v3 ad=0 pd=0 as=0 ps=0 w=1.56u l=0.28u
X3785 VREFP A44_DCTRL_STRIP_W_R2_0/CTRL_OUT[6] A44_CDAC_CAP_BANK_ASSEMBLY_R8_M6_0/A44_CAP_CORE128_M6_R1_0/CAP_BOTTOM_080 VDD pfet_03v3 ad=0 pd=0 as=0 ps=0 w=1.56u l=0.28u
X3786 VREFP A44_DCTRL_STRIP_W_R2_0/CTRL_OUT[6] A44_CDAC_CAP_BANK_ASSEMBLY_R8_M6_0/A44_CAP_CORE128_M6_R1_0/CAP_BOTTOM_080 VDD pfet_03v3 ad=0 pd=0 as=0 ps=0 w=1.56u l=0.28u
X3787 VREFP A44_DCTRL_STRIP_W_R2_0/CTRL_OUT[6] A44_CDAC_CAP_BANK_ASSEMBLY_R8_M6_0/A44_CAP_CORE128_M6_R1_0/CAP_BOTTOM_080 VDD pfet_03v3 ad=0 pd=0 as=0 ps=0 w=1.56u l=0.28u
X3788 VREFP A44_DCTRL_STRIP_W_R2_0/CTRL_OUT[6] A44_CDAC_CAP_BANK_ASSEMBLY_R8_M6_0/A44_CAP_CORE128_M6_R1_0/CAP_BOTTOM_080 VDD pfet_03v3 ad=0 pd=0 as=0 ps=0 w=1.56u l=0.28u
X3789 VREFP A44_DCTRL_STRIP_W_R2_0/CTRL_OUT[6] A44_CDAC_CAP_BANK_ASSEMBLY_R8_M6_0/A44_CAP_CORE128_M6_R1_0/CAP_BOTTOM_080 VDD pfet_03v3 ad=0 pd=0 as=0 ps=0 w=1.56u l=0.28u
X3790 VREFP A44_DCTRL_STRIP_W_R2_0/CTRL_OUT[6] A44_CDAC_CAP_BANK_ASSEMBLY_R8_M6_0/A44_CAP_CORE128_M6_R1_0/CAP_BOTTOM_080 VDD pfet_03v3 ad=0 pd=0 as=0 ps=0 w=1.56u l=0.28u
X3791 VREFP A44_DCTRL_STRIP_W_R2_0/CTRL_OUT[6] A44_CDAC_CAP_BANK_ASSEMBLY_R8_M6_0/A44_CAP_CORE128_M6_R1_0/CAP_BOTTOM_080 VDD pfet_03v3 ad=0 pd=0 as=0 ps=0 w=1.56u l=0.28u
X3792 VREFP A44_DCTRL_STRIP_W_R2_0/CTRL_OUT[6] A44_CDAC_CAP_BANK_ASSEMBLY_R8_M6_0/A44_CAP_CORE128_M6_R1_0/CAP_BOTTOM_080 VDD pfet_03v3 ad=0 pd=0 as=0 ps=0 w=1.56u l=0.28u
X3793 VREFP A44_DCTRL_STRIP_W_R2_0/CTRL_OUT[6] A44_CDAC_CAP_BANK_ASSEMBLY_R8_M6_0/A44_CAP_CORE128_M6_R1_0/CAP_BOTTOM_080 VDD pfet_03v3 ad=0 pd=0 as=0 ps=0 w=1.56u l=0.28u
X3794 VREFP A44_DCTRL_STRIP_W_R2_0/CTRL_OUT[6] A44_CDAC_CAP_BANK_ASSEMBLY_R8_M6_0/A44_CAP_CORE128_M6_R1_0/CAP_BOTTOM_080 VDD pfet_03v3 ad=0 pd=0 as=0 ps=0 w=1.56u l=0.28u
X3795 VREFP A44_DCTRL_STRIP_W_R2_0/CTRL_OUT[6] A44_CDAC_CAP_BANK_ASSEMBLY_R8_M6_0/A44_CAP_CORE128_M6_R1_0/CAP_BOTTOM_080 VDD pfet_03v3 ad=0 pd=0 as=0 ps=0 w=1.56u l=0.28u
X3796 VREFP A44_DCTRL_STRIP_W_R2_0/CTRL_OUT[6] A44_CDAC_CAP_BANK_ASSEMBLY_R8_M6_0/A44_CAP_CORE128_M6_R1_0/CAP_BOTTOM_080 VDD pfet_03v3 ad=0 pd=0 as=0 ps=0 w=1.56u l=0.28u
X3797 VREFP A44_DCTRL_STRIP_W_R2_0/CTRL_OUT[6] A44_CDAC_CAP_BANK_ASSEMBLY_R8_M6_0/A44_CAP_CORE128_M6_R1_0/CAP_BOTTOM_080 VDD pfet_03v3 ad=0 pd=0 as=0 ps=0 w=1.56u l=0.28u
X3798 VREFP A44_DCTRL_STRIP_W_R2_0/CTRL_OUT[6] A44_CDAC_CAP_BANK_ASSEMBLY_R8_M6_0/A44_CAP_CORE128_M6_R1_0/CAP_BOTTOM_080 VDD pfet_03v3 ad=0 pd=0 as=0 ps=0 w=1.56u l=0.28u
X3799 VREFP A44_DCTRL_STRIP_W_R2_0/CTRL_OUT[6] A44_CDAC_CAP_BANK_ASSEMBLY_R8_M6_0/A44_CAP_CORE128_M6_R1_0/CAP_BOTTOM_080 VDD pfet_03v3 ad=0 pd=0 as=0 ps=0 w=1.56u l=0.28u
X3800 VREFN A44_DCTRL_STRIP_W_R2_0/CTRL_OUT[6] A44_CDAC_CAP_BANK_ASSEMBLY_R8_M6_0/A44_CAP_CORE128_M6_R1_0/CAP_BOTTOM_080 GND nfet_03v3 ad=0 pd=0 as=16.6842p ps=77.76u w=1.56u l=0.28u
X3801 VREFN A44_DCTRL_STRIP_W_R2_0/CTRL_OUT[6] A44_CDAC_CAP_BANK_ASSEMBLY_R8_M6_0/A44_CAP_CORE128_M6_R1_0/CAP_BOTTOM_080 GND nfet_03v3 ad=0 pd=0 as=0 ps=0 w=1.56u l=0.28u
X3802 VREFN A44_DCTRL_STRIP_W_R2_0/CTRL_OUT[6] A44_CDAC_CAP_BANK_ASSEMBLY_R8_M6_0/A44_CAP_CORE128_M6_R1_0/CAP_BOTTOM_080 GND nfet_03v3 ad=0 pd=0 as=0 ps=0 w=1.56u l=0.28u
X3803 VREFN A44_DCTRL_STRIP_W_R2_0/CTRL_OUT[6] A44_CDAC_CAP_BANK_ASSEMBLY_R8_M6_0/A44_CAP_CORE128_M6_R1_0/CAP_BOTTOM_080 GND nfet_03v3 ad=0 pd=0 as=0 ps=0 w=1.56u l=0.28u
X3804 VREFN A44_DCTRL_STRIP_W_R2_0/CTRL_OUT[6] A44_CDAC_CAP_BANK_ASSEMBLY_R8_M6_0/A44_CAP_CORE128_M6_R1_0/CAP_BOTTOM_080 GND nfet_03v3 ad=0 pd=0 as=0 ps=0 w=1.56u l=0.28u
X3805 VREFN A44_DCTRL_STRIP_W_R2_0/CTRL_OUT[6] A44_CDAC_CAP_BANK_ASSEMBLY_R8_M6_0/A44_CAP_CORE128_M6_R1_0/CAP_BOTTOM_080 GND nfet_03v3 ad=0 pd=0 as=0 ps=0 w=1.56u l=0.28u
X3806 VREFN A44_DCTRL_STRIP_W_R2_0/CTRL_OUT[6] A44_CDAC_CAP_BANK_ASSEMBLY_R8_M6_0/A44_CAP_CORE128_M6_R1_0/CAP_BOTTOM_080 GND nfet_03v3 ad=0 pd=0 as=0 ps=0 w=1.56u l=0.28u
X3807 VREFN A44_DCTRL_STRIP_W_R2_0/CTRL_OUT[6] A44_CDAC_CAP_BANK_ASSEMBLY_R8_M6_0/A44_CAP_CORE128_M6_R1_0/CAP_BOTTOM_080 GND nfet_03v3 ad=0 pd=0 as=0 ps=0 w=1.56u l=0.28u
X3808 VREFN A44_DCTRL_STRIP_W_R2_0/CTRL_OUT[6] A44_CDAC_CAP_BANK_ASSEMBLY_R8_M6_0/A44_CAP_CORE128_M6_R1_0/CAP_BOTTOM_080 GND nfet_03v3 ad=0 pd=0 as=0 ps=0 w=1.56u l=0.28u
X3809 VREFN A44_DCTRL_STRIP_W_R2_0/CTRL_OUT[6] A44_CDAC_CAP_BANK_ASSEMBLY_R8_M6_0/A44_CAP_CORE128_M6_R1_0/CAP_BOTTOM_080 GND nfet_03v3 ad=0 pd=0 as=0 ps=0 w=1.56u l=0.28u
X3810 VREFN A44_DCTRL_STRIP_W_R2_0/CTRL_OUT[6] A44_CDAC_CAP_BANK_ASSEMBLY_R8_M6_0/A44_CAP_CORE128_M6_R1_0/CAP_BOTTOM_080 GND nfet_03v3 ad=0 pd=0 as=0 ps=0 w=1.56u l=0.28u
X3811 VREFN A44_DCTRL_STRIP_W_R2_0/CTRL_OUT[6] A44_CDAC_CAP_BANK_ASSEMBLY_R8_M6_0/A44_CAP_CORE128_M6_R1_0/CAP_BOTTOM_080 GND nfet_03v3 ad=0 pd=0 as=0 ps=0 w=1.56u l=0.28u
X3812 VREFN A44_DCTRL_STRIP_W_R2_0/CTRL_OUT[6] A44_CDAC_CAP_BANK_ASSEMBLY_R8_M6_0/A44_CAP_CORE128_M6_R1_0/CAP_BOTTOM_080 GND nfet_03v3 ad=0 pd=0 as=0 ps=0 w=1.56u l=0.28u
X3813 VREFN A44_DCTRL_STRIP_W_R2_0/CTRL_OUT[6] A44_CDAC_CAP_BANK_ASSEMBLY_R8_M6_0/A44_CAP_CORE128_M6_R1_0/CAP_BOTTOM_080 GND nfet_03v3 ad=0 pd=0 as=0 ps=0 w=1.56u l=0.28u
X3814 VREFN A44_DCTRL_STRIP_W_R2_0/CTRL_OUT[6] A44_CDAC_CAP_BANK_ASSEMBLY_R8_M6_0/A44_CAP_CORE128_M6_R1_0/CAP_BOTTOM_080 GND nfet_03v3 ad=0 pd=0 as=0 ps=0 w=1.56u l=0.28u
X3815 VREFN A44_DCTRL_STRIP_W_R2_0/CTRL_OUT[6] A44_CDAC_CAP_BANK_ASSEMBLY_R8_M6_0/A44_CAP_CORE128_M6_R1_0/CAP_BOTTOM_080 GND nfet_03v3 ad=0 pd=0 as=0 ps=0 w=1.56u l=0.28u
X3816 VREFN A44_DCTRL_STRIP_W_R2_0/CTRL_OUT[6] A44_CDAC_CAP_BANK_ASSEMBLY_R8_M6_0/A44_CAP_CORE128_M6_R1_0/CAP_BOTTOM_080 GND nfet_03v3 ad=0 pd=0 as=0 ps=0 w=1.56u l=0.28u
X3817 VREFN A44_DCTRL_STRIP_W_R2_0/CTRL_OUT[6] A44_CDAC_CAP_BANK_ASSEMBLY_R8_M6_0/A44_CAP_CORE128_M6_R1_0/CAP_BOTTOM_080 GND nfet_03v3 ad=0 pd=0 as=0 ps=0 w=1.56u l=0.28u
X3818 VREFP A44_DCTRL_STRIP_W_R2_0/CTRL_OUT[7] A44_CDAC_CAP_BANK_ASSEMBLY_R8_M6_0/A44_CAP_CORE128_M6_R1_0/CAP_BOTTOM_107 VDD pfet_03v3 ad=0 pd=0 as=16.6842p ps=77.76u w=1.56u l=0.28u
X3819 VREFP A44_DCTRL_STRIP_W_R2_0/CTRL_OUT[7] A44_CDAC_CAP_BANK_ASSEMBLY_R8_M6_0/A44_CAP_CORE128_M6_R1_0/CAP_BOTTOM_107 VDD pfet_03v3 ad=0 pd=0 as=0 ps=0 w=1.56u l=0.28u
X3820 VREFP A44_DCTRL_STRIP_W_R2_0/CTRL_OUT[7] A44_CDAC_CAP_BANK_ASSEMBLY_R8_M6_0/A44_CAP_CORE128_M6_R1_0/CAP_BOTTOM_107 VDD pfet_03v3 ad=0 pd=0 as=0 ps=0 w=1.56u l=0.28u
X3821 VREFP A44_DCTRL_STRIP_W_R2_0/CTRL_OUT[7] A44_CDAC_CAP_BANK_ASSEMBLY_R8_M6_0/A44_CAP_CORE128_M6_R1_0/CAP_BOTTOM_107 VDD pfet_03v3 ad=0 pd=0 as=0 ps=0 w=1.56u l=0.28u
X3822 VREFP A44_DCTRL_STRIP_W_R2_0/CTRL_OUT[7] A44_CDAC_CAP_BANK_ASSEMBLY_R8_M6_0/A44_CAP_CORE128_M6_R1_0/CAP_BOTTOM_107 VDD pfet_03v3 ad=0 pd=0 as=0 ps=0 w=1.56u l=0.28u
X3823 VREFP A44_DCTRL_STRIP_W_R2_0/CTRL_OUT[7] A44_CDAC_CAP_BANK_ASSEMBLY_R8_M6_0/A44_CAP_CORE128_M6_R1_0/CAP_BOTTOM_107 VDD pfet_03v3 ad=0 pd=0 as=0 ps=0 w=1.56u l=0.28u
X3824 VREFP A44_DCTRL_STRIP_W_R2_0/CTRL_OUT[7] A44_CDAC_CAP_BANK_ASSEMBLY_R8_M6_0/A44_CAP_CORE128_M6_R1_0/CAP_BOTTOM_107 VDD pfet_03v3 ad=0 pd=0 as=0 ps=0 w=1.56u l=0.28u
X3825 VREFP A44_DCTRL_STRIP_W_R2_0/CTRL_OUT[7] A44_CDAC_CAP_BANK_ASSEMBLY_R8_M6_0/A44_CAP_CORE128_M6_R1_0/CAP_BOTTOM_107 VDD pfet_03v3 ad=0 pd=0 as=0 ps=0 w=1.56u l=0.28u
X3826 VREFP A44_DCTRL_STRIP_W_R2_0/CTRL_OUT[7] A44_CDAC_CAP_BANK_ASSEMBLY_R8_M6_0/A44_CAP_CORE128_M6_R1_0/CAP_BOTTOM_107 VDD pfet_03v3 ad=0 pd=0 as=0 ps=0 w=1.56u l=0.28u
X3827 VREFP A44_DCTRL_STRIP_W_R2_0/CTRL_OUT[7] A44_CDAC_CAP_BANK_ASSEMBLY_R8_M6_0/A44_CAP_CORE128_M6_R1_0/CAP_BOTTOM_107 VDD pfet_03v3 ad=0 pd=0 as=0 ps=0 w=1.56u l=0.28u
X3828 VREFP A44_DCTRL_STRIP_W_R2_0/CTRL_OUT[7] A44_CDAC_CAP_BANK_ASSEMBLY_R8_M6_0/A44_CAP_CORE128_M6_R1_0/CAP_BOTTOM_107 VDD pfet_03v3 ad=0 pd=0 as=0 ps=0 w=1.56u l=0.28u
X3829 VREFP A44_DCTRL_STRIP_W_R2_0/CTRL_OUT[7] A44_CDAC_CAP_BANK_ASSEMBLY_R8_M6_0/A44_CAP_CORE128_M6_R1_0/CAP_BOTTOM_107 VDD pfet_03v3 ad=0 pd=0 as=0 ps=0 w=1.56u l=0.28u
X3830 VREFP A44_DCTRL_STRIP_W_R2_0/CTRL_OUT[7] A44_CDAC_CAP_BANK_ASSEMBLY_R8_M6_0/A44_CAP_CORE128_M6_R1_0/CAP_BOTTOM_107 VDD pfet_03v3 ad=0 pd=0 as=0 ps=0 w=1.56u l=0.28u
X3831 VREFP A44_DCTRL_STRIP_W_R2_0/CTRL_OUT[7] A44_CDAC_CAP_BANK_ASSEMBLY_R8_M6_0/A44_CAP_CORE128_M6_R1_0/CAP_BOTTOM_107 VDD pfet_03v3 ad=0 pd=0 as=0 ps=0 w=1.56u l=0.28u
X3832 VREFP A44_DCTRL_STRIP_W_R2_0/CTRL_OUT[7] A44_CDAC_CAP_BANK_ASSEMBLY_R8_M6_0/A44_CAP_CORE128_M6_R1_0/CAP_BOTTOM_107 VDD pfet_03v3 ad=0 pd=0 as=0 ps=0 w=1.56u l=0.28u
X3833 VREFP A44_DCTRL_STRIP_W_R2_0/CTRL_OUT[7] A44_CDAC_CAP_BANK_ASSEMBLY_R8_M6_0/A44_CAP_CORE128_M6_R1_0/CAP_BOTTOM_107 VDD pfet_03v3 ad=0 pd=0 as=0 ps=0 w=1.56u l=0.28u
X3834 VREFP A44_DCTRL_STRIP_W_R2_0/CTRL_OUT[7] A44_CDAC_CAP_BANK_ASSEMBLY_R8_M6_0/A44_CAP_CORE128_M6_R1_0/CAP_BOTTOM_107 VDD pfet_03v3 ad=0 pd=0 as=0 ps=0 w=1.56u l=0.28u
X3835 VREFP A44_DCTRL_STRIP_W_R2_0/CTRL_OUT[7] A44_CDAC_CAP_BANK_ASSEMBLY_R8_M6_0/A44_CAP_CORE128_M6_R1_0/CAP_BOTTOM_107 VDD pfet_03v3 ad=0 pd=0 as=0 ps=0 w=1.56u l=0.28u
X3836 VREFN A44_DCTRL_STRIP_W_R2_0/CTRL_OUT[7] A44_CDAC_CAP_BANK_ASSEMBLY_R8_M6_0/A44_CAP_CORE128_M6_R1_0/CAP_BOTTOM_107 GND nfet_03v3 ad=0 pd=0 as=16.6842p ps=77.76u w=1.56u l=0.28u
X3837 VREFN A44_DCTRL_STRIP_W_R2_0/CTRL_OUT[7] A44_CDAC_CAP_BANK_ASSEMBLY_R8_M6_0/A44_CAP_CORE128_M6_R1_0/CAP_BOTTOM_107 GND nfet_03v3 ad=0 pd=0 as=0 ps=0 w=1.56u l=0.28u
X3838 VREFN A44_DCTRL_STRIP_W_R2_0/CTRL_OUT[7] A44_CDAC_CAP_BANK_ASSEMBLY_R8_M6_0/A44_CAP_CORE128_M6_R1_0/CAP_BOTTOM_107 GND nfet_03v3 ad=0 pd=0 as=0 ps=0 w=1.56u l=0.28u
X3839 VREFN A44_DCTRL_STRIP_W_R2_0/CTRL_OUT[7] A44_CDAC_CAP_BANK_ASSEMBLY_R8_M6_0/A44_CAP_CORE128_M6_R1_0/CAP_BOTTOM_107 GND nfet_03v3 ad=0 pd=0 as=0 ps=0 w=1.56u l=0.28u
X3840 VREFN A44_DCTRL_STRIP_W_R2_0/CTRL_OUT[7] A44_CDAC_CAP_BANK_ASSEMBLY_R8_M6_0/A44_CAP_CORE128_M6_R1_0/CAP_BOTTOM_107 GND nfet_03v3 ad=0 pd=0 as=0 ps=0 w=1.56u l=0.28u
X3841 VREFN A44_DCTRL_STRIP_W_R2_0/CTRL_OUT[7] A44_CDAC_CAP_BANK_ASSEMBLY_R8_M6_0/A44_CAP_CORE128_M6_R1_0/CAP_BOTTOM_107 GND nfet_03v3 ad=0 pd=0 as=0 ps=0 w=1.56u l=0.28u
X3842 VREFN A44_DCTRL_STRIP_W_R2_0/CTRL_OUT[7] A44_CDAC_CAP_BANK_ASSEMBLY_R8_M6_0/A44_CAP_CORE128_M6_R1_0/CAP_BOTTOM_107 GND nfet_03v3 ad=0 pd=0 as=0 ps=0 w=1.56u l=0.28u
X3843 VREFN A44_DCTRL_STRIP_W_R2_0/CTRL_OUT[7] A44_CDAC_CAP_BANK_ASSEMBLY_R8_M6_0/A44_CAP_CORE128_M6_R1_0/CAP_BOTTOM_107 GND nfet_03v3 ad=0 pd=0 as=0 ps=0 w=1.56u l=0.28u
X3844 VREFN A44_DCTRL_STRIP_W_R2_0/CTRL_OUT[7] A44_CDAC_CAP_BANK_ASSEMBLY_R8_M6_0/A44_CAP_CORE128_M6_R1_0/CAP_BOTTOM_107 GND nfet_03v3 ad=0 pd=0 as=0 ps=0 w=1.56u l=0.28u
X3845 VREFN A44_DCTRL_STRIP_W_R2_0/CTRL_OUT[7] A44_CDAC_CAP_BANK_ASSEMBLY_R8_M6_0/A44_CAP_CORE128_M6_R1_0/CAP_BOTTOM_107 GND nfet_03v3 ad=0 pd=0 as=0 ps=0 w=1.56u l=0.28u
X3846 VREFN A44_DCTRL_STRIP_W_R2_0/CTRL_OUT[7] A44_CDAC_CAP_BANK_ASSEMBLY_R8_M6_0/A44_CAP_CORE128_M6_R1_0/CAP_BOTTOM_107 GND nfet_03v3 ad=0 pd=0 as=0 ps=0 w=1.56u l=0.28u
X3847 VREFN A44_DCTRL_STRIP_W_R2_0/CTRL_OUT[7] A44_CDAC_CAP_BANK_ASSEMBLY_R8_M6_0/A44_CAP_CORE128_M6_R1_0/CAP_BOTTOM_107 GND nfet_03v3 ad=0 pd=0 as=0 ps=0 w=1.56u l=0.28u
X3848 VREFN A44_DCTRL_STRIP_W_R2_0/CTRL_OUT[7] A44_CDAC_CAP_BANK_ASSEMBLY_R8_M6_0/A44_CAP_CORE128_M6_R1_0/CAP_BOTTOM_107 GND nfet_03v3 ad=0 pd=0 as=0 ps=0 w=1.56u l=0.28u
X3849 VREFN A44_DCTRL_STRIP_W_R2_0/CTRL_OUT[7] A44_CDAC_CAP_BANK_ASSEMBLY_R8_M6_0/A44_CAP_CORE128_M6_R1_0/CAP_BOTTOM_107 GND nfet_03v3 ad=0 pd=0 as=0 ps=0 w=1.56u l=0.28u
X3850 VREFN A44_DCTRL_STRIP_W_R2_0/CTRL_OUT[7] A44_CDAC_CAP_BANK_ASSEMBLY_R8_M6_0/A44_CAP_CORE128_M6_R1_0/CAP_BOTTOM_107 GND nfet_03v3 ad=0 pd=0 as=0 ps=0 w=1.56u l=0.28u
X3851 VREFN A44_DCTRL_STRIP_W_R2_0/CTRL_OUT[7] A44_CDAC_CAP_BANK_ASSEMBLY_R8_M6_0/A44_CAP_CORE128_M6_R1_0/CAP_BOTTOM_107 GND nfet_03v3 ad=0 pd=0 as=0 ps=0 w=1.56u l=0.28u
X3852 VREFN A44_DCTRL_STRIP_W_R2_0/CTRL_OUT[7] A44_CDAC_CAP_BANK_ASSEMBLY_R8_M6_0/A44_CAP_CORE128_M6_R1_0/CAP_BOTTOM_107 GND nfet_03v3 ad=0 pd=0 as=0 ps=0 w=1.56u l=0.28u
X3853 VREFN A44_DCTRL_STRIP_W_R2_0/CTRL_OUT[7] A44_CDAC_CAP_BANK_ASSEMBLY_R8_M6_0/A44_CAP_CORE128_M6_R1_0/CAP_BOTTOM_107 GND nfet_03v3 ad=0 pd=0 as=0 ps=0 w=1.56u l=0.28u
X3854 VREFP A44_DCTRL_STRIP_W_R2_0/CTRL_OUT[5] A44_CDAC_CAP_BANK_ASSEMBLY_R8_M6_0/A44_CAP_CORE128_M6_R1_0/CAP_BOTTOM_104 VDD pfet_03v3 ad=0 pd=0 as=16.6842p ps=77.76u w=1.56u l=0.28u
X3855 VREFP A44_DCTRL_STRIP_W_R2_0/CTRL_OUT[5] A44_CDAC_CAP_BANK_ASSEMBLY_R8_M6_0/A44_CAP_CORE128_M6_R1_0/CAP_BOTTOM_104 VDD pfet_03v3 ad=0 pd=0 as=0 ps=0 w=1.56u l=0.28u
X3856 VREFP A44_DCTRL_STRIP_W_R2_0/CTRL_OUT[5] A44_CDAC_CAP_BANK_ASSEMBLY_R8_M6_0/A44_CAP_CORE128_M6_R1_0/CAP_BOTTOM_104 VDD pfet_03v3 ad=0 pd=0 as=0 ps=0 w=1.56u l=0.28u
X3857 VREFP A44_DCTRL_STRIP_W_R2_0/CTRL_OUT[5] A44_CDAC_CAP_BANK_ASSEMBLY_R8_M6_0/A44_CAP_CORE128_M6_R1_0/CAP_BOTTOM_104 VDD pfet_03v3 ad=0 pd=0 as=0 ps=0 w=1.56u l=0.28u
X3858 VREFP A44_DCTRL_STRIP_W_R2_0/CTRL_OUT[5] A44_CDAC_CAP_BANK_ASSEMBLY_R8_M6_0/A44_CAP_CORE128_M6_R1_0/CAP_BOTTOM_104 VDD pfet_03v3 ad=0 pd=0 as=0 ps=0 w=1.56u l=0.28u
X3859 VREFP A44_DCTRL_STRIP_W_R2_0/CTRL_OUT[5] A44_CDAC_CAP_BANK_ASSEMBLY_R8_M6_0/A44_CAP_CORE128_M6_R1_0/CAP_BOTTOM_104 VDD pfet_03v3 ad=0 pd=0 as=0 ps=0 w=1.56u l=0.28u
X3860 VREFP A44_DCTRL_STRIP_W_R2_0/CTRL_OUT[5] A44_CDAC_CAP_BANK_ASSEMBLY_R8_M6_0/A44_CAP_CORE128_M6_R1_0/CAP_BOTTOM_104 VDD pfet_03v3 ad=0 pd=0 as=0 ps=0 w=1.56u l=0.28u
X3861 VREFP A44_DCTRL_STRIP_W_R2_0/CTRL_OUT[5] A44_CDAC_CAP_BANK_ASSEMBLY_R8_M6_0/A44_CAP_CORE128_M6_R1_0/CAP_BOTTOM_104 VDD pfet_03v3 ad=0 pd=0 as=0 ps=0 w=1.56u l=0.28u
X3862 VREFP A44_DCTRL_STRIP_W_R2_0/CTRL_OUT[5] A44_CDAC_CAP_BANK_ASSEMBLY_R8_M6_0/A44_CAP_CORE128_M6_R1_0/CAP_BOTTOM_104 VDD pfet_03v3 ad=0 pd=0 as=0 ps=0 w=1.56u l=0.28u
X3863 VREFP A44_DCTRL_STRIP_W_R2_0/CTRL_OUT[5] A44_CDAC_CAP_BANK_ASSEMBLY_R8_M6_0/A44_CAP_CORE128_M6_R1_0/CAP_BOTTOM_104 VDD pfet_03v3 ad=0 pd=0 as=0 ps=0 w=1.56u l=0.28u
X3864 VREFP A44_DCTRL_STRIP_W_R2_0/CTRL_OUT[5] A44_CDAC_CAP_BANK_ASSEMBLY_R8_M6_0/A44_CAP_CORE128_M6_R1_0/CAP_BOTTOM_104 VDD pfet_03v3 ad=0 pd=0 as=0 ps=0 w=1.56u l=0.28u
X3865 VREFP A44_DCTRL_STRIP_W_R2_0/CTRL_OUT[5] A44_CDAC_CAP_BANK_ASSEMBLY_R8_M6_0/A44_CAP_CORE128_M6_R1_0/CAP_BOTTOM_104 VDD pfet_03v3 ad=0 pd=0 as=0 ps=0 w=1.56u l=0.28u
X3866 VREFP A44_DCTRL_STRIP_W_R2_0/CTRL_OUT[5] A44_CDAC_CAP_BANK_ASSEMBLY_R8_M6_0/A44_CAP_CORE128_M6_R1_0/CAP_BOTTOM_104 VDD pfet_03v3 ad=0 pd=0 as=0 ps=0 w=1.56u l=0.28u
X3867 VREFP A44_DCTRL_STRIP_W_R2_0/CTRL_OUT[5] A44_CDAC_CAP_BANK_ASSEMBLY_R8_M6_0/A44_CAP_CORE128_M6_R1_0/CAP_BOTTOM_104 VDD pfet_03v3 ad=0 pd=0 as=0 ps=0 w=1.56u l=0.28u
X3868 VREFP A44_DCTRL_STRIP_W_R2_0/CTRL_OUT[5] A44_CDAC_CAP_BANK_ASSEMBLY_R8_M6_0/A44_CAP_CORE128_M6_R1_0/CAP_BOTTOM_104 VDD pfet_03v3 ad=0 pd=0 as=0 ps=0 w=1.56u l=0.28u
X3869 VREFP A44_DCTRL_STRIP_W_R2_0/CTRL_OUT[5] A44_CDAC_CAP_BANK_ASSEMBLY_R8_M6_0/A44_CAP_CORE128_M6_R1_0/CAP_BOTTOM_104 VDD pfet_03v3 ad=0 pd=0 as=0 ps=0 w=1.56u l=0.28u
X3870 VREFP A44_DCTRL_STRIP_W_R2_0/CTRL_OUT[5] A44_CDAC_CAP_BANK_ASSEMBLY_R8_M6_0/A44_CAP_CORE128_M6_R1_0/CAP_BOTTOM_104 VDD pfet_03v3 ad=0 pd=0 as=0 ps=0 w=1.56u l=0.28u
X3871 VREFP A44_DCTRL_STRIP_W_R2_0/CTRL_OUT[5] A44_CDAC_CAP_BANK_ASSEMBLY_R8_M6_0/A44_CAP_CORE128_M6_R1_0/CAP_BOTTOM_104 VDD pfet_03v3 ad=0 pd=0 as=0 ps=0 w=1.56u l=0.28u
X3872 VREFN A44_DCTRL_STRIP_W_R2_0/CTRL_OUT[5] A44_CDAC_CAP_BANK_ASSEMBLY_R8_M6_0/A44_CAP_CORE128_M6_R1_0/CAP_BOTTOM_104 GND nfet_03v3 ad=0 pd=0 as=16.6842p ps=77.76u w=1.56u l=0.28u
X3873 VREFN A44_DCTRL_STRIP_W_R2_0/CTRL_OUT[5] A44_CDAC_CAP_BANK_ASSEMBLY_R8_M6_0/A44_CAP_CORE128_M6_R1_0/CAP_BOTTOM_104 GND nfet_03v3 ad=0 pd=0 as=0 ps=0 w=1.56u l=0.28u
X3874 VREFN A44_DCTRL_STRIP_W_R2_0/CTRL_OUT[5] A44_CDAC_CAP_BANK_ASSEMBLY_R8_M6_0/A44_CAP_CORE128_M6_R1_0/CAP_BOTTOM_104 GND nfet_03v3 ad=0 pd=0 as=0 ps=0 w=1.56u l=0.28u
X3875 VREFN A44_DCTRL_STRIP_W_R2_0/CTRL_OUT[5] A44_CDAC_CAP_BANK_ASSEMBLY_R8_M6_0/A44_CAP_CORE128_M6_R1_0/CAP_BOTTOM_104 GND nfet_03v3 ad=0 pd=0 as=0 ps=0 w=1.56u l=0.28u
X3876 VREFN A44_DCTRL_STRIP_W_R2_0/CTRL_OUT[5] A44_CDAC_CAP_BANK_ASSEMBLY_R8_M6_0/A44_CAP_CORE128_M6_R1_0/CAP_BOTTOM_104 GND nfet_03v3 ad=0 pd=0 as=0 ps=0 w=1.56u l=0.28u
X3877 VREFN A44_DCTRL_STRIP_W_R2_0/CTRL_OUT[5] A44_CDAC_CAP_BANK_ASSEMBLY_R8_M6_0/A44_CAP_CORE128_M6_R1_0/CAP_BOTTOM_104 GND nfet_03v3 ad=0 pd=0 as=0 ps=0 w=1.56u l=0.28u
X3878 VREFN A44_DCTRL_STRIP_W_R2_0/CTRL_OUT[5] A44_CDAC_CAP_BANK_ASSEMBLY_R8_M6_0/A44_CAP_CORE128_M6_R1_0/CAP_BOTTOM_104 GND nfet_03v3 ad=0 pd=0 as=0 ps=0 w=1.56u l=0.28u
X3879 VREFN A44_DCTRL_STRIP_W_R2_0/CTRL_OUT[5] A44_CDAC_CAP_BANK_ASSEMBLY_R8_M6_0/A44_CAP_CORE128_M6_R1_0/CAP_BOTTOM_104 GND nfet_03v3 ad=0 pd=0 as=0 ps=0 w=1.56u l=0.28u
X3880 VREFN A44_DCTRL_STRIP_W_R2_0/CTRL_OUT[5] A44_CDAC_CAP_BANK_ASSEMBLY_R8_M6_0/A44_CAP_CORE128_M6_R1_0/CAP_BOTTOM_104 GND nfet_03v3 ad=0 pd=0 as=0 ps=0 w=1.56u l=0.28u
X3881 VREFN A44_DCTRL_STRIP_W_R2_0/CTRL_OUT[5] A44_CDAC_CAP_BANK_ASSEMBLY_R8_M6_0/A44_CAP_CORE128_M6_R1_0/CAP_BOTTOM_104 GND nfet_03v3 ad=0 pd=0 as=0 ps=0 w=1.56u l=0.28u
X3882 VREFN A44_DCTRL_STRIP_W_R2_0/CTRL_OUT[5] A44_CDAC_CAP_BANK_ASSEMBLY_R8_M6_0/A44_CAP_CORE128_M6_R1_0/CAP_BOTTOM_104 GND nfet_03v3 ad=0 pd=0 as=0 ps=0 w=1.56u l=0.28u
X3883 VREFN A44_DCTRL_STRIP_W_R2_0/CTRL_OUT[5] A44_CDAC_CAP_BANK_ASSEMBLY_R8_M6_0/A44_CAP_CORE128_M6_R1_0/CAP_BOTTOM_104 GND nfet_03v3 ad=0 pd=0 as=0 ps=0 w=1.56u l=0.28u
X3884 VREFN A44_DCTRL_STRIP_W_R2_0/CTRL_OUT[5] A44_CDAC_CAP_BANK_ASSEMBLY_R8_M6_0/A44_CAP_CORE128_M6_R1_0/CAP_BOTTOM_104 GND nfet_03v3 ad=0 pd=0 as=0 ps=0 w=1.56u l=0.28u
X3885 VREFN A44_DCTRL_STRIP_W_R2_0/CTRL_OUT[5] A44_CDAC_CAP_BANK_ASSEMBLY_R8_M6_0/A44_CAP_CORE128_M6_R1_0/CAP_BOTTOM_104 GND nfet_03v3 ad=0 pd=0 as=0 ps=0 w=1.56u l=0.28u
X3886 VREFN A44_DCTRL_STRIP_W_R2_0/CTRL_OUT[5] A44_CDAC_CAP_BANK_ASSEMBLY_R8_M6_0/A44_CAP_CORE128_M6_R1_0/CAP_BOTTOM_104 GND nfet_03v3 ad=0 pd=0 as=0 ps=0 w=1.56u l=0.28u
X3887 VREFN A44_DCTRL_STRIP_W_R2_0/CTRL_OUT[5] A44_CDAC_CAP_BANK_ASSEMBLY_R8_M6_0/A44_CAP_CORE128_M6_R1_0/CAP_BOTTOM_104 GND nfet_03v3 ad=0 pd=0 as=0 ps=0 w=1.56u l=0.28u
X3888 VREFN A44_DCTRL_STRIP_W_R2_0/CTRL_OUT[5] A44_CDAC_CAP_BANK_ASSEMBLY_R8_M6_0/A44_CAP_CORE128_M6_R1_0/CAP_BOTTOM_104 GND nfet_03v3 ad=0 pd=0 as=0 ps=0 w=1.56u l=0.28u
X3889 VREFN A44_DCTRL_STRIP_W_R2_0/CTRL_OUT[5] A44_CDAC_CAP_BANK_ASSEMBLY_R8_M6_0/A44_CAP_CORE128_M6_R1_0/CAP_BOTTOM_104 GND nfet_03v3 ad=0 pd=0 as=0 ps=0 w=1.56u l=0.28u
X3890 VREFP A44_DCTRL_STRIP_W_R2_0/CTRL_OUT[7] A44_CDAC_CAP_BANK_ASSEMBLY_R8_M6_0/A44_CAP_CORE128_M6_R1_0/CAP_BOTTOM_101 VDD pfet_03v3 ad=0 pd=0 as=16.6842p ps=77.76u w=1.56u l=0.28u
X3891 VREFP A44_DCTRL_STRIP_W_R2_0/CTRL_OUT[7] A44_CDAC_CAP_BANK_ASSEMBLY_R8_M6_0/A44_CAP_CORE128_M6_R1_0/CAP_BOTTOM_101 VDD pfet_03v3 ad=0 pd=0 as=0 ps=0 w=1.56u l=0.28u
X3892 VREFP A44_DCTRL_STRIP_W_R2_0/CTRL_OUT[7] A44_CDAC_CAP_BANK_ASSEMBLY_R8_M6_0/A44_CAP_CORE128_M6_R1_0/CAP_BOTTOM_101 VDD pfet_03v3 ad=0 pd=0 as=0 ps=0 w=1.56u l=0.28u
X3893 VREFP A44_DCTRL_STRIP_W_R2_0/CTRL_OUT[7] A44_CDAC_CAP_BANK_ASSEMBLY_R8_M6_0/A44_CAP_CORE128_M6_R1_0/CAP_BOTTOM_101 VDD pfet_03v3 ad=0 pd=0 as=0 ps=0 w=1.56u l=0.28u
X3894 VREFP A44_DCTRL_STRIP_W_R2_0/CTRL_OUT[7] A44_CDAC_CAP_BANK_ASSEMBLY_R8_M6_0/A44_CAP_CORE128_M6_R1_0/CAP_BOTTOM_101 VDD pfet_03v3 ad=0 pd=0 as=0 ps=0 w=1.56u l=0.28u
X3895 VREFP A44_DCTRL_STRIP_W_R2_0/CTRL_OUT[7] A44_CDAC_CAP_BANK_ASSEMBLY_R8_M6_0/A44_CAP_CORE128_M6_R1_0/CAP_BOTTOM_101 VDD pfet_03v3 ad=0 pd=0 as=0 ps=0 w=1.56u l=0.28u
X3896 VREFP A44_DCTRL_STRIP_W_R2_0/CTRL_OUT[7] A44_CDAC_CAP_BANK_ASSEMBLY_R8_M6_0/A44_CAP_CORE128_M6_R1_0/CAP_BOTTOM_101 VDD pfet_03v3 ad=0 pd=0 as=0 ps=0 w=1.56u l=0.28u
X3897 VREFP A44_DCTRL_STRIP_W_R2_0/CTRL_OUT[7] A44_CDAC_CAP_BANK_ASSEMBLY_R8_M6_0/A44_CAP_CORE128_M6_R1_0/CAP_BOTTOM_101 VDD pfet_03v3 ad=0 pd=0 as=0 ps=0 w=1.56u l=0.28u
X3898 VREFP A44_DCTRL_STRIP_W_R2_0/CTRL_OUT[7] A44_CDAC_CAP_BANK_ASSEMBLY_R8_M6_0/A44_CAP_CORE128_M6_R1_0/CAP_BOTTOM_101 VDD pfet_03v3 ad=0 pd=0 as=0 ps=0 w=1.56u l=0.28u
X3899 VREFP A44_DCTRL_STRIP_W_R2_0/CTRL_OUT[7] A44_CDAC_CAP_BANK_ASSEMBLY_R8_M6_0/A44_CAP_CORE128_M6_R1_0/CAP_BOTTOM_101 VDD pfet_03v3 ad=0 pd=0 as=0 ps=0 w=1.56u l=0.28u
X3900 VREFP A44_DCTRL_STRIP_W_R2_0/CTRL_OUT[7] A44_CDAC_CAP_BANK_ASSEMBLY_R8_M6_0/A44_CAP_CORE128_M6_R1_0/CAP_BOTTOM_101 VDD pfet_03v3 ad=0 pd=0 as=0 ps=0 w=1.56u l=0.28u
X3901 VREFP A44_DCTRL_STRIP_W_R2_0/CTRL_OUT[7] A44_CDAC_CAP_BANK_ASSEMBLY_R8_M6_0/A44_CAP_CORE128_M6_R1_0/CAP_BOTTOM_101 VDD pfet_03v3 ad=0 pd=0 as=0 ps=0 w=1.56u l=0.28u
X3902 VREFP A44_DCTRL_STRIP_W_R2_0/CTRL_OUT[7] A44_CDAC_CAP_BANK_ASSEMBLY_R8_M6_0/A44_CAP_CORE128_M6_R1_0/CAP_BOTTOM_101 VDD pfet_03v3 ad=0 pd=0 as=0 ps=0 w=1.56u l=0.28u
X3903 VREFP A44_DCTRL_STRIP_W_R2_0/CTRL_OUT[7] A44_CDAC_CAP_BANK_ASSEMBLY_R8_M6_0/A44_CAP_CORE128_M6_R1_0/CAP_BOTTOM_101 VDD pfet_03v3 ad=0 pd=0 as=0 ps=0 w=1.56u l=0.28u
X3904 VREFP A44_DCTRL_STRIP_W_R2_0/CTRL_OUT[7] A44_CDAC_CAP_BANK_ASSEMBLY_R8_M6_0/A44_CAP_CORE128_M6_R1_0/CAP_BOTTOM_101 VDD pfet_03v3 ad=0 pd=0 as=0 ps=0 w=1.56u l=0.28u
X3905 VREFP A44_DCTRL_STRIP_W_R2_0/CTRL_OUT[7] A44_CDAC_CAP_BANK_ASSEMBLY_R8_M6_0/A44_CAP_CORE128_M6_R1_0/CAP_BOTTOM_101 VDD pfet_03v3 ad=0 pd=0 as=0 ps=0 w=1.56u l=0.28u
X3906 VREFP A44_DCTRL_STRIP_W_R2_0/CTRL_OUT[7] A44_CDAC_CAP_BANK_ASSEMBLY_R8_M6_0/A44_CAP_CORE128_M6_R1_0/CAP_BOTTOM_101 VDD pfet_03v3 ad=0 pd=0 as=0 ps=0 w=1.56u l=0.28u
X3907 VREFP A44_DCTRL_STRIP_W_R2_0/CTRL_OUT[7] A44_CDAC_CAP_BANK_ASSEMBLY_R8_M6_0/A44_CAP_CORE128_M6_R1_0/CAP_BOTTOM_101 VDD pfet_03v3 ad=0 pd=0 as=0 ps=0 w=1.56u l=0.28u
X3908 VREFN A44_DCTRL_STRIP_W_R2_0/CTRL_OUT[7] A44_CDAC_CAP_BANK_ASSEMBLY_R8_M6_0/A44_CAP_CORE128_M6_R1_0/CAP_BOTTOM_101 GND nfet_03v3 ad=0 pd=0 as=16.6842p ps=77.76u w=1.56u l=0.28u
X3909 VREFN A44_DCTRL_STRIP_W_R2_0/CTRL_OUT[7] A44_CDAC_CAP_BANK_ASSEMBLY_R8_M6_0/A44_CAP_CORE128_M6_R1_0/CAP_BOTTOM_101 GND nfet_03v3 ad=0 pd=0 as=0 ps=0 w=1.56u l=0.28u
X3910 VREFN A44_DCTRL_STRIP_W_R2_0/CTRL_OUT[7] A44_CDAC_CAP_BANK_ASSEMBLY_R8_M6_0/A44_CAP_CORE128_M6_R1_0/CAP_BOTTOM_101 GND nfet_03v3 ad=0 pd=0 as=0 ps=0 w=1.56u l=0.28u
X3911 VREFN A44_DCTRL_STRIP_W_R2_0/CTRL_OUT[7] A44_CDAC_CAP_BANK_ASSEMBLY_R8_M6_0/A44_CAP_CORE128_M6_R1_0/CAP_BOTTOM_101 GND nfet_03v3 ad=0 pd=0 as=0 ps=0 w=1.56u l=0.28u
X3912 VREFN A44_DCTRL_STRIP_W_R2_0/CTRL_OUT[7] A44_CDAC_CAP_BANK_ASSEMBLY_R8_M6_0/A44_CAP_CORE128_M6_R1_0/CAP_BOTTOM_101 GND nfet_03v3 ad=0 pd=0 as=0 ps=0 w=1.56u l=0.28u
X3913 VREFN A44_DCTRL_STRIP_W_R2_0/CTRL_OUT[7] A44_CDAC_CAP_BANK_ASSEMBLY_R8_M6_0/A44_CAP_CORE128_M6_R1_0/CAP_BOTTOM_101 GND nfet_03v3 ad=0 pd=0 as=0 ps=0 w=1.56u l=0.28u
X3914 VREFN A44_DCTRL_STRIP_W_R2_0/CTRL_OUT[7] A44_CDAC_CAP_BANK_ASSEMBLY_R8_M6_0/A44_CAP_CORE128_M6_R1_0/CAP_BOTTOM_101 GND nfet_03v3 ad=0 pd=0 as=0 ps=0 w=1.56u l=0.28u
X3915 VREFN A44_DCTRL_STRIP_W_R2_0/CTRL_OUT[7] A44_CDAC_CAP_BANK_ASSEMBLY_R8_M6_0/A44_CAP_CORE128_M6_R1_0/CAP_BOTTOM_101 GND nfet_03v3 ad=0 pd=0 as=0 ps=0 w=1.56u l=0.28u
X3916 VREFN A44_DCTRL_STRIP_W_R2_0/CTRL_OUT[7] A44_CDAC_CAP_BANK_ASSEMBLY_R8_M6_0/A44_CAP_CORE128_M6_R1_0/CAP_BOTTOM_101 GND nfet_03v3 ad=0 pd=0 as=0 ps=0 w=1.56u l=0.28u
X3917 VREFN A44_DCTRL_STRIP_W_R2_0/CTRL_OUT[7] A44_CDAC_CAP_BANK_ASSEMBLY_R8_M6_0/A44_CAP_CORE128_M6_R1_0/CAP_BOTTOM_101 GND nfet_03v3 ad=0 pd=0 as=0 ps=0 w=1.56u l=0.28u
X3918 VREFN A44_DCTRL_STRIP_W_R2_0/CTRL_OUT[7] A44_CDAC_CAP_BANK_ASSEMBLY_R8_M6_0/A44_CAP_CORE128_M6_R1_0/CAP_BOTTOM_101 GND nfet_03v3 ad=0 pd=0 as=0 ps=0 w=1.56u l=0.28u
X3919 VREFN A44_DCTRL_STRIP_W_R2_0/CTRL_OUT[7] A44_CDAC_CAP_BANK_ASSEMBLY_R8_M6_0/A44_CAP_CORE128_M6_R1_0/CAP_BOTTOM_101 GND nfet_03v3 ad=0 pd=0 as=0 ps=0 w=1.56u l=0.28u
X3920 VREFN A44_DCTRL_STRIP_W_R2_0/CTRL_OUT[7] A44_CDAC_CAP_BANK_ASSEMBLY_R8_M6_0/A44_CAP_CORE128_M6_R1_0/CAP_BOTTOM_101 GND nfet_03v3 ad=0 pd=0 as=0 ps=0 w=1.56u l=0.28u
X3921 VREFN A44_DCTRL_STRIP_W_R2_0/CTRL_OUT[7] A44_CDAC_CAP_BANK_ASSEMBLY_R8_M6_0/A44_CAP_CORE128_M6_R1_0/CAP_BOTTOM_101 GND nfet_03v3 ad=0 pd=0 as=0 ps=0 w=1.56u l=0.28u
X3922 VREFN A44_DCTRL_STRIP_W_R2_0/CTRL_OUT[7] A44_CDAC_CAP_BANK_ASSEMBLY_R8_M6_0/A44_CAP_CORE128_M6_R1_0/CAP_BOTTOM_101 GND nfet_03v3 ad=0 pd=0 as=0 ps=0 w=1.56u l=0.28u
X3923 VREFN A44_DCTRL_STRIP_W_R2_0/CTRL_OUT[7] A44_CDAC_CAP_BANK_ASSEMBLY_R8_M6_0/A44_CAP_CORE128_M6_R1_0/CAP_BOTTOM_101 GND nfet_03v3 ad=0 pd=0 as=0 ps=0 w=1.56u l=0.28u
X3924 VREFN A44_DCTRL_STRIP_W_R2_0/CTRL_OUT[7] A44_CDAC_CAP_BANK_ASSEMBLY_R8_M6_0/A44_CAP_CORE128_M6_R1_0/CAP_BOTTOM_101 GND nfet_03v3 ad=0 pd=0 as=0 ps=0 w=1.56u l=0.28u
X3925 VREFN A44_DCTRL_STRIP_W_R2_0/CTRL_OUT[7] A44_CDAC_CAP_BANK_ASSEMBLY_R8_M6_0/A44_CAP_CORE128_M6_R1_0/CAP_BOTTOM_101 GND nfet_03v3 ad=0 pd=0 as=0 ps=0 w=1.56u l=0.28u
X3926 VREFP A44_DCTRL_STRIP_W_R2_0/CTRL_OUT[5] A44_CDAC_CAP_BANK_ASSEMBLY_R8_M6_0/A44_CAP_CORE128_M6_R1_0/CAP_BOTTOM_068 VDD pfet_03v3 ad=0 pd=0 as=16.6842p ps=77.76u w=1.56u l=0.28u
X3927 VREFP A44_DCTRL_STRIP_W_R2_0/CTRL_OUT[5] A44_CDAC_CAP_BANK_ASSEMBLY_R8_M6_0/A44_CAP_CORE128_M6_R1_0/CAP_BOTTOM_068 VDD pfet_03v3 ad=0 pd=0 as=0 ps=0 w=1.56u l=0.28u
X3928 VREFP A44_DCTRL_STRIP_W_R2_0/CTRL_OUT[5] A44_CDAC_CAP_BANK_ASSEMBLY_R8_M6_0/A44_CAP_CORE128_M6_R1_0/CAP_BOTTOM_068 VDD pfet_03v3 ad=0 pd=0 as=0 ps=0 w=1.56u l=0.28u
X3929 VREFP A44_DCTRL_STRIP_W_R2_0/CTRL_OUT[5] A44_CDAC_CAP_BANK_ASSEMBLY_R8_M6_0/A44_CAP_CORE128_M6_R1_0/CAP_BOTTOM_068 VDD pfet_03v3 ad=0 pd=0 as=0 ps=0 w=1.56u l=0.28u
X3930 VREFP A44_DCTRL_STRIP_W_R2_0/CTRL_OUT[5] A44_CDAC_CAP_BANK_ASSEMBLY_R8_M6_0/A44_CAP_CORE128_M6_R1_0/CAP_BOTTOM_068 VDD pfet_03v3 ad=0 pd=0 as=0 ps=0 w=1.56u l=0.28u
X3931 VREFP A44_DCTRL_STRIP_W_R2_0/CTRL_OUT[5] A44_CDAC_CAP_BANK_ASSEMBLY_R8_M6_0/A44_CAP_CORE128_M6_R1_0/CAP_BOTTOM_068 VDD pfet_03v3 ad=0 pd=0 as=0 ps=0 w=1.56u l=0.28u
X3932 VREFP A44_DCTRL_STRIP_W_R2_0/CTRL_OUT[5] A44_CDAC_CAP_BANK_ASSEMBLY_R8_M6_0/A44_CAP_CORE128_M6_R1_0/CAP_BOTTOM_068 VDD pfet_03v3 ad=0 pd=0 as=0 ps=0 w=1.56u l=0.28u
X3933 VREFP A44_DCTRL_STRIP_W_R2_0/CTRL_OUT[5] A44_CDAC_CAP_BANK_ASSEMBLY_R8_M6_0/A44_CAP_CORE128_M6_R1_0/CAP_BOTTOM_068 VDD pfet_03v3 ad=0 pd=0 as=0 ps=0 w=1.56u l=0.28u
X3934 VREFP A44_DCTRL_STRIP_W_R2_0/CTRL_OUT[5] A44_CDAC_CAP_BANK_ASSEMBLY_R8_M6_0/A44_CAP_CORE128_M6_R1_0/CAP_BOTTOM_068 VDD pfet_03v3 ad=0 pd=0 as=0 ps=0 w=1.56u l=0.28u
X3935 VREFP A44_DCTRL_STRIP_W_R2_0/CTRL_OUT[5] A44_CDAC_CAP_BANK_ASSEMBLY_R8_M6_0/A44_CAP_CORE128_M6_R1_0/CAP_BOTTOM_068 VDD pfet_03v3 ad=0 pd=0 as=0 ps=0 w=1.56u l=0.28u
X3936 VREFP A44_DCTRL_STRIP_W_R2_0/CTRL_OUT[5] A44_CDAC_CAP_BANK_ASSEMBLY_R8_M6_0/A44_CAP_CORE128_M6_R1_0/CAP_BOTTOM_068 VDD pfet_03v3 ad=0 pd=0 as=0 ps=0 w=1.56u l=0.28u
X3937 VREFP A44_DCTRL_STRIP_W_R2_0/CTRL_OUT[5] A44_CDAC_CAP_BANK_ASSEMBLY_R8_M6_0/A44_CAP_CORE128_M6_R1_0/CAP_BOTTOM_068 VDD pfet_03v3 ad=0 pd=0 as=0 ps=0 w=1.56u l=0.28u
X3938 VREFP A44_DCTRL_STRIP_W_R2_0/CTRL_OUT[5] A44_CDAC_CAP_BANK_ASSEMBLY_R8_M6_0/A44_CAP_CORE128_M6_R1_0/CAP_BOTTOM_068 VDD pfet_03v3 ad=0 pd=0 as=0 ps=0 w=1.56u l=0.28u
X3939 VREFP A44_DCTRL_STRIP_W_R2_0/CTRL_OUT[5] A44_CDAC_CAP_BANK_ASSEMBLY_R8_M6_0/A44_CAP_CORE128_M6_R1_0/CAP_BOTTOM_068 VDD pfet_03v3 ad=0 pd=0 as=0 ps=0 w=1.56u l=0.28u
X3940 VREFP A44_DCTRL_STRIP_W_R2_0/CTRL_OUT[5] A44_CDAC_CAP_BANK_ASSEMBLY_R8_M6_0/A44_CAP_CORE128_M6_R1_0/CAP_BOTTOM_068 VDD pfet_03v3 ad=0 pd=0 as=0 ps=0 w=1.56u l=0.28u
X3941 VREFP A44_DCTRL_STRIP_W_R2_0/CTRL_OUT[5] A44_CDAC_CAP_BANK_ASSEMBLY_R8_M6_0/A44_CAP_CORE128_M6_R1_0/CAP_BOTTOM_068 VDD pfet_03v3 ad=0 pd=0 as=0 ps=0 w=1.56u l=0.28u
X3942 VREFP A44_DCTRL_STRIP_W_R2_0/CTRL_OUT[5] A44_CDAC_CAP_BANK_ASSEMBLY_R8_M6_0/A44_CAP_CORE128_M6_R1_0/CAP_BOTTOM_068 VDD pfet_03v3 ad=0 pd=0 as=0 ps=0 w=1.56u l=0.28u
X3943 VREFP A44_DCTRL_STRIP_W_R2_0/CTRL_OUT[5] A44_CDAC_CAP_BANK_ASSEMBLY_R8_M6_0/A44_CAP_CORE128_M6_R1_0/CAP_BOTTOM_068 VDD pfet_03v3 ad=0 pd=0 as=0 ps=0 w=1.56u l=0.28u
X3944 VREFN A44_DCTRL_STRIP_W_R2_0/CTRL_OUT[5] A44_CDAC_CAP_BANK_ASSEMBLY_R8_M6_0/A44_CAP_CORE128_M6_R1_0/CAP_BOTTOM_068 GND nfet_03v3 ad=0 pd=0 as=16.6842p ps=77.76u w=1.56u l=0.28u
X3945 VREFN A44_DCTRL_STRIP_W_R2_0/CTRL_OUT[5] A44_CDAC_CAP_BANK_ASSEMBLY_R8_M6_0/A44_CAP_CORE128_M6_R1_0/CAP_BOTTOM_068 GND nfet_03v3 ad=0 pd=0 as=0 ps=0 w=1.56u l=0.28u
X3946 VREFN A44_DCTRL_STRIP_W_R2_0/CTRL_OUT[5] A44_CDAC_CAP_BANK_ASSEMBLY_R8_M6_0/A44_CAP_CORE128_M6_R1_0/CAP_BOTTOM_068 GND nfet_03v3 ad=0 pd=0 as=0 ps=0 w=1.56u l=0.28u
X3947 VREFN A44_DCTRL_STRIP_W_R2_0/CTRL_OUT[5] A44_CDAC_CAP_BANK_ASSEMBLY_R8_M6_0/A44_CAP_CORE128_M6_R1_0/CAP_BOTTOM_068 GND nfet_03v3 ad=0 pd=0 as=0 ps=0 w=1.56u l=0.28u
X3948 VREFN A44_DCTRL_STRIP_W_R2_0/CTRL_OUT[5] A44_CDAC_CAP_BANK_ASSEMBLY_R8_M6_0/A44_CAP_CORE128_M6_R1_0/CAP_BOTTOM_068 GND nfet_03v3 ad=0 pd=0 as=0 ps=0 w=1.56u l=0.28u
X3949 VREFN A44_DCTRL_STRIP_W_R2_0/CTRL_OUT[5] A44_CDAC_CAP_BANK_ASSEMBLY_R8_M6_0/A44_CAP_CORE128_M6_R1_0/CAP_BOTTOM_068 GND nfet_03v3 ad=0 pd=0 as=0 ps=0 w=1.56u l=0.28u
X3950 VREFN A44_DCTRL_STRIP_W_R2_0/CTRL_OUT[5] A44_CDAC_CAP_BANK_ASSEMBLY_R8_M6_0/A44_CAP_CORE128_M6_R1_0/CAP_BOTTOM_068 GND nfet_03v3 ad=0 pd=0 as=0 ps=0 w=1.56u l=0.28u
X3951 VREFN A44_DCTRL_STRIP_W_R2_0/CTRL_OUT[5] A44_CDAC_CAP_BANK_ASSEMBLY_R8_M6_0/A44_CAP_CORE128_M6_R1_0/CAP_BOTTOM_068 GND nfet_03v3 ad=0 pd=0 as=0 ps=0 w=1.56u l=0.28u
X3952 VREFN A44_DCTRL_STRIP_W_R2_0/CTRL_OUT[5] A44_CDAC_CAP_BANK_ASSEMBLY_R8_M6_0/A44_CAP_CORE128_M6_R1_0/CAP_BOTTOM_068 GND nfet_03v3 ad=0 pd=0 as=0 ps=0 w=1.56u l=0.28u
X3953 VREFN A44_DCTRL_STRIP_W_R2_0/CTRL_OUT[5] A44_CDAC_CAP_BANK_ASSEMBLY_R8_M6_0/A44_CAP_CORE128_M6_R1_0/CAP_BOTTOM_068 GND nfet_03v3 ad=0 pd=0 as=0 ps=0 w=1.56u l=0.28u
X3954 VREFN A44_DCTRL_STRIP_W_R2_0/CTRL_OUT[5] A44_CDAC_CAP_BANK_ASSEMBLY_R8_M6_0/A44_CAP_CORE128_M6_R1_0/CAP_BOTTOM_068 GND nfet_03v3 ad=0 pd=0 as=0 ps=0 w=1.56u l=0.28u
X3955 VREFN A44_DCTRL_STRIP_W_R2_0/CTRL_OUT[5] A44_CDAC_CAP_BANK_ASSEMBLY_R8_M6_0/A44_CAP_CORE128_M6_R1_0/CAP_BOTTOM_068 GND nfet_03v3 ad=0 pd=0 as=0 ps=0 w=1.56u l=0.28u
X3956 VREFN A44_DCTRL_STRIP_W_R2_0/CTRL_OUT[5] A44_CDAC_CAP_BANK_ASSEMBLY_R8_M6_0/A44_CAP_CORE128_M6_R1_0/CAP_BOTTOM_068 GND nfet_03v3 ad=0 pd=0 as=0 ps=0 w=1.56u l=0.28u
X3957 VREFN A44_DCTRL_STRIP_W_R2_0/CTRL_OUT[5] A44_CDAC_CAP_BANK_ASSEMBLY_R8_M6_0/A44_CAP_CORE128_M6_R1_0/CAP_BOTTOM_068 GND nfet_03v3 ad=0 pd=0 as=0 ps=0 w=1.56u l=0.28u
X3958 VREFN A44_DCTRL_STRIP_W_R2_0/CTRL_OUT[5] A44_CDAC_CAP_BANK_ASSEMBLY_R8_M6_0/A44_CAP_CORE128_M6_R1_0/CAP_BOTTOM_068 GND nfet_03v3 ad=0 pd=0 as=0 ps=0 w=1.56u l=0.28u
X3959 VREFN A44_DCTRL_STRIP_W_R2_0/CTRL_OUT[5] A44_CDAC_CAP_BANK_ASSEMBLY_R8_M6_0/A44_CAP_CORE128_M6_R1_0/CAP_BOTTOM_068 GND nfet_03v3 ad=0 pd=0 as=0 ps=0 w=1.56u l=0.28u
X3960 VREFN A44_DCTRL_STRIP_W_R2_0/CTRL_OUT[5] A44_CDAC_CAP_BANK_ASSEMBLY_R8_M6_0/A44_CAP_CORE128_M6_R1_0/CAP_BOTTOM_068 GND nfet_03v3 ad=0 pd=0 as=0 ps=0 w=1.56u l=0.28u
X3961 VREFN A44_DCTRL_STRIP_W_R2_0/CTRL_OUT[5] A44_CDAC_CAP_BANK_ASSEMBLY_R8_M6_0/A44_CAP_CORE128_M6_R1_0/CAP_BOTTOM_068 GND nfet_03v3 ad=0 pd=0 as=0 ps=0 w=1.56u l=0.28u
X3962 VREFP A44_DCTRL_STRIP_W_R2_0/CTRL_OUT[7] A44_CDAC_CAP_BANK_ASSEMBLY_R8_M6_0/A44_CAP_CORE128_M6_R1_0/CAP_BOTTOM_065 VDD pfet_03v3 ad=0 pd=0 as=16.6842p ps=77.76u w=1.56u l=0.28u
X3963 VREFP A44_DCTRL_STRIP_W_R2_0/CTRL_OUT[7] A44_CDAC_CAP_BANK_ASSEMBLY_R8_M6_0/A44_CAP_CORE128_M6_R1_0/CAP_BOTTOM_065 VDD pfet_03v3 ad=0 pd=0 as=0 ps=0 w=1.56u l=0.28u
X3964 VREFP A44_DCTRL_STRIP_W_R2_0/CTRL_OUT[7] A44_CDAC_CAP_BANK_ASSEMBLY_R8_M6_0/A44_CAP_CORE128_M6_R1_0/CAP_BOTTOM_065 VDD pfet_03v3 ad=0 pd=0 as=0 ps=0 w=1.56u l=0.28u
X3965 VREFP A44_DCTRL_STRIP_W_R2_0/CTRL_OUT[7] A44_CDAC_CAP_BANK_ASSEMBLY_R8_M6_0/A44_CAP_CORE128_M6_R1_0/CAP_BOTTOM_065 VDD pfet_03v3 ad=0 pd=0 as=0 ps=0 w=1.56u l=0.28u
X3966 VREFP A44_DCTRL_STRIP_W_R2_0/CTRL_OUT[7] A44_CDAC_CAP_BANK_ASSEMBLY_R8_M6_0/A44_CAP_CORE128_M6_R1_0/CAP_BOTTOM_065 VDD pfet_03v3 ad=0 pd=0 as=0 ps=0 w=1.56u l=0.28u
X3967 VREFP A44_DCTRL_STRIP_W_R2_0/CTRL_OUT[7] A44_CDAC_CAP_BANK_ASSEMBLY_R8_M6_0/A44_CAP_CORE128_M6_R1_0/CAP_BOTTOM_065 VDD pfet_03v3 ad=0 pd=0 as=0 ps=0 w=1.56u l=0.28u
X3968 VREFP A44_DCTRL_STRIP_W_R2_0/CTRL_OUT[7] A44_CDAC_CAP_BANK_ASSEMBLY_R8_M6_0/A44_CAP_CORE128_M6_R1_0/CAP_BOTTOM_065 VDD pfet_03v3 ad=0 pd=0 as=0 ps=0 w=1.56u l=0.28u
X3969 VREFP A44_DCTRL_STRIP_W_R2_0/CTRL_OUT[7] A44_CDAC_CAP_BANK_ASSEMBLY_R8_M6_0/A44_CAP_CORE128_M6_R1_0/CAP_BOTTOM_065 VDD pfet_03v3 ad=0 pd=0 as=0 ps=0 w=1.56u l=0.28u
X3970 VREFP A44_DCTRL_STRIP_W_R2_0/CTRL_OUT[7] A44_CDAC_CAP_BANK_ASSEMBLY_R8_M6_0/A44_CAP_CORE128_M6_R1_0/CAP_BOTTOM_065 VDD pfet_03v3 ad=0 pd=0 as=0 ps=0 w=1.56u l=0.28u
X3971 VREFP A44_DCTRL_STRIP_W_R2_0/CTRL_OUT[7] A44_CDAC_CAP_BANK_ASSEMBLY_R8_M6_0/A44_CAP_CORE128_M6_R1_0/CAP_BOTTOM_065 VDD pfet_03v3 ad=0 pd=0 as=0 ps=0 w=1.56u l=0.28u
X3972 VREFP A44_DCTRL_STRIP_W_R2_0/CTRL_OUT[7] A44_CDAC_CAP_BANK_ASSEMBLY_R8_M6_0/A44_CAP_CORE128_M6_R1_0/CAP_BOTTOM_065 VDD pfet_03v3 ad=0 pd=0 as=0 ps=0 w=1.56u l=0.28u
X3973 VREFP A44_DCTRL_STRIP_W_R2_0/CTRL_OUT[7] A44_CDAC_CAP_BANK_ASSEMBLY_R8_M6_0/A44_CAP_CORE128_M6_R1_0/CAP_BOTTOM_065 VDD pfet_03v3 ad=0 pd=0 as=0 ps=0 w=1.56u l=0.28u
X3974 VREFP A44_DCTRL_STRIP_W_R2_0/CTRL_OUT[7] A44_CDAC_CAP_BANK_ASSEMBLY_R8_M6_0/A44_CAP_CORE128_M6_R1_0/CAP_BOTTOM_065 VDD pfet_03v3 ad=0 pd=0 as=0 ps=0 w=1.56u l=0.28u
X3975 VREFP A44_DCTRL_STRIP_W_R2_0/CTRL_OUT[7] A44_CDAC_CAP_BANK_ASSEMBLY_R8_M6_0/A44_CAP_CORE128_M6_R1_0/CAP_BOTTOM_065 VDD pfet_03v3 ad=0 pd=0 as=0 ps=0 w=1.56u l=0.28u
X3976 VREFP A44_DCTRL_STRIP_W_R2_0/CTRL_OUT[7] A44_CDAC_CAP_BANK_ASSEMBLY_R8_M6_0/A44_CAP_CORE128_M6_R1_0/CAP_BOTTOM_065 VDD pfet_03v3 ad=0 pd=0 as=0 ps=0 w=1.56u l=0.28u
X3977 VREFP A44_DCTRL_STRIP_W_R2_0/CTRL_OUT[7] A44_CDAC_CAP_BANK_ASSEMBLY_R8_M6_0/A44_CAP_CORE128_M6_R1_0/CAP_BOTTOM_065 VDD pfet_03v3 ad=0 pd=0 as=0 ps=0 w=1.56u l=0.28u
X3978 VREFP A44_DCTRL_STRIP_W_R2_0/CTRL_OUT[7] A44_CDAC_CAP_BANK_ASSEMBLY_R8_M6_0/A44_CAP_CORE128_M6_R1_0/CAP_BOTTOM_065 VDD pfet_03v3 ad=0 pd=0 as=0 ps=0 w=1.56u l=0.28u
X3979 VREFP A44_DCTRL_STRIP_W_R2_0/CTRL_OUT[7] A44_CDAC_CAP_BANK_ASSEMBLY_R8_M6_0/A44_CAP_CORE128_M6_R1_0/CAP_BOTTOM_065 VDD pfet_03v3 ad=0 pd=0 as=0 ps=0 w=1.56u l=0.28u
X3980 VREFN A44_DCTRL_STRIP_W_R2_0/CTRL_OUT[7] A44_CDAC_CAP_BANK_ASSEMBLY_R8_M6_0/A44_CAP_CORE128_M6_R1_0/CAP_BOTTOM_065 GND nfet_03v3 ad=0 pd=0 as=16.6842p ps=77.76u w=1.56u l=0.28u
X3981 VREFN A44_DCTRL_STRIP_W_R2_0/CTRL_OUT[7] A44_CDAC_CAP_BANK_ASSEMBLY_R8_M6_0/A44_CAP_CORE128_M6_R1_0/CAP_BOTTOM_065 GND nfet_03v3 ad=0 pd=0 as=0 ps=0 w=1.56u l=0.28u
X3982 VREFN A44_DCTRL_STRIP_W_R2_0/CTRL_OUT[7] A44_CDAC_CAP_BANK_ASSEMBLY_R8_M6_0/A44_CAP_CORE128_M6_R1_0/CAP_BOTTOM_065 GND nfet_03v3 ad=0 pd=0 as=0 ps=0 w=1.56u l=0.28u
X3983 VREFN A44_DCTRL_STRIP_W_R2_0/CTRL_OUT[7] A44_CDAC_CAP_BANK_ASSEMBLY_R8_M6_0/A44_CAP_CORE128_M6_R1_0/CAP_BOTTOM_065 GND nfet_03v3 ad=0 pd=0 as=0 ps=0 w=1.56u l=0.28u
X3984 VREFN A44_DCTRL_STRIP_W_R2_0/CTRL_OUT[7] A44_CDAC_CAP_BANK_ASSEMBLY_R8_M6_0/A44_CAP_CORE128_M6_R1_0/CAP_BOTTOM_065 GND nfet_03v3 ad=0 pd=0 as=0 ps=0 w=1.56u l=0.28u
X3985 VREFN A44_DCTRL_STRIP_W_R2_0/CTRL_OUT[7] A44_CDAC_CAP_BANK_ASSEMBLY_R8_M6_0/A44_CAP_CORE128_M6_R1_0/CAP_BOTTOM_065 GND nfet_03v3 ad=0 pd=0 as=0 ps=0 w=1.56u l=0.28u
X3986 VREFN A44_DCTRL_STRIP_W_R2_0/CTRL_OUT[7] A44_CDAC_CAP_BANK_ASSEMBLY_R8_M6_0/A44_CAP_CORE128_M6_R1_0/CAP_BOTTOM_065 GND nfet_03v3 ad=0 pd=0 as=0 ps=0 w=1.56u l=0.28u
X3987 VREFN A44_DCTRL_STRIP_W_R2_0/CTRL_OUT[7] A44_CDAC_CAP_BANK_ASSEMBLY_R8_M6_0/A44_CAP_CORE128_M6_R1_0/CAP_BOTTOM_065 GND nfet_03v3 ad=0 pd=0 as=0 ps=0 w=1.56u l=0.28u
X3988 VREFN A44_DCTRL_STRIP_W_R2_0/CTRL_OUT[7] A44_CDAC_CAP_BANK_ASSEMBLY_R8_M6_0/A44_CAP_CORE128_M6_R1_0/CAP_BOTTOM_065 GND nfet_03v3 ad=0 pd=0 as=0 ps=0 w=1.56u l=0.28u
X3989 VREFN A44_DCTRL_STRIP_W_R2_0/CTRL_OUT[7] A44_CDAC_CAP_BANK_ASSEMBLY_R8_M6_0/A44_CAP_CORE128_M6_R1_0/CAP_BOTTOM_065 GND nfet_03v3 ad=0 pd=0 as=0 ps=0 w=1.56u l=0.28u
X3990 VREFN A44_DCTRL_STRIP_W_R2_0/CTRL_OUT[7] A44_CDAC_CAP_BANK_ASSEMBLY_R8_M6_0/A44_CAP_CORE128_M6_R1_0/CAP_BOTTOM_065 GND nfet_03v3 ad=0 pd=0 as=0 ps=0 w=1.56u l=0.28u
X3991 VREFN A44_DCTRL_STRIP_W_R2_0/CTRL_OUT[7] A44_CDAC_CAP_BANK_ASSEMBLY_R8_M6_0/A44_CAP_CORE128_M6_R1_0/CAP_BOTTOM_065 GND nfet_03v3 ad=0 pd=0 as=0 ps=0 w=1.56u l=0.28u
X3992 VREFN A44_DCTRL_STRIP_W_R2_0/CTRL_OUT[7] A44_CDAC_CAP_BANK_ASSEMBLY_R8_M6_0/A44_CAP_CORE128_M6_R1_0/CAP_BOTTOM_065 GND nfet_03v3 ad=0 pd=0 as=0 ps=0 w=1.56u l=0.28u
X3993 VREFN A44_DCTRL_STRIP_W_R2_0/CTRL_OUT[7] A44_CDAC_CAP_BANK_ASSEMBLY_R8_M6_0/A44_CAP_CORE128_M6_R1_0/CAP_BOTTOM_065 GND nfet_03v3 ad=0 pd=0 as=0 ps=0 w=1.56u l=0.28u
X3994 VREFN A44_DCTRL_STRIP_W_R2_0/CTRL_OUT[7] A44_CDAC_CAP_BANK_ASSEMBLY_R8_M6_0/A44_CAP_CORE128_M6_R1_0/CAP_BOTTOM_065 GND nfet_03v3 ad=0 pd=0 as=0 ps=0 w=1.56u l=0.28u
X3995 VREFN A44_DCTRL_STRIP_W_R2_0/CTRL_OUT[7] A44_CDAC_CAP_BANK_ASSEMBLY_R8_M6_0/A44_CAP_CORE128_M6_R1_0/CAP_BOTTOM_065 GND nfet_03v3 ad=0 pd=0 as=0 ps=0 w=1.56u l=0.28u
X3996 VREFN A44_DCTRL_STRIP_W_R2_0/CTRL_OUT[7] A44_CDAC_CAP_BANK_ASSEMBLY_R8_M6_0/A44_CAP_CORE128_M6_R1_0/CAP_BOTTOM_065 GND nfet_03v3 ad=0 pd=0 as=0 ps=0 w=1.56u l=0.28u
X3997 VREFN A44_DCTRL_STRIP_W_R2_0/CTRL_OUT[7] A44_CDAC_CAP_BANK_ASSEMBLY_R8_M6_0/A44_CAP_CORE128_M6_R1_0/CAP_BOTTOM_065 GND nfet_03v3 ad=0 pd=0 as=0 ps=0 w=1.56u l=0.28u
X3998 VREFP A44_DCTRL_STRIP_W_R2_0/CTRL_OUT[6] A44_CDAC_CAP_BANK_ASSEMBLY_R8_M6_0/A44_CAP_CORE128_M6_R1_0/CAP_BOTTOM_088 VDD pfet_03v3 ad=0 pd=0 as=16.6842p ps=77.76u w=1.56u l=0.28u
X3999 VREFP A44_DCTRL_STRIP_W_R2_0/CTRL_OUT[6] A44_CDAC_CAP_BANK_ASSEMBLY_R8_M6_0/A44_CAP_CORE128_M6_R1_0/CAP_BOTTOM_088 VDD pfet_03v3 ad=0 pd=0 as=0 ps=0 w=1.56u l=0.28u
X4000 VREFP A44_DCTRL_STRIP_W_R2_0/CTRL_OUT[6] A44_CDAC_CAP_BANK_ASSEMBLY_R8_M6_0/A44_CAP_CORE128_M6_R1_0/CAP_BOTTOM_088 VDD pfet_03v3 ad=0 pd=0 as=0 ps=0 w=1.56u l=0.28u
X4001 VREFP A44_DCTRL_STRIP_W_R2_0/CTRL_OUT[6] A44_CDAC_CAP_BANK_ASSEMBLY_R8_M6_0/A44_CAP_CORE128_M6_R1_0/CAP_BOTTOM_088 VDD pfet_03v3 ad=0 pd=0 as=0 ps=0 w=1.56u l=0.28u
X4002 VREFP A44_DCTRL_STRIP_W_R2_0/CTRL_OUT[6] A44_CDAC_CAP_BANK_ASSEMBLY_R8_M6_0/A44_CAP_CORE128_M6_R1_0/CAP_BOTTOM_088 VDD pfet_03v3 ad=0 pd=0 as=0 ps=0 w=1.56u l=0.28u
X4003 VREFP A44_DCTRL_STRIP_W_R2_0/CTRL_OUT[6] A44_CDAC_CAP_BANK_ASSEMBLY_R8_M6_0/A44_CAP_CORE128_M6_R1_0/CAP_BOTTOM_088 VDD pfet_03v3 ad=0 pd=0 as=0 ps=0 w=1.56u l=0.28u
X4004 VREFP A44_DCTRL_STRIP_W_R2_0/CTRL_OUT[6] A44_CDAC_CAP_BANK_ASSEMBLY_R8_M6_0/A44_CAP_CORE128_M6_R1_0/CAP_BOTTOM_088 VDD pfet_03v3 ad=0 pd=0 as=0 ps=0 w=1.56u l=0.28u
X4005 VREFP A44_DCTRL_STRIP_W_R2_0/CTRL_OUT[6] A44_CDAC_CAP_BANK_ASSEMBLY_R8_M6_0/A44_CAP_CORE128_M6_R1_0/CAP_BOTTOM_088 VDD pfet_03v3 ad=0 pd=0 as=0 ps=0 w=1.56u l=0.28u
X4006 VREFP A44_DCTRL_STRIP_W_R2_0/CTRL_OUT[6] A44_CDAC_CAP_BANK_ASSEMBLY_R8_M6_0/A44_CAP_CORE128_M6_R1_0/CAP_BOTTOM_088 VDD pfet_03v3 ad=0 pd=0 as=0 ps=0 w=1.56u l=0.28u
X4007 VREFP A44_DCTRL_STRIP_W_R2_0/CTRL_OUT[6] A44_CDAC_CAP_BANK_ASSEMBLY_R8_M6_0/A44_CAP_CORE128_M6_R1_0/CAP_BOTTOM_088 VDD pfet_03v3 ad=0 pd=0 as=0 ps=0 w=1.56u l=0.28u
X4008 VREFP A44_DCTRL_STRIP_W_R2_0/CTRL_OUT[6] A44_CDAC_CAP_BANK_ASSEMBLY_R8_M6_0/A44_CAP_CORE128_M6_R1_0/CAP_BOTTOM_088 VDD pfet_03v3 ad=0 pd=0 as=0 ps=0 w=1.56u l=0.28u
X4009 VREFP A44_DCTRL_STRIP_W_R2_0/CTRL_OUT[6] A44_CDAC_CAP_BANK_ASSEMBLY_R8_M6_0/A44_CAP_CORE128_M6_R1_0/CAP_BOTTOM_088 VDD pfet_03v3 ad=0 pd=0 as=0 ps=0 w=1.56u l=0.28u
X4010 VREFP A44_DCTRL_STRIP_W_R2_0/CTRL_OUT[6] A44_CDAC_CAP_BANK_ASSEMBLY_R8_M6_0/A44_CAP_CORE128_M6_R1_0/CAP_BOTTOM_088 VDD pfet_03v3 ad=0 pd=0 as=0 ps=0 w=1.56u l=0.28u
X4011 VREFP A44_DCTRL_STRIP_W_R2_0/CTRL_OUT[6] A44_CDAC_CAP_BANK_ASSEMBLY_R8_M6_0/A44_CAP_CORE128_M6_R1_0/CAP_BOTTOM_088 VDD pfet_03v3 ad=0 pd=0 as=0 ps=0 w=1.56u l=0.28u
X4012 VREFP A44_DCTRL_STRIP_W_R2_0/CTRL_OUT[6] A44_CDAC_CAP_BANK_ASSEMBLY_R8_M6_0/A44_CAP_CORE128_M6_R1_0/CAP_BOTTOM_088 VDD pfet_03v3 ad=0 pd=0 as=0 ps=0 w=1.56u l=0.28u
X4013 VREFP A44_DCTRL_STRIP_W_R2_0/CTRL_OUT[6] A44_CDAC_CAP_BANK_ASSEMBLY_R8_M6_0/A44_CAP_CORE128_M6_R1_0/CAP_BOTTOM_088 VDD pfet_03v3 ad=0 pd=0 as=0 ps=0 w=1.56u l=0.28u
X4014 VREFP A44_DCTRL_STRIP_W_R2_0/CTRL_OUT[6] A44_CDAC_CAP_BANK_ASSEMBLY_R8_M6_0/A44_CAP_CORE128_M6_R1_0/CAP_BOTTOM_088 VDD pfet_03v3 ad=0 pd=0 as=0 ps=0 w=1.56u l=0.28u
X4015 VREFP A44_DCTRL_STRIP_W_R2_0/CTRL_OUT[6] A44_CDAC_CAP_BANK_ASSEMBLY_R8_M6_0/A44_CAP_CORE128_M6_R1_0/CAP_BOTTOM_088 VDD pfet_03v3 ad=0 pd=0 as=0 ps=0 w=1.56u l=0.28u
X4016 VREFN A44_DCTRL_STRIP_W_R2_0/CTRL_OUT[6] A44_CDAC_CAP_BANK_ASSEMBLY_R8_M6_0/A44_CAP_CORE128_M6_R1_0/CAP_BOTTOM_088 GND nfet_03v3 ad=0 pd=0 as=16.6842p ps=77.76u w=1.56u l=0.28u
X4017 VREFN A44_DCTRL_STRIP_W_R2_0/CTRL_OUT[6] A44_CDAC_CAP_BANK_ASSEMBLY_R8_M6_0/A44_CAP_CORE128_M6_R1_0/CAP_BOTTOM_088 GND nfet_03v3 ad=0 pd=0 as=0 ps=0 w=1.56u l=0.28u
X4018 VREFN A44_DCTRL_STRIP_W_R2_0/CTRL_OUT[6] A44_CDAC_CAP_BANK_ASSEMBLY_R8_M6_0/A44_CAP_CORE128_M6_R1_0/CAP_BOTTOM_088 GND nfet_03v3 ad=0 pd=0 as=0 ps=0 w=1.56u l=0.28u
X4019 VREFN A44_DCTRL_STRIP_W_R2_0/CTRL_OUT[6] A44_CDAC_CAP_BANK_ASSEMBLY_R8_M6_0/A44_CAP_CORE128_M6_R1_0/CAP_BOTTOM_088 GND nfet_03v3 ad=0 pd=0 as=0 ps=0 w=1.56u l=0.28u
X4020 VREFN A44_DCTRL_STRIP_W_R2_0/CTRL_OUT[6] A44_CDAC_CAP_BANK_ASSEMBLY_R8_M6_0/A44_CAP_CORE128_M6_R1_0/CAP_BOTTOM_088 GND nfet_03v3 ad=0 pd=0 as=0 ps=0 w=1.56u l=0.28u
X4021 VREFN A44_DCTRL_STRIP_W_R2_0/CTRL_OUT[6] A44_CDAC_CAP_BANK_ASSEMBLY_R8_M6_0/A44_CAP_CORE128_M6_R1_0/CAP_BOTTOM_088 GND nfet_03v3 ad=0 pd=0 as=0 ps=0 w=1.56u l=0.28u
X4022 VREFN A44_DCTRL_STRIP_W_R2_0/CTRL_OUT[6] A44_CDAC_CAP_BANK_ASSEMBLY_R8_M6_0/A44_CAP_CORE128_M6_R1_0/CAP_BOTTOM_088 GND nfet_03v3 ad=0 pd=0 as=0 ps=0 w=1.56u l=0.28u
X4023 VREFN A44_DCTRL_STRIP_W_R2_0/CTRL_OUT[6] A44_CDAC_CAP_BANK_ASSEMBLY_R8_M6_0/A44_CAP_CORE128_M6_R1_0/CAP_BOTTOM_088 GND nfet_03v3 ad=0 pd=0 as=0 ps=0 w=1.56u l=0.28u
X4024 VREFN A44_DCTRL_STRIP_W_R2_0/CTRL_OUT[6] A44_CDAC_CAP_BANK_ASSEMBLY_R8_M6_0/A44_CAP_CORE128_M6_R1_0/CAP_BOTTOM_088 GND nfet_03v3 ad=0 pd=0 as=0 ps=0 w=1.56u l=0.28u
X4025 VREFN A44_DCTRL_STRIP_W_R2_0/CTRL_OUT[6] A44_CDAC_CAP_BANK_ASSEMBLY_R8_M6_0/A44_CAP_CORE128_M6_R1_0/CAP_BOTTOM_088 GND nfet_03v3 ad=0 pd=0 as=0 ps=0 w=1.56u l=0.28u
X4026 VREFN A44_DCTRL_STRIP_W_R2_0/CTRL_OUT[6] A44_CDAC_CAP_BANK_ASSEMBLY_R8_M6_0/A44_CAP_CORE128_M6_R1_0/CAP_BOTTOM_088 GND nfet_03v3 ad=0 pd=0 as=0 ps=0 w=1.56u l=0.28u
X4027 VREFN A44_DCTRL_STRIP_W_R2_0/CTRL_OUT[6] A44_CDAC_CAP_BANK_ASSEMBLY_R8_M6_0/A44_CAP_CORE128_M6_R1_0/CAP_BOTTOM_088 GND nfet_03v3 ad=0 pd=0 as=0 ps=0 w=1.56u l=0.28u
X4028 VREFN A44_DCTRL_STRIP_W_R2_0/CTRL_OUT[6] A44_CDAC_CAP_BANK_ASSEMBLY_R8_M6_0/A44_CAP_CORE128_M6_R1_0/CAP_BOTTOM_088 GND nfet_03v3 ad=0 pd=0 as=0 ps=0 w=1.56u l=0.28u
X4029 VREFN A44_DCTRL_STRIP_W_R2_0/CTRL_OUT[6] A44_CDAC_CAP_BANK_ASSEMBLY_R8_M6_0/A44_CAP_CORE128_M6_R1_0/CAP_BOTTOM_088 GND nfet_03v3 ad=0 pd=0 as=0 ps=0 w=1.56u l=0.28u
X4030 VREFN A44_DCTRL_STRIP_W_R2_0/CTRL_OUT[6] A44_CDAC_CAP_BANK_ASSEMBLY_R8_M6_0/A44_CAP_CORE128_M6_R1_0/CAP_BOTTOM_088 GND nfet_03v3 ad=0 pd=0 as=0 ps=0 w=1.56u l=0.28u
X4031 VREFN A44_DCTRL_STRIP_W_R2_0/CTRL_OUT[6] A44_CDAC_CAP_BANK_ASSEMBLY_R8_M6_0/A44_CAP_CORE128_M6_R1_0/CAP_BOTTOM_088 GND nfet_03v3 ad=0 pd=0 as=0 ps=0 w=1.56u l=0.28u
X4032 VREFN A44_DCTRL_STRIP_W_R2_0/CTRL_OUT[6] A44_CDAC_CAP_BANK_ASSEMBLY_R8_M6_0/A44_CAP_CORE128_M6_R1_0/CAP_BOTTOM_088 GND nfet_03v3 ad=0 pd=0 as=0 ps=0 w=1.56u l=0.28u
X4033 VREFN A44_DCTRL_STRIP_W_R2_0/CTRL_OUT[6] A44_CDAC_CAP_BANK_ASSEMBLY_R8_M6_0/A44_CAP_CORE128_M6_R1_0/CAP_BOTTOM_088 GND nfet_03v3 ad=0 pd=0 as=0 ps=0 w=1.56u l=0.28u
X4034 VREFP A44_DCTRL_STRIP_W_R2_0/CTRL_OUT[7] A44_CDAC_CAP_BANK_ASSEMBLY_R8_M6_0/A44_CAP_CORE128_M6_R1_0/CAP_BOTTOM_085 VDD pfet_03v3 ad=0 pd=0 as=16.6842p ps=77.76u w=1.56u l=0.28u
X4035 VREFP A44_DCTRL_STRIP_W_R2_0/CTRL_OUT[7] A44_CDAC_CAP_BANK_ASSEMBLY_R8_M6_0/A44_CAP_CORE128_M6_R1_0/CAP_BOTTOM_085 VDD pfet_03v3 ad=0 pd=0 as=0 ps=0 w=1.56u l=0.28u
X4036 VREFP A44_DCTRL_STRIP_W_R2_0/CTRL_OUT[7] A44_CDAC_CAP_BANK_ASSEMBLY_R8_M6_0/A44_CAP_CORE128_M6_R1_0/CAP_BOTTOM_085 VDD pfet_03v3 ad=0 pd=0 as=0 ps=0 w=1.56u l=0.28u
X4037 VREFP A44_DCTRL_STRIP_W_R2_0/CTRL_OUT[7] A44_CDAC_CAP_BANK_ASSEMBLY_R8_M6_0/A44_CAP_CORE128_M6_R1_0/CAP_BOTTOM_085 VDD pfet_03v3 ad=0 pd=0 as=0 ps=0 w=1.56u l=0.28u
X4038 VREFP A44_DCTRL_STRIP_W_R2_0/CTRL_OUT[7] A44_CDAC_CAP_BANK_ASSEMBLY_R8_M6_0/A44_CAP_CORE128_M6_R1_0/CAP_BOTTOM_085 VDD pfet_03v3 ad=0 pd=0 as=0 ps=0 w=1.56u l=0.28u
X4039 VREFP A44_DCTRL_STRIP_W_R2_0/CTRL_OUT[7] A44_CDAC_CAP_BANK_ASSEMBLY_R8_M6_0/A44_CAP_CORE128_M6_R1_0/CAP_BOTTOM_085 VDD pfet_03v3 ad=0 pd=0 as=0 ps=0 w=1.56u l=0.28u
X4040 VREFP A44_DCTRL_STRIP_W_R2_0/CTRL_OUT[7] A44_CDAC_CAP_BANK_ASSEMBLY_R8_M6_0/A44_CAP_CORE128_M6_R1_0/CAP_BOTTOM_085 VDD pfet_03v3 ad=0 pd=0 as=0 ps=0 w=1.56u l=0.28u
X4041 VREFP A44_DCTRL_STRIP_W_R2_0/CTRL_OUT[7] A44_CDAC_CAP_BANK_ASSEMBLY_R8_M6_0/A44_CAP_CORE128_M6_R1_0/CAP_BOTTOM_085 VDD pfet_03v3 ad=0 pd=0 as=0 ps=0 w=1.56u l=0.28u
X4042 VREFP A44_DCTRL_STRIP_W_R2_0/CTRL_OUT[7] A44_CDAC_CAP_BANK_ASSEMBLY_R8_M6_0/A44_CAP_CORE128_M6_R1_0/CAP_BOTTOM_085 VDD pfet_03v3 ad=0 pd=0 as=0 ps=0 w=1.56u l=0.28u
X4043 VREFP A44_DCTRL_STRIP_W_R2_0/CTRL_OUT[7] A44_CDAC_CAP_BANK_ASSEMBLY_R8_M6_0/A44_CAP_CORE128_M6_R1_0/CAP_BOTTOM_085 VDD pfet_03v3 ad=0 pd=0 as=0 ps=0 w=1.56u l=0.28u
X4044 VREFP A44_DCTRL_STRIP_W_R2_0/CTRL_OUT[7] A44_CDAC_CAP_BANK_ASSEMBLY_R8_M6_0/A44_CAP_CORE128_M6_R1_0/CAP_BOTTOM_085 VDD pfet_03v3 ad=0 pd=0 as=0 ps=0 w=1.56u l=0.28u
X4045 VREFP A44_DCTRL_STRIP_W_R2_0/CTRL_OUT[7] A44_CDAC_CAP_BANK_ASSEMBLY_R8_M6_0/A44_CAP_CORE128_M6_R1_0/CAP_BOTTOM_085 VDD pfet_03v3 ad=0 pd=0 as=0 ps=0 w=1.56u l=0.28u
X4046 VREFP A44_DCTRL_STRIP_W_R2_0/CTRL_OUT[7] A44_CDAC_CAP_BANK_ASSEMBLY_R8_M6_0/A44_CAP_CORE128_M6_R1_0/CAP_BOTTOM_085 VDD pfet_03v3 ad=0 pd=0 as=0 ps=0 w=1.56u l=0.28u
X4047 VREFP A44_DCTRL_STRIP_W_R2_0/CTRL_OUT[7] A44_CDAC_CAP_BANK_ASSEMBLY_R8_M6_0/A44_CAP_CORE128_M6_R1_0/CAP_BOTTOM_085 VDD pfet_03v3 ad=0 pd=0 as=0 ps=0 w=1.56u l=0.28u
X4048 VREFP A44_DCTRL_STRIP_W_R2_0/CTRL_OUT[7] A44_CDAC_CAP_BANK_ASSEMBLY_R8_M6_0/A44_CAP_CORE128_M6_R1_0/CAP_BOTTOM_085 VDD pfet_03v3 ad=0 pd=0 as=0 ps=0 w=1.56u l=0.28u
X4049 VREFP A44_DCTRL_STRIP_W_R2_0/CTRL_OUT[7] A44_CDAC_CAP_BANK_ASSEMBLY_R8_M6_0/A44_CAP_CORE128_M6_R1_0/CAP_BOTTOM_085 VDD pfet_03v3 ad=0 pd=0 as=0 ps=0 w=1.56u l=0.28u
X4050 VREFP A44_DCTRL_STRIP_W_R2_0/CTRL_OUT[7] A44_CDAC_CAP_BANK_ASSEMBLY_R8_M6_0/A44_CAP_CORE128_M6_R1_0/CAP_BOTTOM_085 VDD pfet_03v3 ad=0 pd=0 as=0 ps=0 w=1.56u l=0.28u
X4051 VREFP A44_DCTRL_STRIP_W_R2_0/CTRL_OUT[7] A44_CDAC_CAP_BANK_ASSEMBLY_R8_M6_0/A44_CAP_CORE128_M6_R1_0/CAP_BOTTOM_085 VDD pfet_03v3 ad=0 pd=0 as=0 ps=0 w=1.56u l=0.28u
X4052 VREFN A44_DCTRL_STRIP_W_R2_0/CTRL_OUT[7] A44_CDAC_CAP_BANK_ASSEMBLY_R8_M6_0/A44_CAP_CORE128_M6_R1_0/CAP_BOTTOM_085 GND nfet_03v3 ad=0 pd=0 as=16.6842p ps=77.76u w=1.56u l=0.28u
X4053 VREFN A44_DCTRL_STRIP_W_R2_0/CTRL_OUT[7] A44_CDAC_CAP_BANK_ASSEMBLY_R8_M6_0/A44_CAP_CORE128_M6_R1_0/CAP_BOTTOM_085 GND nfet_03v3 ad=0 pd=0 as=0 ps=0 w=1.56u l=0.28u
X4054 VREFN A44_DCTRL_STRIP_W_R2_0/CTRL_OUT[7] A44_CDAC_CAP_BANK_ASSEMBLY_R8_M6_0/A44_CAP_CORE128_M6_R1_0/CAP_BOTTOM_085 GND nfet_03v3 ad=0 pd=0 as=0 ps=0 w=1.56u l=0.28u
X4055 VREFN A44_DCTRL_STRIP_W_R2_0/CTRL_OUT[7] A44_CDAC_CAP_BANK_ASSEMBLY_R8_M6_0/A44_CAP_CORE128_M6_R1_0/CAP_BOTTOM_085 GND nfet_03v3 ad=0 pd=0 as=0 ps=0 w=1.56u l=0.28u
X4056 VREFN A44_DCTRL_STRIP_W_R2_0/CTRL_OUT[7] A44_CDAC_CAP_BANK_ASSEMBLY_R8_M6_0/A44_CAP_CORE128_M6_R1_0/CAP_BOTTOM_085 GND nfet_03v3 ad=0 pd=0 as=0 ps=0 w=1.56u l=0.28u
X4057 VREFN A44_DCTRL_STRIP_W_R2_0/CTRL_OUT[7] A44_CDAC_CAP_BANK_ASSEMBLY_R8_M6_0/A44_CAP_CORE128_M6_R1_0/CAP_BOTTOM_085 GND nfet_03v3 ad=0 pd=0 as=0 ps=0 w=1.56u l=0.28u
X4058 VREFN A44_DCTRL_STRIP_W_R2_0/CTRL_OUT[7] A44_CDAC_CAP_BANK_ASSEMBLY_R8_M6_0/A44_CAP_CORE128_M6_R1_0/CAP_BOTTOM_085 GND nfet_03v3 ad=0 pd=0 as=0 ps=0 w=1.56u l=0.28u
X4059 VREFN A44_DCTRL_STRIP_W_R2_0/CTRL_OUT[7] A44_CDAC_CAP_BANK_ASSEMBLY_R8_M6_0/A44_CAP_CORE128_M6_R1_0/CAP_BOTTOM_085 GND nfet_03v3 ad=0 pd=0 as=0 ps=0 w=1.56u l=0.28u
X4060 VREFN A44_DCTRL_STRIP_W_R2_0/CTRL_OUT[7] A44_CDAC_CAP_BANK_ASSEMBLY_R8_M6_0/A44_CAP_CORE128_M6_R1_0/CAP_BOTTOM_085 GND nfet_03v3 ad=0 pd=0 as=0 ps=0 w=1.56u l=0.28u
X4061 VREFN A44_DCTRL_STRIP_W_R2_0/CTRL_OUT[7] A44_CDAC_CAP_BANK_ASSEMBLY_R8_M6_0/A44_CAP_CORE128_M6_R1_0/CAP_BOTTOM_085 GND nfet_03v3 ad=0 pd=0 as=0 ps=0 w=1.56u l=0.28u
X4062 VREFN A44_DCTRL_STRIP_W_R2_0/CTRL_OUT[7] A44_CDAC_CAP_BANK_ASSEMBLY_R8_M6_0/A44_CAP_CORE128_M6_R1_0/CAP_BOTTOM_085 GND nfet_03v3 ad=0 pd=0 as=0 ps=0 w=1.56u l=0.28u
X4063 VREFN A44_DCTRL_STRIP_W_R2_0/CTRL_OUT[7] A44_CDAC_CAP_BANK_ASSEMBLY_R8_M6_0/A44_CAP_CORE128_M6_R1_0/CAP_BOTTOM_085 GND nfet_03v3 ad=0 pd=0 as=0 ps=0 w=1.56u l=0.28u
X4064 VREFN A44_DCTRL_STRIP_W_R2_0/CTRL_OUT[7] A44_CDAC_CAP_BANK_ASSEMBLY_R8_M6_0/A44_CAP_CORE128_M6_R1_0/CAP_BOTTOM_085 GND nfet_03v3 ad=0 pd=0 as=0 ps=0 w=1.56u l=0.28u
X4065 VREFN A44_DCTRL_STRIP_W_R2_0/CTRL_OUT[7] A44_CDAC_CAP_BANK_ASSEMBLY_R8_M6_0/A44_CAP_CORE128_M6_R1_0/CAP_BOTTOM_085 GND nfet_03v3 ad=0 pd=0 as=0 ps=0 w=1.56u l=0.28u
X4066 VREFN A44_DCTRL_STRIP_W_R2_0/CTRL_OUT[7] A44_CDAC_CAP_BANK_ASSEMBLY_R8_M6_0/A44_CAP_CORE128_M6_R1_0/CAP_BOTTOM_085 GND nfet_03v3 ad=0 pd=0 as=0 ps=0 w=1.56u l=0.28u
X4067 VREFN A44_DCTRL_STRIP_W_R2_0/CTRL_OUT[7] A44_CDAC_CAP_BANK_ASSEMBLY_R8_M6_0/A44_CAP_CORE128_M6_R1_0/CAP_BOTTOM_085 GND nfet_03v3 ad=0 pd=0 as=0 ps=0 w=1.56u l=0.28u
X4068 VREFN A44_DCTRL_STRIP_W_R2_0/CTRL_OUT[7] A44_CDAC_CAP_BANK_ASSEMBLY_R8_M6_0/A44_CAP_CORE128_M6_R1_0/CAP_BOTTOM_085 GND nfet_03v3 ad=0 pd=0 as=0 ps=0 w=1.56u l=0.28u
X4069 VREFN A44_DCTRL_STRIP_W_R2_0/CTRL_OUT[7] A44_CDAC_CAP_BANK_ASSEMBLY_R8_M6_0/A44_CAP_CORE128_M6_R1_0/CAP_BOTTOM_085 GND nfet_03v3 ad=0 pd=0 as=0 ps=0 w=1.56u l=0.28u
X4070 VREFP A44_DCTRL_STRIP_W_R2_0/CTRL_OUT[6] A44_CDAC_CAP_BANK_ASSEMBLY_R8_M6_0/A44_CAP_CORE128_M6_R1_0/CAP_BOTTOM_111 VDD pfet_03v3 ad=0 pd=0 as=16.6842p ps=77.76u w=1.56u l=0.28u
X4071 VREFP A44_DCTRL_STRIP_W_R2_0/CTRL_OUT[6] A44_CDAC_CAP_BANK_ASSEMBLY_R8_M6_0/A44_CAP_CORE128_M6_R1_0/CAP_BOTTOM_111 VDD pfet_03v3 ad=0 pd=0 as=0 ps=0 w=1.56u l=0.28u
X4072 VREFP A44_DCTRL_STRIP_W_R2_0/CTRL_OUT[6] A44_CDAC_CAP_BANK_ASSEMBLY_R8_M6_0/A44_CAP_CORE128_M6_R1_0/CAP_BOTTOM_111 VDD pfet_03v3 ad=0 pd=0 as=0 ps=0 w=1.56u l=0.28u
X4073 VREFP A44_DCTRL_STRIP_W_R2_0/CTRL_OUT[6] A44_CDAC_CAP_BANK_ASSEMBLY_R8_M6_0/A44_CAP_CORE128_M6_R1_0/CAP_BOTTOM_111 VDD pfet_03v3 ad=0 pd=0 as=0 ps=0 w=1.56u l=0.28u
X4074 VREFP A44_DCTRL_STRIP_W_R2_0/CTRL_OUT[6] A44_CDAC_CAP_BANK_ASSEMBLY_R8_M6_0/A44_CAP_CORE128_M6_R1_0/CAP_BOTTOM_111 VDD pfet_03v3 ad=0 pd=0 as=0 ps=0 w=1.56u l=0.28u
X4075 VREFP A44_DCTRL_STRIP_W_R2_0/CTRL_OUT[6] A44_CDAC_CAP_BANK_ASSEMBLY_R8_M6_0/A44_CAP_CORE128_M6_R1_0/CAP_BOTTOM_111 VDD pfet_03v3 ad=0 pd=0 as=0 ps=0 w=1.56u l=0.28u
X4076 VREFP A44_DCTRL_STRIP_W_R2_0/CTRL_OUT[6] A44_CDAC_CAP_BANK_ASSEMBLY_R8_M6_0/A44_CAP_CORE128_M6_R1_0/CAP_BOTTOM_111 VDD pfet_03v3 ad=0 pd=0 as=0 ps=0 w=1.56u l=0.28u
X4077 VREFP A44_DCTRL_STRIP_W_R2_0/CTRL_OUT[6] A44_CDAC_CAP_BANK_ASSEMBLY_R8_M6_0/A44_CAP_CORE128_M6_R1_0/CAP_BOTTOM_111 VDD pfet_03v3 ad=0 pd=0 as=0 ps=0 w=1.56u l=0.28u
X4078 VREFP A44_DCTRL_STRIP_W_R2_0/CTRL_OUT[6] A44_CDAC_CAP_BANK_ASSEMBLY_R8_M6_0/A44_CAP_CORE128_M6_R1_0/CAP_BOTTOM_111 VDD pfet_03v3 ad=0 pd=0 as=0 ps=0 w=1.56u l=0.28u
X4079 VREFP A44_DCTRL_STRIP_W_R2_0/CTRL_OUT[6] A44_CDAC_CAP_BANK_ASSEMBLY_R8_M6_0/A44_CAP_CORE128_M6_R1_0/CAP_BOTTOM_111 VDD pfet_03v3 ad=0 pd=0 as=0 ps=0 w=1.56u l=0.28u
X4080 VREFP A44_DCTRL_STRIP_W_R2_0/CTRL_OUT[6] A44_CDAC_CAP_BANK_ASSEMBLY_R8_M6_0/A44_CAP_CORE128_M6_R1_0/CAP_BOTTOM_111 VDD pfet_03v3 ad=0 pd=0 as=0 ps=0 w=1.56u l=0.28u
X4081 VREFP A44_DCTRL_STRIP_W_R2_0/CTRL_OUT[6] A44_CDAC_CAP_BANK_ASSEMBLY_R8_M6_0/A44_CAP_CORE128_M6_R1_0/CAP_BOTTOM_111 VDD pfet_03v3 ad=0 pd=0 as=0 ps=0 w=1.56u l=0.28u
X4082 VREFP A44_DCTRL_STRIP_W_R2_0/CTRL_OUT[6] A44_CDAC_CAP_BANK_ASSEMBLY_R8_M6_0/A44_CAP_CORE128_M6_R1_0/CAP_BOTTOM_111 VDD pfet_03v3 ad=0 pd=0 as=0 ps=0 w=1.56u l=0.28u
X4083 VREFP A44_DCTRL_STRIP_W_R2_0/CTRL_OUT[6] A44_CDAC_CAP_BANK_ASSEMBLY_R8_M6_0/A44_CAP_CORE128_M6_R1_0/CAP_BOTTOM_111 VDD pfet_03v3 ad=0 pd=0 as=0 ps=0 w=1.56u l=0.28u
X4084 VREFP A44_DCTRL_STRIP_W_R2_0/CTRL_OUT[6] A44_CDAC_CAP_BANK_ASSEMBLY_R8_M6_0/A44_CAP_CORE128_M6_R1_0/CAP_BOTTOM_111 VDD pfet_03v3 ad=0 pd=0 as=0 ps=0 w=1.56u l=0.28u
X4085 VREFP A44_DCTRL_STRIP_W_R2_0/CTRL_OUT[6] A44_CDAC_CAP_BANK_ASSEMBLY_R8_M6_0/A44_CAP_CORE128_M6_R1_0/CAP_BOTTOM_111 VDD pfet_03v3 ad=0 pd=0 as=0 ps=0 w=1.56u l=0.28u
X4086 VREFP A44_DCTRL_STRIP_W_R2_0/CTRL_OUT[6] A44_CDAC_CAP_BANK_ASSEMBLY_R8_M6_0/A44_CAP_CORE128_M6_R1_0/CAP_BOTTOM_111 VDD pfet_03v3 ad=0 pd=0 as=0 ps=0 w=1.56u l=0.28u
X4087 VREFP A44_DCTRL_STRIP_W_R2_0/CTRL_OUT[6] A44_CDAC_CAP_BANK_ASSEMBLY_R8_M6_0/A44_CAP_CORE128_M6_R1_0/CAP_BOTTOM_111 VDD pfet_03v3 ad=0 pd=0 as=0 ps=0 w=1.56u l=0.28u
X4088 VREFN A44_DCTRL_STRIP_W_R2_0/CTRL_OUT[6] A44_CDAC_CAP_BANK_ASSEMBLY_R8_M6_0/A44_CAP_CORE128_M6_R1_0/CAP_BOTTOM_111 GND nfet_03v3 ad=0 pd=0 as=16.6842p ps=77.76u w=1.56u l=0.28u
X4089 VREFN A44_DCTRL_STRIP_W_R2_0/CTRL_OUT[6] A44_CDAC_CAP_BANK_ASSEMBLY_R8_M6_0/A44_CAP_CORE128_M6_R1_0/CAP_BOTTOM_111 GND nfet_03v3 ad=0 pd=0 as=0 ps=0 w=1.56u l=0.28u
X4090 VREFN A44_DCTRL_STRIP_W_R2_0/CTRL_OUT[6] A44_CDAC_CAP_BANK_ASSEMBLY_R8_M6_0/A44_CAP_CORE128_M6_R1_0/CAP_BOTTOM_111 GND nfet_03v3 ad=0 pd=0 as=0 ps=0 w=1.56u l=0.28u
X4091 VREFN A44_DCTRL_STRIP_W_R2_0/CTRL_OUT[6] A44_CDAC_CAP_BANK_ASSEMBLY_R8_M6_0/A44_CAP_CORE128_M6_R1_0/CAP_BOTTOM_111 GND nfet_03v3 ad=0 pd=0 as=0 ps=0 w=1.56u l=0.28u
X4092 VREFN A44_DCTRL_STRIP_W_R2_0/CTRL_OUT[6] A44_CDAC_CAP_BANK_ASSEMBLY_R8_M6_0/A44_CAP_CORE128_M6_R1_0/CAP_BOTTOM_111 GND nfet_03v3 ad=0 pd=0 as=0 ps=0 w=1.56u l=0.28u
X4093 VREFN A44_DCTRL_STRIP_W_R2_0/CTRL_OUT[6] A44_CDAC_CAP_BANK_ASSEMBLY_R8_M6_0/A44_CAP_CORE128_M6_R1_0/CAP_BOTTOM_111 GND nfet_03v3 ad=0 pd=0 as=0 ps=0 w=1.56u l=0.28u
X4094 VREFN A44_DCTRL_STRIP_W_R2_0/CTRL_OUT[6] A44_CDAC_CAP_BANK_ASSEMBLY_R8_M6_0/A44_CAP_CORE128_M6_R1_0/CAP_BOTTOM_111 GND nfet_03v3 ad=0 pd=0 as=0 ps=0 w=1.56u l=0.28u
X4095 VREFN A44_DCTRL_STRIP_W_R2_0/CTRL_OUT[6] A44_CDAC_CAP_BANK_ASSEMBLY_R8_M6_0/A44_CAP_CORE128_M6_R1_0/CAP_BOTTOM_111 GND nfet_03v3 ad=0 pd=0 as=0 ps=0 w=1.56u l=0.28u
X4096 VREFN A44_DCTRL_STRIP_W_R2_0/CTRL_OUT[6] A44_CDAC_CAP_BANK_ASSEMBLY_R8_M6_0/A44_CAP_CORE128_M6_R1_0/CAP_BOTTOM_111 GND nfet_03v3 ad=0 pd=0 as=0 ps=0 w=1.56u l=0.28u
X4097 VREFN A44_DCTRL_STRIP_W_R2_0/CTRL_OUT[6] A44_CDAC_CAP_BANK_ASSEMBLY_R8_M6_0/A44_CAP_CORE128_M6_R1_0/CAP_BOTTOM_111 GND nfet_03v3 ad=0 pd=0 as=0 ps=0 w=1.56u l=0.28u
X4098 VREFN A44_DCTRL_STRIP_W_R2_0/CTRL_OUT[6] A44_CDAC_CAP_BANK_ASSEMBLY_R8_M6_0/A44_CAP_CORE128_M6_R1_0/CAP_BOTTOM_111 GND nfet_03v3 ad=0 pd=0 as=0 ps=0 w=1.56u l=0.28u
X4099 VREFN A44_DCTRL_STRIP_W_R2_0/CTRL_OUT[6] A44_CDAC_CAP_BANK_ASSEMBLY_R8_M6_0/A44_CAP_CORE128_M6_R1_0/CAP_BOTTOM_111 GND nfet_03v3 ad=0 pd=0 as=0 ps=0 w=1.56u l=0.28u
X4100 VREFN A44_DCTRL_STRIP_W_R2_0/CTRL_OUT[6] A44_CDAC_CAP_BANK_ASSEMBLY_R8_M6_0/A44_CAP_CORE128_M6_R1_0/CAP_BOTTOM_111 GND nfet_03v3 ad=0 pd=0 as=0 ps=0 w=1.56u l=0.28u
X4101 VREFN A44_DCTRL_STRIP_W_R2_0/CTRL_OUT[6] A44_CDAC_CAP_BANK_ASSEMBLY_R8_M6_0/A44_CAP_CORE128_M6_R1_0/CAP_BOTTOM_111 GND nfet_03v3 ad=0 pd=0 as=0 ps=0 w=1.56u l=0.28u
X4102 VREFN A44_DCTRL_STRIP_W_R2_0/CTRL_OUT[6] A44_CDAC_CAP_BANK_ASSEMBLY_R8_M6_0/A44_CAP_CORE128_M6_R1_0/CAP_BOTTOM_111 GND nfet_03v3 ad=0 pd=0 as=0 ps=0 w=1.56u l=0.28u
X4103 VREFN A44_DCTRL_STRIP_W_R2_0/CTRL_OUT[6] A44_CDAC_CAP_BANK_ASSEMBLY_R8_M6_0/A44_CAP_CORE128_M6_R1_0/CAP_BOTTOM_111 GND nfet_03v3 ad=0 pd=0 as=0 ps=0 w=1.56u l=0.28u
X4104 VREFN A44_DCTRL_STRIP_W_R2_0/CTRL_OUT[6] A44_CDAC_CAP_BANK_ASSEMBLY_R8_M6_0/A44_CAP_CORE128_M6_R1_0/CAP_BOTTOM_111 GND nfet_03v3 ad=0 pd=0 as=0 ps=0 w=1.56u l=0.28u
X4105 VREFN A44_DCTRL_STRIP_W_R2_0/CTRL_OUT[6] A44_CDAC_CAP_BANK_ASSEMBLY_R8_M6_0/A44_CAP_CORE128_M6_R1_0/CAP_BOTTOM_111 GND nfet_03v3 ad=0 pd=0 as=0 ps=0 w=1.56u l=0.28u
X4106 VREFP A44_DCTRL_STRIP_W_R2_0/CTRL_OUT[6] A44_CDAC_CAP_BANK_ASSEMBLY_R8_M6_0/A44_CAP_CORE128_M6_R1_0/CAP_BOTTOM_077 VDD pfet_03v3 ad=0 pd=0 as=16.6842p ps=77.76u w=1.56u l=0.28u
X4107 VREFP A44_DCTRL_STRIP_W_R2_0/CTRL_OUT[6] A44_CDAC_CAP_BANK_ASSEMBLY_R8_M6_0/A44_CAP_CORE128_M6_R1_0/CAP_BOTTOM_077 VDD pfet_03v3 ad=0 pd=0 as=0 ps=0 w=1.56u l=0.28u
X4108 VREFP A44_DCTRL_STRIP_W_R2_0/CTRL_OUT[6] A44_CDAC_CAP_BANK_ASSEMBLY_R8_M6_0/A44_CAP_CORE128_M6_R1_0/CAP_BOTTOM_077 VDD pfet_03v3 ad=0 pd=0 as=0 ps=0 w=1.56u l=0.28u
X4109 VREFP A44_DCTRL_STRIP_W_R2_0/CTRL_OUT[6] A44_CDAC_CAP_BANK_ASSEMBLY_R8_M6_0/A44_CAP_CORE128_M6_R1_0/CAP_BOTTOM_077 VDD pfet_03v3 ad=0 pd=0 as=0 ps=0 w=1.56u l=0.28u
X4110 VREFP A44_DCTRL_STRIP_W_R2_0/CTRL_OUT[6] A44_CDAC_CAP_BANK_ASSEMBLY_R8_M6_0/A44_CAP_CORE128_M6_R1_0/CAP_BOTTOM_077 VDD pfet_03v3 ad=0 pd=0 as=0 ps=0 w=1.56u l=0.28u
X4111 VREFP A44_DCTRL_STRIP_W_R2_0/CTRL_OUT[6] A44_CDAC_CAP_BANK_ASSEMBLY_R8_M6_0/A44_CAP_CORE128_M6_R1_0/CAP_BOTTOM_077 VDD pfet_03v3 ad=0 pd=0 as=0 ps=0 w=1.56u l=0.28u
X4112 VREFP A44_DCTRL_STRIP_W_R2_0/CTRL_OUT[6] A44_CDAC_CAP_BANK_ASSEMBLY_R8_M6_0/A44_CAP_CORE128_M6_R1_0/CAP_BOTTOM_077 VDD pfet_03v3 ad=0 pd=0 as=0 ps=0 w=1.56u l=0.28u
X4113 VREFP A44_DCTRL_STRIP_W_R2_0/CTRL_OUT[6] A44_CDAC_CAP_BANK_ASSEMBLY_R8_M6_0/A44_CAP_CORE128_M6_R1_0/CAP_BOTTOM_077 VDD pfet_03v3 ad=0 pd=0 as=0 ps=0 w=1.56u l=0.28u
X4114 VREFP A44_DCTRL_STRIP_W_R2_0/CTRL_OUT[6] A44_CDAC_CAP_BANK_ASSEMBLY_R8_M6_0/A44_CAP_CORE128_M6_R1_0/CAP_BOTTOM_077 VDD pfet_03v3 ad=0 pd=0 as=0 ps=0 w=1.56u l=0.28u
X4115 VREFP A44_DCTRL_STRIP_W_R2_0/CTRL_OUT[6] A44_CDAC_CAP_BANK_ASSEMBLY_R8_M6_0/A44_CAP_CORE128_M6_R1_0/CAP_BOTTOM_077 VDD pfet_03v3 ad=0 pd=0 as=0 ps=0 w=1.56u l=0.28u
X4116 VREFP A44_DCTRL_STRIP_W_R2_0/CTRL_OUT[6] A44_CDAC_CAP_BANK_ASSEMBLY_R8_M6_0/A44_CAP_CORE128_M6_R1_0/CAP_BOTTOM_077 VDD pfet_03v3 ad=0 pd=0 as=0 ps=0 w=1.56u l=0.28u
X4117 VREFP A44_DCTRL_STRIP_W_R2_0/CTRL_OUT[6] A44_CDAC_CAP_BANK_ASSEMBLY_R8_M6_0/A44_CAP_CORE128_M6_R1_0/CAP_BOTTOM_077 VDD pfet_03v3 ad=0 pd=0 as=0 ps=0 w=1.56u l=0.28u
X4118 VREFP A44_DCTRL_STRIP_W_R2_0/CTRL_OUT[6] A44_CDAC_CAP_BANK_ASSEMBLY_R8_M6_0/A44_CAP_CORE128_M6_R1_0/CAP_BOTTOM_077 VDD pfet_03v3 ad=0 pd=0 as=0 ps=0 w=1.56u l=0.28u
X4119 VREFP A44_DCTRL_STRIP_W_R2_0/CTRL_OUT[6] A44_CDAC_CAP_BANK_ASSEMBLY_R8_M6_0/A44_CAP_CORE128_M6_R1_0/CAP_BOTTOM_077 VDD pfet_03v3 ad=0 pd=0 as=0 ps=0 w=1.56u l=0.28u
X4120 VREFP A44_DCTRL_STRIP_W_R2_0/CTRL_OUT[6] A44_CDAC_CAP_BANK_ASSEMBLY_R8_M6_0/A44_CAP_CORE128_M6_R1_0/CAP_BOTTOM_077 VDD pfet_03v3 ad=0 pd=0 as=0 ps=0 w=1.56u l=0.28u
X4121 VREFP A44_DCTRL_STRIP_W_R2_0/CTRL_OUT[6] A44_CDAC_CAP_BANK_ASSEMBLY_R8_M6_0/A44_CAP_CORE128_M6_R1_0/CAP_BOTTOM_077 VDD pfet_03v3 ad=0 pd=0 as=0 ps=0 w=1.56u l=0.28u
X4122 VREFP A44_DCTRL_STRIP_W_R2_0/CTRL_OUT[6] A44_CDAC_CAP_BANK_ASSEMBLY_R8_M6_0/A44_CAP_CORE128_M6_R1_0/CAP_BOTTOM_077 VDD pfet_03v3 ad=0 pd=0 as=0 ps=0 w=1.56u l=0.28u
X4123 VREFP A44_DCTRL_STRIP_W_R2_0/CTRL_OUT[6] A44_CDAC_CAP_BANK_ASSEMBLY_R8_M6_0/A44_CAP_CORE128_M6_R1_0/CAP_BOTTOM_077 VDD pfet_03v3 ad=0 pd=0 as=0 ps=0 w=1.56u l=0.28u
X4124 VREFN A44_DCTRL_STRIP_W_R2_0/CTRL_OUT[6] A44_CDAC_CAP_BANK_ASSEMBLY_R8_M6_0/A44_CAP_CORE128_M6_R1_0/CAP_BOTTOM_077 GND nfet_03v3 ad=0 pd=0 as=16.6842p ps=77.76u w=1.56u l=0.28u
X4125 VREFN A44_DCTRL_STRIP_W_R2_0/CTRL_OUT[6] A44_CDAC_CAP_BANK_ASSEMBLY_R8_M6_0/A44_CAP_CORE128_M6_R1_0/CAP_BOTTOM_077 GND nfet_03v3 ad=0 pd=0 as=0 ps=0 w=1.56u l=0.28u
X4126 VREFN A44_DCTRL_STRIP_W_R2_0/CTRL_OUT[6] A44_CDAC_CAP_BANK_ASSEMBLY_R8_M6_0/A44_CAP_CORE128_M6_R1_0/CAP_BOTTOM_077 GND nfet_03v3 ad=0 pd=0 as=0 ps=0 w=1.56u l=0.28u
X4127 VREFN A44_DCTRL_STRIP_W_R2_0/CTRL_OUT[6] A44_CDAC_CAP_BANK_ASSEMBLY_R8_M6_0/A44_CAP_CORE128_M6_R1_0/CAP_BOTTOM_077 GND nfet_03v3 ad=0 pd=0 as=0 ps=0 w=1.56u l=0.28u
X4128 VREFN A44_DCTRL_STRIP_W_R2_0/CTRL_OUT[6] A44_CDAC_CAP_BANK_ASSEMBLY_R8_M6_0/A44_CAP_CORE128_M6_R1_0/CAP_BOTTOM_077 GND nfet_03v3 ad=0 pd=0 as=0 ps=0 w=1.56u l=0.28u
X4129 VREFN A44_DCTRL_STRIP_W_R2_0/CTRL_OUT[6] A44_CDAC_CAP_BANK_ASSEMBLY_R8_M6_0/A44_CAP_CORE128_M6_R1_0/CAP_BOTTOM_077 GND nfet_03v3 ad=0 pd=0 as=0 ps=0 w=1.56u l=0.28u
X4130 VREFN A44_DCTRL_STRIP_W_R2_0/CTRL_OUT[6] A44_CDAC_CAP_BANK_ASSEMBLY_R8_M6_0/A44_CAP_CORE128_M6_R1_0/CAP_BOTTOM_077 GND nfet_03v3 ad=0 pd=0 as=0 ps=0 w=1.56u l=0.28u
X4131 VREFN A44_DCTRL_STRIP_W_R2_0/CTRL_OUT[6] A44_CDAC_CAP_BANK_ASSEMBLY_R8_M6_0/A44_CAP_CORE128_M6_R1_0/CAP_BOTTOM_077 GND nfet_03v3 ad=0 pd=0 as=0 ps=0 w=1.56u l=0.28u
X4132 VREFN A44_DCTRL_STRIP_W_R2_0/CTRL_OUT[6] A44_CDAC_CAP_BANK_ASSEMBLY_R8_M6_0/A44_CAP_CORE128_M6_R1_0/CAP_BOTTOM_077 GND nfet_03v3 ad=0 pd=0 as=0 ps=0 w=1.56u l=0.28u
X4133 VREFN A44_DCTRL_STRIP_W_R2_0/CTRL_OUT[6] A44_CDAC_CAP_BANK_ASSEMBLY_R8_M6_0/A44_CAP_CORE128_M6_R1_0/CAP_BOTTOM_077 GND nfet_03v3 ad=0 pd=0 as=0 ps=0 w=1.56u l=0.28u
X4134 VREFN A44_DCTRL_STRIP_W_R2_0/CTRL_OUT[6] A44_CDAC_CAP_BANK_ASSEMBLY_R8_M6_0/A44_CAP_CORE128_M6_R1_0/CAP_BOTTOM_077 GND nfet_03v3 ad=0 pd=0 as=0 ps=0 w=1.56u l=0.28u
X4135 VREFN A44_DCTRL_STRIP_W_R2_0/CTRL_OUT[6] A44_CDAC_CAP_BANK_ASSEMBLY_R8_M6_0/A44_CAP_CORE128_M6_R1_0/CAP_BOTTOM_077 GND nfet_03v3 ad=0 pd=0 as=0 ps=0 w=1.56u l=0.28u
X4136 VREFN A44_DCTRL_STRIP_W_R2_0/CTRL_OUT[6] A44_CDAC_CAP_BANK_ASSEMBLY_R8_M6_0/A44_CAP_CORE128_M6_R1_0/CAP_BOTTOM_077 GND nfet_03v3 ad=0 pd=0 as=0 ps=0 w=1.56u l=0.28u
X4137 VREFN A44_DCTRL_STRIP_W_R2_0/CTRL_OUT[6] A44_CDAC_CAP_BANK_ASSEMBLY_R8_M6_0/A44_CAP_CORE128_M6_R1_0/CAP_BOTTOM_077 GND nfet_03v3 ad=0 pd=0 as=0 ps=0 w=1.56u l=0.28u
X4138 VREFN A44_DCTRL_STRIP_W_R2_0/CTRL_OUT[6] A44_CDAC_CAP_BANK_ASSEMBLY_R8_M6_0/A44_CAP_CORE128_M6_R1_0/CAP_BOTTOM_077 GND nfet_03v3 ad=0 pd=0 as=0 ps=0 w=1.56u l=0.28u
X4139 VREFN A44_DCTRL_STRIP_W_R2_0/CTRL_OUT[6] A44_CDAC_CAP_BANK_ASSEMBLY_R8_M6_0/A44_CAP_CORE128_M6_R1_0/CAP_BOTTOM_077 GND nfet_03v3 ad=0 pd=0 as=0 ps=0 w=1.56u l=0.28u
X4140 VREFN A44_DCTRL_STRIP_W_R2_0/CTRL_OUT[6] A44_CDAC_CAP_BANK_ASSEMBLY_R8_M6_0/A44_CAP_CORE128_M6_R1_0/CAP_BOTTOM_077 GND nfet_03v3 ad=0 pd=0 as=0 ps=0 w=1.56u l=0.28u
X4141 VREFN A44_DCTRL_STRIP_W_R2_0/CTRL_OUT[6] A44_CDAC_CAP_BANK_ASSEMBLY_R8_M6_0/A44_CAP_CORE128_M6_R1_0/CAP_BOTTOM_077 GND nfet_03v3 ad=0 pd=0 as=0 ps=0 w=1.56u l=0.28u
X4142 VREFP A44_DCTRL_STRIP_W_R2_0/CTRL_OUT[4] A44_CDAC_CAP_BANK_ASSEMBLY_R8_M6_0/A44_CAP_CORE128_M6_R1_0/CAP_BOTTOM_075 VDD pfet_03v3 ad=0 pd=0 as=16.6842p ps=77.76u w=1.56u l=0.28u
X4143 VREFP A44_DCTRL_STRIP_W_R2_0/CTRL_OUT[4] A44_CDAC_CAP_BANK_ASSEMBLY_R8_M6_0/A44_CAP_CORE128_M6_R1_0/CAP_BOTTOM_075 VDD pfet_03v3 ad=0 pd=0 as=0 ps=0 w=1.56u l=0.28u
X4144 VREFP A44_DCTRL_STRIP_W_R2_0/CTRL_OUT[4] A44_CDAC_CAP_BANK_ASSEMBLY_R8_M6_0/A44_CAP_CORE128_M6_R1_0/CAP_BOTTOM_075 VDD pfet_03v3 ad=0 pd=0 as=0 ps=0 w=1.56u l=0.28u
X4145 VREFP A44_DCTRL_STRIP_W_R2_0/CTRL_OUT[4] A44_CDAC_CAP_BANK_ASSEMBLY_R8_M6_0/A44_CAP_CORE128_M6_R1_0/CAP_BOTTOM_075 VDD pfet_03v3 ad=0 pd=0 as=0 ps=0 w=1.56u l=0.28u
X4146 VREFP A44_DCTRL_STRIP_W_R2_0/CTRL_OUT[4] A44_CDAC_CAP_BANK_ASSEMBLY_R8_M6_0/A44_CAP_CORE128_M6_R1_0/CAP_BOTTOM_075 VDD pfet_03v3 ad=0 pd=0 as=0 ps=0 w=1.56u l=0.28u
X4147 VREFP A44_DCTRL_STRIP_W_R2_0/CTRL_OUT[4] A44_CDAC_CAP_BANK_ASSEMBLY_R8_M6_0/A44_CAP_CORE128_M6_R1_0/CAP_BOTTOM_075 VDD pfet_03v3 ad=0 pd=0 as=0 ps=0 w=1.56u l=0.28u
X4148 VREFP A44_DCTRL_STRIP_W_R2_0/CTRL_OUT[4] A44_CDAC_CAP_BANK_ASSEMBLY_R8_M6_0/A44_CAP_CORE128_M6_R1_0/CAP_BOTTOM_075 VDD pfet_03v3 ad=0 pd=0 as=0 ps=0 w=1.56u l=0.28u
X4149 VREFP A44_DCTRL_STRIP_W_R2_0/CTRL_OUT[4] A44_CDAC_CAP_BANK_ASSEMBLY_R8_M6_0/A44_CAP_CORE128_M6_R1_0/CAP_BOTTOM_075 VDD pfet_03v3 ad=0 pd=0 as=0 ps=0 w=1.56u l=0.28u
X4150 VREFP A44_DCTRL_STRIP_W_R2_0/CTRL_OUT[4] A44_CDAC_CAP_BANK_ASSEMBLY_R8_M6_0/A44_CAP_CORE128_M6_R1_0/CAP_BOTTOM_075 VDD pfet_03v3 ad=0 pd=0 as=0 ps=0 w=1.56u l=0.28u
X4151 VREFP A44_DCTRL_STRIP_W_R2_0/CTRL_OUT[4] A44_CDAC_CAP_BANK_ASSEMBLY_R8_M6_0/A44_CAP_CORE128_M6_R1_0/CAP_BOTTOM_075 VDD pfet_03v3 ad=0 pd=0 as=0 ps=0 w=1.56u l=0.28u
X4152 VREFP A44_DCTRL_STRIP_W_R2_0/CTRL_OUT[4] A44_CDAC_CAP_BANK_ASSEMBLY_R8_M6_0/A44_CAP_CORE128_M6_R1_0/CAP_BOTTOM_075 VDD pfet_03v3 ad=0 pd=0 as=0 ps=0 w=1.56u l=0.28u
X4153 VREFP A44_DCTRL_STRIP_W_R2_0/CTRL_OUT[4] A44_CDAC_CAP_BANK_ASSEMBLY_R8_M6_0/A44_CAP_CORE128_M6_R1_0/CAP_BOTTOM_075 VDD pfet_03v3 ad=0 pd=0 as=0 ps=0 w=1.56u l=0.28u
X4154 VREFP A44_DCTRL_STRIP_W_R2_0/CTRL_OUT[4] A44_CDAC_CAP_BANK_ASSEMBLY_R8_M6_0/A44_CAP_CORE128_M6_R1_0/CAP_BOTTOM_075 VDD pfet_03v3 ad=0 pd=0 as=0 ps=0 w=1.56u l=0.28u
X4155 VREFP A44_DCTRL_STRIP_W_R2_0/CTRL_OUT[4] A44_CDAC_CAP_BANK_ASSEMBLY_R8_M6_0/A44_CAP_CORE128_M6_R1_0/CAP_BOTTOM_075 VDD pfet_03v3 ad=0 pd=0 as=0 ps=0 w=1.56u l=0.28u
X4156 VREFP A44_DCTRL_STRIP_W_R2_0/CTRL_OUT[4] A44_CDAC_CAP_BANK_ASSEMBLY_R8_M6_0/A44_CAP_CORE128_M6_R1_0/CAP_BOTTOM_075 VDD pfet_03v3 ad=0 pd=0 as=0 ps=0 w=1.56u l=0.28u
X4157 VREFP A44_DCTRL_STRIP_W_R2_0/CTRL_OUT[4] A44_CDAC_CAP_BANK_ASSEMBLY_R8_M6_0/A44_CAP_CORE128_M6_R1_0/CAP_BOTTOM_075 VDD pfet_03v3 ad=0 pd=0 as=0 ps=0 w=1.56u l=0.28u
X4158 VREFP A44_DCTRL_STRIP_W_R2_0/CTRL_OUT[4] A44_CDAC_CAP_BANK_ASSEMBLY_R8_M6_0/A44_CAP_CORE128_M6_R1_0/CAP_BOTTOM_075 VDD pfet_03v3 ad=0 pd=0 as=0 ps=0 w=1.56u l=0.28u
X4159 VREFP A44_DCTRL_STRIP_W_R2_0/CTRL_OUT[4] A44_CDAC_CAP_BANK_ASSEMBLY_R8_M6_0/A44_CAP_CORE128_M6_R1_0/CAP_BOTTOM_075 VDD pfet_03v3 ad=0 pd=0 as=0 ps=0 w=1.56u l=0.28u
X4160 VREFN A44_DCTRL_STRIP_W_R2_0/CTRL_OUT[4] A44_CDAC_CAP_BANK_ASSEMBLY_R8_M6_0/A44_CAP_CORE128_M6_R1_0/CAP_BOTTOM_075 GND nfet_03v3 ad=0 pd=0 as=16.6842p ps=77.76u w=1.56u l=0.28u
X4161 VREFN A44_DCTRL_STRIP_W_R2_0/CTRL_OUT[4] A44_CDAC_CAP_BANK_ASSEMBLY_R8_M6_0/A44_CAP_CORE128_M6_R1_0/CAP_BOTTOM_075 GND nfet_03v3 ad=0 pd=0 as=0 ps=0 w=1.56u l=0.28u
X4162 VREFN A44_DCTRL_STRIP_W_R2_0/CTRL_OUT[4] A44_CDAC_CAP_BANK_ASSEMBLY_R8_M6_0/A44_CAP_CORE128_M6_R1_0/CAP_BOTTOM_075 GND nfet_03v3 ad=0 pd=0 as=0 ps=0 w=1.56u l=0.28u
X4163 VREFN A44_DCTRL_STRIP_W_R2_0/CTRL_OUT[4] A44_CDAC_CAP_BANK_ASSEMBLY_R8_M6_0/A44_CAP_CORE128_M6_R1_0/CAP_BOTTOM_075 GND nfet_03v3 ad=0 pd=0 as=0 ps=0 w=1.56u l=0.28u
X4164 VREFN A44_DCTRL_STRIP_W_R2_0/CTRL_OUT[4] A44_CDAC_CAP_BANK_ASSEMBLY_R8_M6_0/A44_CAP_CORE128_M6_R1_0/CAP_BOTTOM_075 GND nfet_03v3 ad=0 pd=0 as=0 ps=0 w=1.56u l=0.28u
X4165 VREFN A44_DCTRL_STRIP_W_R2_0/CTRL_OUT[4] A44_CDAC_CAP_BANK_ASSEMBLY_R8_M6_0/A44_CAP_CORE128_M6_R1_0/CAP_BOTTOM_075 GND nfet_03v3 ad=0 pd=0 as=0 ps=0 w=1.56u l=0.28u
X4166 VREFN A44_DCTRL_STRIP_W_R2_0/CTRL_OUT[4] A44_CDAC_CAP_BANK_ASSEMBLY_R8_M6_0/A44_CAP_CORE128_M6_R1_0/CAP_BOTTOM_075 GND nfet_03v3 ad=0 pd=0 as=0 ps=0 w=1.56u l=0.28u
X4167 VREFN A44_DCTRL_STRIP_W_R2_0/CTRL_OUT[4] A44_CDAC_CAP_BANK_ASSEMBLY_R8_M6_0/A44_CAP_CORE128_M6_R1_0/CAP_BOTTOM_075 GND nfet_03v3 ad=0 pd=0 as=0 ps=0 w=1.56u l=0.28u
X4168 VREFN A44_DCTRL_STRIP_W_R2_0/CTRL_OUT[4] A44_CDAC_CAP_BANK_ASSEMBLY_R8_M6_0/A44_CAP_CORE128_M6_R1_0/CAP_BOTTOM_075 GND nfet_03v3 ad=0 pd=0 as=0 ps=0 w=1.56u l=0.28u
X4169 VREFN A44_DCTRL_STRIP_W_R2_0/CTRL_OUT[4] A44_CDAC_CAP_BANK_ASSEMBLY_R8_M6_0/A44_CAP_CORE128_M6_R1_0/CAP_BOTTOM_075 GND nfet_03v3 ad=0 pd=0 as=0 ps=0 w=1.56u l=0.28u
X4170 VREFN A44_DCTRL_STRIP_W_R2_0/CTRL_OUT[4] A44_CDAC_CAP_BANK_ASSEMBLY_R8_M6_0/A44_CAP_CORE128_M6_R1_0/CAP_BOTTOM_075 GND nfet_03v3 ad=0 pd=0 as=0 ps=0 w=1.56u l=0.28u
X4171 VREFN A44_DCTRL_STRIP_W_R2_0/CTRL_OUT[4] A44_CDAC_CAP_BANK_ASSEMBLY_R8_M6_0/A44_CAP_CORE128_M6_R1_0/CAP_BOTTOM_075 GND nfet_03v3 ad=0 pd=0 as=0 ps=0 w=1.56u l=0.28u
X4172 VREFN A44_DCTRL_STRIP_W_R2_0/CTRL_OUT[4] A44_CDAC_CAP_BANK_ASSEMBLY_R8_M6_0/A44_CAP_CORE128_M6_R1_0/CAP_BOTTOM_075 GND nfet_03v3 ad=0 pd=0 as=0 ps=0 w=1.56u l=0.28u
X4173 VREFN A44_DCTRL_STRIP_W_R2_0/CTRL_OUT[4] A44_CDAC_CAP_BANK_ASSEMBLY_R8_M6_0/A44_CAP_CORE128_M6_R1_0/CAP_BOTTOM_075 GND nfet_03v3 ad=0 pd=0 as=0 ps=0 w=1.56u l=0.28u
X4174 VREFN A44_DCTRL_STRIP_W_R2_0/CTRL_OUT[4] A44_CDAC_CAP_BANK_ASSEMBLY_R8_M6_0/A44_CAP_CORE128_M6_R1_0/CAP_BOTTOM_075 GND nfet_03v3 ad=0 pd=0 as=0 ps=0 w=1.56u l=0.28u
X4175 VREFN A44_DCTRL_STRIP_W_R2_0/CTRL_OUT[4] A44_CDAC_CAP_BANK_ASSEMBLY_R8_M6_0/A44_CAP_CORE128_M6_R1_0/CAP_BOTTOM_075 GND nfet_03v3 ad=0 pd=0 as=0 ps=0 w=1.56u l=0.28u
X4176 VREFN A44_DCTRL_STRIP_W_R2_0/CTRL_OUT[4] A44_CDAC_CAP_BANK_ASSEMBLY_R8_M6_0/A44_CAP_CORE128_M6_R1_0/CAP_BOTTOM_075 GND nfet_03v3 ad=0 pd=0 as=0 ps=0 w=1.56u l=0.28u
X4177 VREFN A44_DCTRL_STRIP_W_R2_0/CTRL_OUT[4] A44_CDAC_CAP_BANK_ASSEMBLY_R8_M6_0/A44_CAP_CORE128_M6_R1_0/CAP_BOTTOM_075 GND nfet_03v3 ad=0 pd=0 as=0 ps=0 w=1.56u l=0.28u
X4178 VREFP A44_DCTRL_STRIP_W_R2_0/CTRL_OUT[6] A44_CDAC_CAP_BANK_ASSEMBLY_R8_M6_0/A44_CAP_CORE128_M6_R1_0/CAP_BOTTOM_098 VDD pfet_03v3 ad=0 pd=0 as=16.6842p ps=77.76u w=1.56u l=0.28u
X4179 VREFP A44_DCTRL_STRIP_W_R2_0/CTRL_OUT[6] A44_CDAC_CAP_BANK_ASSEMBLY_R8_M6_0/A44_CAP_CORE128_M6_R1_0/CAP_BOTTOM_098 VDD pfet_03v3 ad=0 pd=0 as=0 ps=0 w=1.56u l=0.28u
X4180 VREFP A44_DCTRL_STRIP_W_R2_0/CTRL_OUT[6] A44_CDAC_CAP_BANK_ASSEMBLY_R8_M6_0/A44_CAP_CORE128_M6_R1_0/CAP_BOTTOM_098 VDD pfet_03v3 ad=0 pd=0 as=0 ps=0 w=1.56u l=0.28u
X4181 VREFP A44_DCTRL_STRIP_W_R2_0/CTRL_OUT[6] A44_CDAC_CAP_BANK_ASSEMBLY_R8_M6_0/A44_CAP_CORE128_M6_R1_0/CAP_BOTTOM_098 VDD pfet_03v3 ad=0 pd=0 as=0 ps=0 w=1.56u l=0.28u
X4182 VREFP A44_DCTRL_STRIP_W_R2_0/CTRL_OUT[6] A44_CDAC_CAP_BANK_ASSEMBLY_R8_M6_0/A44_CAP_CORE128_M6_R1_0/CAP_BOTTOM_098 VDD pfet_03v3 ad=0 pd=0 as=0 ps=0 w=1.56u l=0.28u
X4183 VREFP A44_DCTRL_STRIP_W_R2_0/CTRL_OUT[6] A44_CDAC_CAP_BANK_ASSEMBLY_R8_M6_0/A44_CAP_CORE128_M6_R1_0/CAP_BOTTOM_098 VDD pfet_03v3 ad=0 pd=0 as=0 ps=0 w=1.56u l=0.28u
X4184 VREFP A44_DCTRL_STRIP_W_R2_0/CTRL_OUT[6] A44_CDAC_CAP_BANK_ASSEMBLY_R8_M6_0/A44_CAP_CORE128_M6_R1_0/CAP_BOTTOM_098 VDD pfet_03v3 ad=0 pd=0 as=0 ps=0 w=1.56u l=0.28u
X4185 VREFP A44_DCTRL_STRIP_W_R2_0/CTRL_OUT[6] A44_CDAC_CAP_BANK_ASSEMBLY_R8_M6_0/A44_CAP_CORE128_M6_R1_0/CAP_BOTTOM_098 VDD pfet_03v3 ad=0 pd=0 as=0 ps=0 w=1.56u l=0.28u
X4186 VREFP A44_DCTRL_STRIP_W_R2_0/CTRL_OUT[6] A44_CDAC_CAP_BANK_ASSEMBLY_R8_M6_0/A44_CAP_CORE128_M6_R1_0/CAP_BOTTOM_098 VDD pfet_03v3 ad=0 pd=0 as=0 ps=0 w=1.56u l=0.28u
X4187 VREFP A44_DCTRL_STRIP_W_R2_0/CTRL_OUT[6] A44_CDAC_CAP_BANK_ASSEMBLY_R8_M6_0/A44_CAP_CORE128_M6_R1_0/CAP_BOTTOM_098 VDD pfet_03v3 ad=0 pd=0 as=0 ps=0 w=1.56u l=0.28u
X4188 VREFP A44_DCTRL_STRIP_W_R2_0/CTRL_OUT[6] A44_CDAC_CAP_BANK_ASSEMBLY_R8_M6_0/A44_CAP_CORE128_M6_R1_0/CAP_BOTTOM_098 VDD pfet_03v3 ad=0 pd=0 as=0 ps=0 w=1.56u l=0.28u
X4189 VREFP A44_DCTRL_STRIP_W_R2_0/CTRL_OUT[6] A44_CDAC_CAP_BANK_ASSEMBLY_R8_M6_0/A44_CAP_CORE128_M6_R1_0/CAP_BOTTOM_098 VDD pfet_03v3 ad=0 pd=0 as=0 ps=0 w=1.56u l=0.28u
X4190 VREFP A44_DCTRL_STRIP_W_R2_0/CTRL_OUT[6] A44_CDAC_CAP_BANK_ASSEMBLY_R8_M6_0/A44_CAP_CORE128_M6_R1_0/CAP_BOTTOM_098 VDD pfet_03v3 ad=0 pd=0 as=0 ps=0 w=1.56u l=0.28u
X4191 VREFP A44_DCTRL_STRIP_W_R2_0/CTRL_OUT[6] A44_CDAC_CAP_BANK_ASSEMBLY_R8_M6_0/A44_CAP_CORE128_M6_R1_0/CAP_BOTTOM_098 VDD pfet_03v3 ad=0 pd=0 as=0 ps=0 w=1.56u l=0.28u
X4192 VREFP A44_DCTRL_STRIP_W_R2_0/CTRL_OUT[6] A44_CDAC_CAP_BANK_ASSEMBLY_R8_M6_0/A44_CAP_CORE128_M6_R1_0/CAP_BOTTOM_098 VDD pfet_03v3 ad=0 pd=0 as=0 ps=0 w=1.56u l=0.28u
X4193 VREFP A44_DCTRL_STRIP_W_R2_0/CTRL_OUT[6] A44_CDAC_CAP_BANK_ASSEMBLY_R8_M6_0/A44_CAP_CORE128_M6_R1_0/CAP_BOTTOM_098 VDD pfet_03v3 ad=0 pd=0 as=0 ps=0 w=1.56u l=0.28u
X4194 VREFP A44_DCTRL_STRIP_W_R2_0/CTRL_OUT[6] A44_CDAC_CAP_BANK_ASSEMBLY_R8_M6_0/A44_CAP_CORE128_M6_R1_0/CAP_BOTTOM_098 VDD pfet_03v3 ad=0 pd=0 as=0 ps=0 w=1.56u l=0.28u
X4195 VREFP A44_DCTRL_STRIP_W_R2_0/CTRL_OUT[6] A44_CDAC_CAP_BANK_ASSEMBLY_R8_M6_0/A44_CAP_CORE128_M6_R1_0/CAP_BOTTOM_098 VDD pfet_03v3 ad=0 pd=0 as=0 ps=0 w=1.56u l=0.28u
X4196 VREFN A44_DCTRL_STRIP_W_R2_0/CTRL_OUT[6] A44_CDAC_CAP_BANK_ASSEMBLY_R8_M6_0/A44_CAP_CORE128_M6_R1_0/CAP_BOTTOM_098 GND nfet_03v3 ad=0 pd=0 as=16.6842p ps=77.76u w=1.56u l=0.28u
X4197 VREFN A44_DCTRL_STRIP_W_R2_0/CTRL_OUT[6] A44_CDAC_CAP_BANK_ASSEMBLY_R8_M6_0/A44_CAP_CORE128_M6_R1_0/CAP_BOTTOM_098 GND nfet_03v3 ad=0 pd=0 as=0 ps=0 w=1.56u l=0.28u
X4198 VREFN A44_DCTRL_STRIP_W_R2_0/CTRL_OUT[6] A44_CDAC_CAP_BANK_ASSEMBLY_R8_M6_0/A44_CAP_CORE128_M6_R1_0/CAP_BOTTOM_098 GND nfet_03v3 ad=0 pd=0 as=0 ps=0 w=1.56u l=0.28u
X4199 VREFN A44_DCTRL_STRIP_W_R2_0/CTRL_OUT[6] A44_CDAC_CAP_BANK_ASSEMBLY_R8_M6_0/A44_CAP_CORE128_M6_R1_0/CAP_BOTTOM_098 GND nfet_03v3 ad=0 pd=0 as=0 ps=0 w=1.56u l=0.28u
X4200 VREFN A44_DCTRL_STRIP_W_R2_0/CTRL_OUT[6] A44_CDAC_CAP_BANK_ASSEMBLY_R8_M6_0/A44_CAP_CORE128_M6_R1_0/CAP_BOTTOM_098 GND nfet_03v3 ad=0 pd=0 as=0 ps=0 w=1.56u l=0.28u
X4201 VREFN A44_DCTRL_STRIP_W_R2_0/CTRL_OUT[6] A44_CDAC_CAP_BANK_ASSEMBLY_R8_M6_0/A44_CAP_CORE128_M6_R1_0/CAP_BOTTOM_098 GND nfet_03v3 ad=0 pd=0 as=0 ps=0 w=1.56u l=0.28u
X4202 VREFN A44_DCTRL_STRIP_W_R2_0/CTRL_OUT[6] A44_CDAC_CAP_BANK_ASSEMBLY_R8_M6_0/A44_CAP_CORE128_M6_R1_0/CAP_BOTTOM_098 GND nfet_03v3 ad=0 pd=0 as=0 ps=0 w=1.56u l=0.28u
X4203 VREFN A44_DCTRL_STRIP_W_R2_0/CTRL_OUT[6] A44_CDAC_CAP_BANK_ASSEMBLY_R8_M6_0/A44_CAP_CORE128_M6_R1_0/CAP_BOTTOM_098 GND nfet_03v3 ad=0 pd=0 as=0 ps=0 w=1.56u l=0.28u
X4204 VREFN A44_DCTRL_STRIP_W_R2_0/CTRL_OUT[6] A44_CDAC_CAP_BANK_ASSEMBLY_R8_M6_0/A44_CAP_CORE128_M6_R1_0/CAP_BOTTOM_098 GND nfet_03v3 ad=0 pd=0 as=0 ps=0 w=1.56u l=0.28u
X4205 VREFN A44_DCTRL_STRIP_W_R2_0/CTRL_OUT[6] A44_CDAC_CAP_BANK_ASSEMBLY_R8_M6_0/A44_CAP_CORE128_M6_R1_0/CAP_BOTTOM_098 GND nfet_03v3 ad=0 pd=0 as=0 ps=0 w=1.56u l=0.28u
X4206 VREFN A44_DCTRL_STRIP_W_R2_0/CTRL_OUT[6] A44_CDAC_CAP_BANK_ASSEMBLY_R8_M6_0/A44_CAP_CORE128_M6_R1_0/CAP_BOTTOM_098 GND nfet_03v3 ad=0 pd=0 as=0 ps=0 w=1.56u l=0.28u
X4207 VREFN A44_DCTRL_STRIP_W_R2_0/CTRL_OUT[6] A44_CDAC_CAP_BANK_ASSEMBLY_R8_M6_0/A44_CAP_CORE128_M6_R1_0/CAP_BOTTOM_098 GND nfet_03v3 ad=0 pd=0 as=0 ps=0 w=1.56u l=0.28u
X4208 VREFN A44_DCTRL_STRIP_W_R2_0/CTRL_OUT[6] A44_CDAC_CAP_BANK_ASSEMBLY_R8_M6_0/A44_CAP_CORE128_M6_R1_0/CAP_BOTTOM_098 GND nfet_03v3 ad=0 pd=0 as=0 ps=0 w=1.56u l=0.28u
X4209 VREFN A44_DCTRL_STRIP_W_R2_0/CTRL_OUT[6] A44_CDAC_CAP_BANK_ASSEMBLY_R8_M6_0/A44_CAP_CORE128_M6_R1_0/CAP_BOTTOM_098 GND nfet_03v3 ad=0 pd=0 as=0 ps=0 w=1.56u l=0.28u
X4210 VREFN A44_DCTRL_STRIP_W_R2_0/CTRL_OUT[6] A44_CDAC_CAP_BANK_ASSEMBLY_R8_M6_0/A44_CAP_CORE128_M6_R1_0/CAP_BOTTOM_098 GND nfet_03v3 ad=0 pd=0 as=0 ps=0 w=1.56u l=0.28u
X4211 VREFN A44_DCTRL_STRIP_W_R2_0/CTRL_OUT[6] A44_CDAC_CAP_BANK_ASSEMBLY_R8_M6_0/A44_CAP_CORE128_M6_R1_0/CAP_BOTTOM_098 GND nfet_03v3 ad=0 pd=0 as=0 ps=0 w=1.56u l=0.28u
X4212 VREFN A44_DCTRL_STRIP_W_R2_0/CTRL_OUT[6] A44_CDAC_CAP_BANK_ASSEMBLY_R8_M6_0/A44_CAP_CORE128_M6_R1_0/CAP_BOTTOM_098 GND nfet_03v3 ad=0 pd=0 as=0 ps=0 w=1.56u l=0.28u
X4213 VREFN A44_DCTRL_STRIP_W_R2_0/CTRL_OUT[6] A44_CDAC_CAP_BANK_ASSEMBLY_R8_M6_0/A44_CAP_CORE128_M6_R1_0/CAP_BOTTOM_098 GND nfet_03v3 ad=0 pd=0 as=0 ps=0 w=1.56u l=0.28u
X4214 VREFP A44_DCTRL_STRIP_W_R2_0/CTRL_OUT[7] A44_CDAC_CAP_BANK_ASSEMBLY_R8_M6_0/A44_CAP_CORE128_M6_R1_0/CAP_BOTTOM_124 VDD pfet_03v3 ad=0 pd=0 as=16.6842p ps=77.76u w=1.56u l=0.28u
X4215 VREFP A44_DCTRL_STRIP_W_R2_0/CTRL_OUT[7] A44_CDAC_CAP_BANK_ASSEMBLY_R8_M6_0/A44_CAP_CORE128_M6_R1_0/CAP_BOTTOM_124 VDD pfet_03v3 ad=0 pd=0 as=0 ps=0 w=1.56u l=0.28u
X4216 VREFP A44_DCTRL_STRIP_W_R2_0/CTRL_OUT[7] A44_CDAC_CAP_BANK_ASSEMBLY_R8_M6_0/A44_CAP_CORE128_M6_R1_0/CAP_BOTTOM_124 VDD pfet_03v3 ad=0 pd=0 as=0 ps=0 w=1.56u l=0.28u
X4217 VREFP A44_DCTRL_STRIP_W_R2_0/CTRL_OUT[7] A44_CDAC_CAP_BANK_ASSEMBLY_R8_M6_0/A44_CAP_CORE128_M6_R1_0/CAP_BOTTOM_124 VDD pfet_03v3 ad=0 pd=0 as=0 ps=0 w=1.56u l=0.28u
X4218 VREFP A44_DCTRL_STRIP_W_R2_0/CTRL_OUT[7] A44_CDAC_CAP_BANK_ASSEMBLY_R8_M6_0/A44_CAP_CORE128_M6_R1_0/CAP_BOTTOM_124 VDD pfet_03v3 ad=0 pd=0 as=0 ps=0 w=1.56u l=0.28u
X4219 VREFP A44_DCTRL_STRIP_W_R2_0/CTRL_OUT[7] A44_CDAC_CAP_BANK_ASSEMBLY_R8_M6_0/A44_CAP_CORE128_M6_R1_0/CAP_BOTTOM_124 VDD pfet_03v3 ad=0 pd=0 as=0 ps=0 w=1.56u l=0.28u
X4220 VREFP A44_DCTRL_STRIP_W_R2_0/CTRL_OUT[7] A44_CDAC_CAP_BANK_ASSEMBLY_R8_M6_0/A44_CAP_CORE128_M6_R1_0/CAP_BOTTOM_124 VDD pfet_03v3 ad=0 pd=0 as=0 ps=0 w=1.56u l=0.28u
X4221 VREFP A44_DCTRL_STRIP_W_R2_0/CTRL_OUT[7] A44_CDAC_CAP_BANK_ASSEMBLY_R8_M6_0/A44_CAP_CORE128_M6_R1_0/CAP_BOTTOM_124 VDD pfet_03v3 ad=0 pd=0 as=0 ps=0 w=1.56u l=0.28u
X4222 VREFP A44_DCTRL_STRIP_W_R2_0/CTRL_OUT[7] A44_CDAC_CAP_BANK_ASSEMBLY_R8_M6_0/A44_CAP_CORE128_M6_R1_0/CAP_BOTTOM_124 VDD pfet_03v3 ad=0 pd=0 as=0 ps=0 w=1.56u l=0.28u
X4223 VREFP A44_DCTRL_STRIP_W_R2_0/CTRL_OUT[7] A44_CDAC_CAP_BANK_ASSEMBLY_R8_M6_0/A44_CAP_CORE128_M6_R1_0/CAP_BOTTOM_124 VDD pfet_03v3 ad=0 pd=0 as=0 ps=0 w=1.56u l=0.28u
X4224 VREFP A44_DCTRL_STRIP_W_R2_0/CTRL_OUT[7] A44_CDAC_CAP_BANK_ASSEMBLY_R8_M6_0/A44_CAP_CORE128_M6_R1_0/CAP_BOTTOM_124 VDD pfet_03v3 ad=0 pd=0 as=0 ps=0 w=1.56u l=0.28u
X4225 VREFP A44_DCTRL_STRIP_W_R2_0/CTRL_OUT[7] A44_CDAC_CAP_BANK_ASSEMBLY_R8_M6_0/A44_CAP_CORE128_M6_R1_0/CAP_BOTTOM_124 VDD pfet_03v3 ad=0 pd=0 as=0 ps=0 w=1.56u l=0.28u
X4226 VREFP A44_DCTRL_STRIP_W_R2_0/CTRL_OUT[7] A44_CDAC_CAP_BANK_ASSEMBLY_R8_M6_0/A44_CAP_CORE128_M6_R1_0/CAP_BOTTOM_124 VDD pfet_03v3 ad=0 pd=0 as=0 ps=0 w=1.56u l=0.28u
X4227 VREFP A44_DCTRL_STRIP_W_R2_0/CTRL_OUT[7] A44_CDAC_CAP_BANK_ASSEMBLY_R8_M6_0/A44_CAP_CORE128_M6_R1_0/CAP_BOTTOM_124 VDD pfet_03v3 ad=0 pd=0 as=0 ps=0 w=1.56u l=0.28u
X4228 VREFP A44_DCTRL_STRIP_W_R2_0/CTRL_OUT[7] A44_CDAC_CAP_BANK_ASSEMBLY_R8_M6_0/A44_CAP_CORE128_M6_R1_0/CAP_BOTTOM_124 VDD pfet_03v3 ad=0 pd=0 as=0 ps=0 w=1.56u l=0.28u
X4229 VREFP A44_DCTRL_STRIP_W_R2_0/CTRL_OUT[7] A44_CDAC_CAP_BANK_ASSEMBLY_R8_M6_0/A44_CAP_CORE128_M6_R1_0/CAP_BOTTOM_124 VDD pfet_03v3 ad=0 pd=0 as=0 ps=0 w=1.56u l=0.28u
X4230 VREFP A44_DCTRL_STRIP_W_R2_0/CTRL_OUT[7] A44_CDAC_CAP_BANK_ASSEMBLY_R8_M6_0/A44_CAP_CORE128_M6_R1_0/CAP_BOTTOM_124 VDD pfet_03v3 ad=0 pd=0 as=0 ps=0 w=1.56u l=0.28u
X4231 VREFP A44_DCTRL_STRIP_W_R2_0/CTRL_OUT[7] A44_CDAC_CAP_BANK_ASSEMBLY_R8_M6_0/A44_CAP_CORE128_M6_R1_0/CAP_BOTTOM_124 VDD pfet_03v3 ad=0 pd=0 as=0 ps=0 w=1.56u l=0.28u
X4232 VREFN A44_DCTRL_STRIP_W_R2_0/CTRL_OUT[7] A44_CDAC_CAP_BANK_ASSEMBLY_R8_M6_0/A44_CAP_CORE128_M6_R1_0/CAP_BOTTOM_124 GND nfet_03v3 ad=0 pd=0 as=16.6842p ps=77.76u w=1.56u l=0.28u
X4233 VREFN A44_DCTRL_STRIP_W_R2_0/CTRL_OUT[7] A44_CDAC_CAP_BANK_ASSEMBLY_R8_M6_0/A44_CAP_CORE128_M6_R1_0/CAP_BOTTOM_124 GND nfet_03v3 ad=0 pd=0 as=0 ps=0 w=1.56u l=0.28u
X4234 VREFN A44_DCTRL_STRIP_W_R2_0/CTRL_OUT[7] A44_CDAC_CAP_BANK_ASSEMBLY_R8_M6_0/A44_CAP_CORE128_M6_R1_0/CAP_BOTTOM_124 GND nfet_03v3 ad=0 pd=0 as=0 ps=0 w=1.56u l=0.28u
X4235 VREFN A44_DCTRL_STRIP_W_R2_0/CTRL_OUT[7] A44_CDAC_CAP_BANK_ASSEMBLY_R8_M6_0/A44_CAP_CORE128_M6_R1_0/CAP_BOTTOM_124 GND nfet_03v3 ad=0 pd=0 as=0 ps=0 w=1.56u l=0.28u
X4236 VREFN A44_DCTRL_STRIP_W_R2_0/CTRL_OUT[7] A44_CDAC_CAP_BANK_ASSEMBLY_R8_M6_0/A44_CAP_CORE128_M6_R1_0/CAP_BOTTOM_124 GND nfet_03v3 ad=0 pd=0 as=0 ps=0 w=1.56u l=0.28u
X4237 VREFN A44_DCTRL_STRIP_W_R2_0/CTRL_OUT[7] A44_CDAC_CAP_BANK_ASSEMBLY_R8_M6_0/A44_CAP_CORE128_M6_R1_0/CAP_BOTTOM_124 GND nfet_03v3 ad=0 pd=0 as=0 ps=0 w=1.56u l=0.28u
X4238 VREFN A44_DCTRL_STRIP_W_R2_0/CTRL_OUT[7] A44_CDAC_CAP_BANK_ASSEMBLY_R8_M6_0/A44_CAP_CORE128_M6_R1_0/CAP_BOTTOM_124 GND nfet_03v3 ad=0 pd=0 as=0 ps=0 w=1.56u l=0.28u
X4239 VREFN A44_DCTRL_STRIP_W_R2_0/CTRL_OUT[7] A44_CDAC_CAP_BANK_ASSEMBLY_R8_M6_0/A44_CAP_CORE128_M6_R1_0/CAP_BOTTOM_124 GND nfet_03v3 ad=0 pd=0 as=0 ps=0 w=1.56u l=0.28u
X4240 VREFN A44_DCTRL_STRIP_W_R2_0/CTRL_OUT[7] A44_CDAC_CAP_BANK_ASSEMBLY_R8_M6_0/A44_CAP_CORE128_M6_R1_0/CAP_BOTTOM_124 GND nfet_03v3 ad=0 pd=0 as=0 ps=0 w=1.56u l=0.28u
X4241 VREFN A44_DCTRL_STRIP_W_R2_0/CTRL_OUT[7] A44_CDAC_CAP_BANK_ASSEMBLY_R8_M6_0/A44_CAP_CORE128_M6_R1_0/CAP_BOTTOM_124 GND nfet_03v3 ad=0 pd=0 as=0 ps=0 w=1.56u l=0.28u
X4242 VREFN A44_DCTRL_STRIP_W_R2_0/CTRL_OUT[7] A44_CDAC_CAP_BANK_ASSEMBLY_R8_M6_0/A44_CAP_CORE128_M6_R1_0/CAP_BOTTOM_124 GND nfet_03v3 ad=0 pd=0 as=0 ps=0 w=1.56u l=0.28u
X4243 VREFN A44_DCTRL_STRIP_W_R2_0/CTRL_OUT[7] A44_CDAC_CAP_BANK_ASSEMBLY_R8_M6_0/A44_CAP_CORE128_M6_R1_0/CAP_BOTTOM_124 GND nfet_03v3 ad=0 pd=0 as=0 ps=0 w=1.56u l=0.28u
X4244 VREFN A44_DCTRL_STRIP_W_R2_0/CTRL_OUT[7] A44_CDAC_CAP_BANK_ASSEMBLY_R8_M6_0/A44_CAP_CORE128_M6_R1_0/CAP_BOTTOM_124 GND nfet_03v3 ad=0 pd=0 as=0 ps=0 w=1.56u l=0.28u
X4245 VREFN A44_DCTRL_STRIP_W_R2_0/CTRL_OUT[7] A44_CDAC_CAP_BANK_ASSEMBLY_R8_M6_0/A44_CAP_CORE128_M6_R1_0/CAP_BOTTOM_124 GND nfet_03v3 ad=0 pd=0 as=0 ps=0 w=1.56u l=0.28u
X4246 VREFN A44_DCTRL_STRIP_W_R2_0/CTRL_OUT[7] A44_CDAC_CAP_BANK_ASSEMBLY_R8_M6_0/A44_CAP_CORE128_M6_R1_0/CAP_BOTTOM_124 GND nfet_03v3 ad=0 pd=0 as=0 ps=0 w=1.56u l=0.28u
X4247 VREFN A44_DCTRL_STRIP_W_R2_0/CTRL_OUT[7] A44_CDAC_CAP_BANK_ASSEMBLY_R8_M6_0/A44_CAP_CORE128_M6_R1_0/CAP_BOTTOM_124 GND nfet_03v3 ad=0 pd=0 as=0 ps=0 w=1.56u l=0.28u
X4248 VREFN A44_DCTRL_STRIP_W_R2_0/CTRL_OUT[7] A44_CDAC_CAP_BANK_ASSEMBLY_R8_M6_0/A44_CAP_CORE128_M6_R1_0/CAP_BOTTOM_124 GND nfet_03v3 ad=0 pd=0 as=0 ps=0 w=1.56u l=0.28u
X4249 VREFN A44_DCTRL_STRIP_W_R2_0/CTRL_OUT[7] A44_CDAC_CAP_BANK_ASSEMBLY_R8_M6_0/A44_CAP_CORE128_M6_R1_0/CAP_BOTTOM_124 GND nfet_03v3 ad=0 pd=0 as=0 ps=0 w=1.56u l=0.28u
X4250 VREFP A44_DCTRL_STRIP_W_R2_0/CTRL_OUT[7] A44_CDAC_CAP_BANK_ASSEMBLY_R8_M6_0/A44_CAP_CORE128_M6_R1_0/CAP_BOTTOM_122 VDD pfet_03v3 ad=0 pd=0 as=16.6842p ps=77.76u w=1.56u l=0.28u
X4251 VREFP A44_DCTRL_STRIP_W_R2_0/CTRL_OUT[7] A44_CDAC_CAP_BANK_ASSEMBLY_R8_M6_0/A44_CAP_CORE128_M6_R1_0/CAP_BOTTOM_122 VDD pfet_03v3 ad=0 pd=0 as=0 ps=0 w=1.56u l=0.28u
X4252 VREFP A44_DCTRL_STRIP_W_R2_0/CTRL_OUT[7] A44_CDAC_CAP_BANK_ASSEMBLY_R8_M6_0/A44_CAP_CORE128_M6_R1_0/CAP_BOTTOM_122 VDD pfet_03v3 ad=0 pd=0 as=0 ps=0 w=1.56u l=0.28u
X4253 VREFP A44_DCTRL_STRIP_W_R2_0/CTRL_OUT[7] A44_CDAC_CAP_BANK_ASSEMBLY_R8_M6_0/A44_CAP_CORE128_M6_R1_0/CAP_BOTTOM_122 VDD pfet_03v3 ad=0 pd=0 as=0 ps=0 w=1.56u l=0.28u
X4254 VREFP A44_DCTRL_STRIP_W_R2_0/CTRL_OUT[7] A44_CDAC_CAP_BANK_ASSEMBLY_R8_M6_0/A44_CAP_CORE128_M6_R1_0/CAP_BOTTOM_122 VDD pfet_03v3 ad=0 pd=0 as=0 ps=0 w=1.56u l=0.28u
X4255 VREFP A44_DCTRL_STRIP_W_R2_0/CTRL_OUT[7] A44_CDAC_CAP_BANK_ASSEMBLY_R8_M6_0/A44_CAP_CORE128_M6_R1_0/CAP_BOTTOM_122 VDD pfet_03v3 ad=0 pd=0 as=0 ps=0 w=1.56u l=0.28u
X4256 VREFP A44_DCTRL_STRIP_W_R2_0/CTRL_OUT[7] A44_CDAC_CAP_BANK_ASSEMBLY_R8_M6_0/A44_CAP_CORE128_M6_R1_0/CAP_BOTTOM_122 VDD pfet_03v3 ad=0 pd=0 as=0 ps=0 w=1.56u l=0.28u
X4257 VREFP A44_DCTRL_STRIP_W_R2_0/CTRL_OUT[7] A44_CDAC_CAP_BANK_ASSEMBLY_R8_M6_0/A44_CAP_CORE128_M6_R1_0/CAP_BOTTOM_122 VDD pfet_03v3 ad=0 pd=0 as=0 ps=0 w=1.56u l=0.28u
X4258 VREFP A44_DCTRL_STRIP_W_R2_0/CTRL_OUT[7] A44_CDAC_CAP_BANK_ASSEMBLY_R8_M6_0/A44_CAP_CORE128_M6_R1_0/CAP_BOTTOM_122 VDD pfet_03v3 ad=0 pd=0 as=0 ps=0 w=1.56u l=0.28u
X4259 VREFP A44_DCTRL_STRIP_W_R2_0/CTRL_OUT[7] A44_CDAC_CAP_BANK_ASSEMBLY_R8_M6_0/A44_CAP_CORE128_M6_R1_0/CAP_BOTTOM_122 VDD pfet_03v3 ad=0 pd=0 as=0 ps=0 w=1.56u l=0.28u
X4260 VREFP A44_DCTRL_STRIP_W_R2_0/CTRL_OUT[7] A44_CDAC_CAP_BANK_ASSEMBLY_R8_M6_0/A44_CAP_CORE128_M6_R1_0/CAP_BOTTOM_122 VDD pfet_03v3 ad=0 pd=0 as=0 ps=0 w=1.56u l=0.28u
X4261 VREFP A44_DCTRL_STRIP_W_R2_0/CTRL_OUT[7] A44_CDAC_CAP_BANK_ASSEMBLY_R8_M6_0/A44_CAP_CORE128_M6_R1_0/CAP_BOTTOM_122 VDD pfet_03v3 ad=0 pd=0 as=0 ps=0 w=1.56u l=0.28u
X4262 VREFP A44_DCTRL_STRIP_W_R2_0/CTRL_OUT[7] A44_CDAC_CAP_BANK_ASSEMBLY_R8_M6_0/A44_CAP_CORE128_M6_R1_0/CAP_BOTTOM_122 VDD pfet_03v3 ad=0 pd=0 as=0 ps=0 w=1.56u l=0.28u
X4263 VREFP A44_DCTRL_STRIP_W_R2_0/CTRL_OUT[7] A44_CDAC_CAP_BANK_ASSEMBLY_R8_M6_0/A44_CAP_CORE128_M6_R1_0/CAP_BOTTOM_122 VDD pfet_03v3 ad=0 pd=0 as=0 ps=0 w=1.56u l=0.28u
X4264 VREFP A44_DCTRL_STRIP_W_R2_0/CTRL_OUT[7] A44_CDAC_CAP_BANK_ASSEMBLY_R8_M6_0/A44_CAP_CORE128_M6_R1_0/CAP_BOTTOM_122 VDD pfet_03v3 ad=0 pd=0 as=0 ps=0 w=1.56u l=0.28u
X4265 VREFP A44_DCTRL_STRIP_W_R2_0/CTRL_OUT[7] A44_CDAC_CAP_BANK_ASSEMBLY_R8_M6_0/A44_CAP_CORE128_M6_R1_0/CAP_BOTTOM_122 VDD pfet_03v3 ad=0 pd=0 as=0 ps=0 w=1.56u l=0.28u
X4266 VREFP A44_DCTRL_STRIP_W_R2_0/CTRL_OUT[7] A44_CDAC_CAP_BANK_ASSEMBLY_R8_M6_0/A44_CAP_CORE128_M6_R1_0/CAP_BOTTOM_122 VDD pfet_03v3 ad=0 pd=0 as=0 ps=0 w=1.56u l=0.28u
X4267 VREFP A44_DCTRL_STRIP_W_R2_0/CTRL_OUT[7] A44_CDAC_CAP_BANK_ASSEMBLY_R8_M6_0/A44_CAP_CORE128_M6_R1_0/CAP_BOTTOM_122 VDD pfet_03v3 ad=0 pd=0 as=0 ps=0 w=1.56u l=0.28u
X4268 VREFN A44_DCTRL_STRIP_W_R2_0/CTRL_OUT[7] A44_CDAC_CAP_BANK_ASSEMBLY_R8_M6_0/A44_CAP_CORE128_M6_R1_0/CAP_BOTTOM_122 GND nfet_03v3 ad=0 pd=0 as=16.6842p ps=77.76u w=1.56u l=0.28u
X4269 VREFN A44_DCTRL_STRIP_W_R2_0/CTRL_OUT[7] A44_CDAC_CAP_BANK_ASSEMBLY_R8_M6_0/A44_CAP_CORE128_M6_R1_0/CAP_BOTTOM_122 GND nfet_03v3 ad=0 pd=0 as=0 ps=0 w=1.56u l=0.28u
X4270 VREFN A44_DCTRL_STRIP_W_R2_0/CTRL_OUT[7] A44_CDAC_CAP_BANK_ASSEMBLY_R8_M6_0/A44_CAP_CORE128_M6_R1_0/CAP_BOTTOM_122 GND nfet_03v3 ad=0 pd=0 as=0 ps=0 w=1.56u l=0.28u
X4271 VREFN A44_DCTRL_STRIP_W_R2_0/CTRL_OUT[7] A44_CDAC_CAP_BANK_ASSEMBLY_R8_M6_0/A44_CAP_CORE128_M6_R1_0/CAP_BOTTOM_122 GND nfet_03v3 ad=0 pd=0 as=0 ps=0 w=1.56u l=0.28u
X4272 VREFN A44_DCTRL_STRIP_W_R2_0/CTRL_OUT[7] A44_CDAC_CAP_BANK_ASSEMBLY_R8_M6_0/A44_CAP_CORE128_M6_R1_0/CAP_BOTTOM_122 GND nfet_03v3 ad=0 pd=0 as=0 ps=0 w=1.56u l=0.28u
X4273 VREFN A44_DCTRL_STRIP_W_R2_0/CTRL_OUT[7] A44_CDAC_CAP_BANK_ASSEMBLY_R8_M6_0/A44_CAP_CORE128_M6_R1_0/CAP_BOTTOM_122 GND nfet_03v3 ad=0 pd=0 as=0 ps=0 w=1.56u l=0.28u
X4274 VREFN A44_DCTRL_STRIP_W_R2_0/CTRL_OUT[7] A44_CDAC_CAP_BANK_ASSEMBLY_R8_M6_0/A44_CAP_CORE128_M6_R1_0/CAP_BOTTOM_122 GND nfet_03v3 ad=0 pd=0 as=0 ps=0 w=1.56u l=0.28u
X4275 VREFN A44_DCTRL_STRIP_W_R2_0/CTRL_OUT[7] A44_CDAC_CAP_BANK_ASSEMBLY_R8_M6_0/A44_CAP_CORE128_M6_R1_0/CAP_BOTTOM_122 GND nfet_03v3 ad=0 pd=0 as=0 ps=0 w=1.56u l=0.28u
X4276 VREFN A44_DCTRL_STRIP_W_R2_0/CTRL_OUT[7] A44_CDAC_CAP_BANK_ASSEMBLY_R8_M6_0/A44_CAP_CORE128_M6_R1_0/CAP_BOTTOM_122 GND nfet_03v3 ad=0 pd=0 as=0 ps=0 w=1.56u l=0.28u
X4277 VREFN A44_DCTRL_STRIP_W_R2_0/CTRL_OUT[7] A44_CDAC_CAP_BANK_ASSEMBLY_R8_M6_0/A44_CAP_CORE128_M6_R1_0/CAP_BOTTOM_122 GND nfet_03v3 ad=0 pd=0 as=0 ps=0 w=1.56u l=0.28u
X4278 VREFN A44_DCTRL_STRIP_W_R2_0/CTRL_OUT[7] A44_CDAC_CAP_BANK_ASSEMBLY_R8_M6_0/A44_CAP_CORE128_M6_R1_0/CAP_BOTTOM_122 GND nfet_03v3 ad=0 pd=0 as=0 ps=0 w=1.56u l=0.28u
X4279 VREFN A44_DCTRL_STRIP_W_R2_0/CTRL_OUT[7] A44_CDAC_CAP_BANK_ASSEMBLY_R8_M6_0/A44_CAP_CORE128_M6_R1_0/CAP_BOTTOM_122 GND nfet_03v3 ad=0 pd=0 as=0 ps=0 w=1.56u l=0.28u
X4280 VREFN A44_DCTRL_STRIP_W_R2_0/CTRL_OUT[7] A44_CDAC_CAP_BANK_ASSEMBLY_R8_M6_0/A44_CAP_CORE128_M6_R1_0/CAP_BOTTOM_122 GND nfet_03v3 ad=0 pd=0 as=0 ps=0 w=1.56u l=0.28u
X4281 VREFN A44_DCTRL_STRIP_W_R2_0/CTRL_OUT[7] A44_CDAC_CAP_BANK_ASSEMBLY_R8_M6_0/A44_CAP_CORE128_M6_R1_0/CAP_BOTTOM_122 GND nfet_03v3 ad=0 pd=0 as=0 ps=0 w=1.56u l=0.28u
X4282 VREFN A44_DCTRL_STRIP_W_R2_0/CTRL_OUT[7] A44_CDAC_CAP_BANK_ASSEMBLY_R8_M6_0/A44_CAP_CORE128_M6_R1_0/CAP_BOTTOM_122 GND nfet_03v3 ad=0 pd=0 as=0 ps=0 w=1.56u l=0.28u
X4283 VREFN A44_DCTRL_STRIP_W_R2_0/CTRL_OUT[7] A44_CDAC_CAP_BANK_ASSEMBLY_R8_M6_0/A44_CAP_CORE128_M6_R1_0/CAP_BOTTOM_122 GND nfet_03v3 ad=0 pd=0 as=0 ps=0 w=1.56u l=0.28u
X4284 VREFN A44_DCTRL_STRIP_W_R2_0/CTRL_OUT[7] A44_CDAC_CAP_BANK_ASSEMBLY_R8_M6_0/A44_CAP_CORE128_M6_R1_0/CAP_BOTTOM_122 GND nfet_03v3 ad=0 pd=0 as=0 ps=0 w=1.56u l=0.28u
X4285 VREFN A44_DCTRL_STRIP_W_R2_0/CTRL_OUT[7] A44_CDAC_CAP_BANK_ASSEMBLY_R8_M6_0/A44_CAP_CORE128_M6_R1_0/CAP_BOTTOM_122 GND nfet_03v3 ad=0 pd=0 as=0 ps=0 w=1.56u l=0.28u
X4286 VREFP A44_DCTRL_STRIP_W_R2_0/CTRL_OUT[3] A44_CDAC_CAP_BANK_ASSEMBLY_R8_M6_0/A44_CAP_CORE128_M6_R1_0/CAP_BOTTOM_082 VDD pfet_03v3 ad=0 pd=0 as=16.6842p ps=77.76u w=1.56u l=0.28u
X4287 VREFP A44_DCTRL_STRIP_W_R2_0/CTRL_OUT[3] A44_CDAC_CAP_BANK_ASSEMBLY_R8_M6_0/A44_CAP_CORE128_M6_R1_0/CAP_BOTTOM_082 VDD pfet_03v3 ad=0 pd=0 as=0 ps=0 w=1.56u l=0.28u
X4288 VREFP A44_DCTRL_STRIP_W_R2_0/CTRL_OUT[3] A44_CDAC_CAP_BANK_ASSEMBLY_R8_M6_0/A44_CAP_CORE128_M6_R1_0/CAP_BOTTOM_082 VDD pfet_03v3 ad=0 pd=0 as=0 ps=0 w=1.56u l=0.28u
X4289 VREFP A44_DCTRL_STRIP_W_R2_0/CTRL_OUT[3] A44_CDAC_CAP_BANK_ASSEMBLY_R8_M6_0/A44_CAP_CORE128_M6_R1_0/CAP_BOTTOM_082 VDD pfet_03v3 ad=0 pd=0 as=0 ps=0 w=1.56u l=0.28u
X4290 VREFP A44_DCTRL_STRIP_W_R2_0/CTRL_OUT[3] A44_CDAC_CAP_BANK_ASSEMBLY_R8_M6_0/A44_CAP_CORE128_M6_R1_0/CAP_BOTTOM_082 VDD pfet_03v3 ad=0 pd=0 as=0 ps=0 w=1.56u l=0.28u
X4291 VREFP A44_DCTRL_STRIP_W_R2_0/CTRL_OUT[3] A44_CDAC_CAP_BANK_ASSEMBLY_R8_M6_0/A44_CAP_CORE128_M6_R1_0/CAP_BOTTOM_082 VDD pfet_03v3 ad=0 pd=0 as=0 ps=0 w=1.56u l=0.28u
X4292 VREFP A44_DCTRL_STRIP_W_R2_0/CTRL_OUT[3] A44_CDAC_CAP_BANK_ASSEMBLY_R8_M6_0/A44_CAP_CORE128_M6_R1_0/CAP_BOTTOM_082 VDD pfet_03v3 ad=0 pd=0 as=0 ps=0 w=1.56u l=0.28u
X4293 VREFP A44_DCTRL_STRIP_W_R2_0/CTRL_OUT[3] A44_CDAC_CAP_BANK_ASSEMBLY_R8_M6_0/A44_CAP_CORE128_M6_R1_0/CAP_BOTTOM_082 VDD pfet_03v3 ad=0 pd=0 as=0 ps=0 w=1.56u l=0.28u
X4294 VREFP A44_DCTRL_STRIP_W_R2_0/CTRL_OUT[3] A44_CDAC_CAP_BANK_ASSEMBLY_R8_M6_0/A44_CAP_CORE128_M6_R1_0/CAP_BOTTOM_082 VDD pfet_03v3 ad=0 pd=0 as=0 ps=0 w=1.56u l=0.28u
X4295 VREFP A44_DCTRL_STRIP_W_R2_0/CTRL_OUT[3] A44_CDAC_CAP_BANK_ASSEMBLY_R8_M6_0/A44_CAP_CORE128_M6_R1_0/CAP_BOTTOM_082 VDD pfet_03v3 ad=0 pd=0 as=0 ps=0 w=1.56u l=0.28u
X4296 VREFP A44_DCTRL_STRIP_W_R2_0/CTRL_OUT[3] A44_CDAC_CAP_BANK_ASSEMBLY_R8_M6_0/A44_CAP_CORE128_M6_R1_0/CAP_BOTTOM_082 VDD pfet_03v3 ad=0 pd=0 as=0 ps=0 w=1.56u l=0.28u
X4297 VREFP A44_DCTRL_STRIP_W_R2_0/CTRL_OUT[3] A44_CDAC_CAP_BANK_ASSEMBLY_R8_M6_0/A44_CAP_CORE128_M6_R1_0/CAP_BOTTOM_082 VDD pfet_03v3 ad=0 pd=0 as=0 ps=0 w=1.56u l=0.28u
X4298 VREFP A44_DCTRL_STRIP_W_R2_0/CTRL_OUT[3] A44_CDAC_CAP_BANK_ASSEMBLY_R8_M6_0/A44_CAP_CORE128_M6_R1_0/CAP_BOTTOM_082 VDD pfet_03v3 ad=0 pd=0 as=0 ps=0 w=1.56u l=0.28u
X4299 VREFP A44_DCTRL_STRIP_W_R2_0/CTRL_OUT[3] A44_CDAC_CAP_BANK_ASSEMBLY_R8_M6_0/A44_CAP_CORE128_M6_R1_0/CAP_BOTTOM_082 VDD pfet_03v3 ad=0 pd=0 as=0 ps=0 w=1.56u l=0.28u
X4300 VREFP A44_DCTRL_STRIP_W_R2_0/CTRL_OUT[3] A44_CDAC_CAP_BANK_ASSEMBLY_R8_M6_0/A44_CAP_CORE128_M6_R1_0/CAP_BOTTOM_082 VDD pfet_03v3 ad=0 pd=0 as=0 ps=0 w=1.56u l=0.28u
X4301 VREFP A44_DCTRL_STRIP_W_R2_0/CTRL_OUT[3] A44_CDAC_CAP_BANK_ASSEMBLY_R8_M6_0/A44_CAP_CORE128_M6_R1_0/CAP_BOTTOM_082 VDD pfet_03v3 ad=0 pd=0 as=0 ps=0 w=1.56u l=0.28u
X4302 VREFP A44_DCTRL_STRIP_W_R2_0/CTRL_OUT[3] A44_CDAC_CAP_BANK_ASSEMBLY_R8_M6_0/A44_CAP_CORE128_M6_R1_0/CAP_BOTTOM_082 VDD pfet_03v3 ad=0 pd=0 as=0 ps=0 w=1.56u l=0.28u
X4303 VREFP A44_DCTRL_STRIP_W_R2_0/CTRL_OUT[3] A44_CDAC_CAP_BANK_ASSEMBLY_R8_M6_0/A44_CAP_CORE128_M6_R1_0/CAP_BOTTOM_082 VDD pfet_03v3 ad=0 pd=0 as=0 ps=0 w=1.56u l=0.28u
X4304 VREFN A44_DCTRL_STRIP_W_R2_0/CTRL_OUT[3] A44_CDAC_CAP_BANK_ASSEMBLY_R8_M6_0/A44_CAP_CORE128_M6_R1_0/CAP_BOTTOM_082 GND nfet_03v3 ad=0 pd=0 as=16.6842p ps=77.76u w=1.56u l=0.28u
X4305 VREFN A44_DCTRL_STRIP_W_R2_0/CTRL_OUT[3] A44_CDAC_CAP_BANK_ASSEMBLY_R8_M6_0/A44_CAP_CORE128_M6_R1_0/CAP_BOTTOM_082 GND nfet_03v3 ad=0 pd=0 as=0 ps=0 w=1.56u l=0.28u
X4306 VREFN A44_DCTRL_STRIP_W_R2_0/CTRL_OUT[3] A44_CDAC_CAP_BANK_ASSEMBLY_R8_M6_0/A44_CAP_CORE128_M6_R1_0/CAP_BOTTOM_082 GND nfet_03v3 ad=0 pd=0 as=0 ps=0 w=1.56u l=0.28u
X4307 VREFN A44_DCTRL_STRIP_W_R2_0/CTRL_OUT[3] A44_CDAC_CAP_BANK_ASSEMBLY_R8_M6_0/A44_CAP_CORE128_M6_R1_0/CAP_BOTTOM_082 GND nfet_03v3 ad=0 pd=0 as=0 ps=0 w=1.56u l=0.28u
X4308 VREFN A44_DCTRL_STRIP_W_R2_0/CTRL_OUT[3] A44_CDAC_CAP_BANK_ASSEMBLY_R8_M6_0/A44_CAP_CORE128_M6_R1_0/CAP_BOTTOM_082 GND nfet_03v3 ad=0 pd=0 as=0 ps=0 w=1.56u l=0.28u
X4309 VREFN A44_DCTRL_STRIP_W_R2_0/CTRL_OUT[3] A44_CDAC_CAP_BANK_ASSEMBLY_R8_M6_0/A44_CAP_CORE128_M6_R1_0/CAP_BOTTOM_082 GND nfet_03v3 ad=0 pd=0 as=0 ps=0 w=1.56u l=0.28u
X4310 VREFN A44_DCTRL_STRIP_W_R2_0/CTRL_OUT[3] A44_CDAC_CAP_BANK_ASSEMBLY_R8_M6_0/A44_CAP_CORE128_M6_R1_0/CAP_BOTTOM_082 GND nfet_03v3 ad=0 pd=0 as=0 ps=0 w=1.56u l=0.28u
X4311 VREFN A44_DCTRL_STRIP_W_R2_0/CTRL_OUT[3] A44_CDAC_CAP_BANK_ASSEMBLY_R8_M6_0/A44_CAP_CORE128_M6_R1_0/CAP_BOTTOM_082 GND nfet_03v3 ad=0 pd=0 as=0 ps=0 w=1.56u l=0.28u
X4312 VREFN A44_DCTRL_STRIP_W_R2_0/CTRL_OUT[3] A44_CDAC_CAP_BANK_ASSEMBLY_R8_M6_0/A44_CAP_CORE128_M6_R1_0/CAP_BOTTOM_082 GND nfet_03v3 ad=0 pd=0 as=0 ps=0 w=1.56u l=0.28u
X4313 VREFN A44_DCTRL_STRIP_W_R2_0/CTRL_OUT[3] A44_CDAC_CAP_BANK_ASSEMBLY_R8_M6_0/A44_CAP_CORE128_M6_R1_0/CAP_BOTTOM_082 GND nfet_03v3 ad=0 pd=0 as=0 ps=0 w=1.56u l=0.28u
X4314 VREFN A44_DCTRL_STRIP_W_R2_0/CTRL_OUT[3] A44_CDAC_CAP_BANK_ASSEMBLY_R8_M6_0/A44_CAP_CORE128_M6_R1_0/CAP_BOTTOM_082 GND nfet_03v3 ad=0 pd=0 as=0 ps=0 w=1.56u l=0.28u
X4315 VREFN A44_DCTRL_STRIP_W_R2_0/CTRL_OUT[3] A44_CDAC_CAP_BANK_ASSEMBLY_R8_M6_0/A44_CAP_CORE128_M6_R1_0/CAP_BOTTOM_082 GND nfet_03v3 ad=0 pd=0 as=0 ps=0 w=1.56u l=0.28u
X4316 VREFN A44_DCTRL_STRIP_W_R2_0/CTRL_OUT[3] A44_CDAC_CAP_BANK_ASSEMBLY_R8_M6_0/A44_CAP_CORE128_M6_R1_0/CAP_BOTTOM_082 GND nfet_03v3 ad=0 pd=0 as=0 ps=0 w=1.56u l=0.28u
X4317 VREFN A44_DCTRL_STRIP_W_R2_0/CTRL_OUT[3] A44_CDAC_CAP_BANK_ASSEMBLY_R8_M6_0/A44_CAP_CORE128_M6_R1_0/CAP_BOTTOM_082 GND nfet_03v3 ad=0 pd=0 as=0 ps=0 w=1.56u l=0.28u
X4318 VREFN A44_DCTRL_STRIP_W_R2_0/CTRL_OUT[3] A44_CDAC_CAP_BANK_ASSEMBLY_R8_M6_0/A44_CAP_CORE128_M6_R1_0/CAP_BOTTOM_082 GND nfet_03v3 ad=0 pd=0 as=0 ps=0 w=1.56u l=0.28u
X4319 VREFN A44_DCTRL_STRIP_W_R2_0/CTRL_OUT[3] A44_CDAC_CAP_BANK_ASSEMBLY_R8_M6_0/A44_CAP_CORE128_M6_R1_0/CAP_BOTTOM_082 GND nfet_03v3 ad=0 pd=0 as=0 ps=0 w=1.56u l=0.28u
X4320 VREFN A44_DCTRL_STRIP_W_R2_0/CTRL_OUT[3] A44_CDAC_CAP_BANK_ASSEMBLY_R8_M6_0/A44_CAP_CORE128_M6_R1_0/CAP_BOTTOM_082 GND nfet_03v3 ad=0 pd=0 as=0 ps=0 w=1.56u l=0.28u
X4321 VREFN A44_DCTRL_STRIP_W_R2_0/CTRL_OUT[3] A44_CDAC_CAP_BANK_ASSEMBLY_R8_M6_0/A44_CAP_CORE128_M6_R1_0/CAP_BOTTOM_082 GND nfet_03v3 ad=0 pd=0 as=0 ps=0 w=1.56u l=0.28u
X4322 VREFP A44_DCTRL_STRIP_W_R2_0/CTRL_OUT[7] A44_CDAC_CAP_BANK_ASSEMBLY_R8_M6_0/A44_CAP_CORE128_M6_R1_0/CAP_BOTTOM_072 VDD pfet_03v3 ad=0 pd=0 as=16.6842p ps=77.76u w=1.56u l=0.28u
X4323 VREFP A44_DCTRL_STRIP_W_R2_0/CTRL_OUT[7] A44_CDAC_CAP_BANK_ASSEMBLY_R8_M6_0/A44_CAP_CORE128_M6_R1_0/CAP_BOTTOM_072 VDD pfet_03v3 ad=0 pd=0 as=0 ps=0 w=1.56u l=0.28u
X4324 VREFP A44_DCTRL_STRIP_W_R2_0/CTRL_OUT[7] A44_CDAC_CAP_BANK_ASSEMBLY_R8_M6_0/A44_CAP_CORE128_M6_R1_0/CAP_BOTTOM_072 VDD pfet_03v3 ad=0 pd=0 as=0 ps=0 w=1.56u l=0.28u
X4325 VREFP A44_DCTRL_STRIP_W_R2_0/CTRL_OUT[7] A44_CDAC_CAP_BANK_ASSEMBLY_R8_M6_0/A44_CAP_CORE128_M6_R1_0/CAP_BOTTOM_072 VDD pfet_03v3 ad=0 pd=0 as=0 ps=0 w=1.56u l=0.28u
X4326 VREFP A44_DCTRL_STRIP_W_R2_0/CTRL_OUT[7] A44_CDAC_CAP_BANK_ASSEMBLY_R8_M6_0/A44_CAP_CORE128_M6_R1_0/CAP_BOTTOM_072 VDD pfet_03v3 ad=0 pd=0 as=0 ps=0 w=1.56u l=0.28u
X4327 VREFP A44_DCTRL_STRIP_W_R2_0/CTRL_OUT[7] A44_CDAC_CAP_BANK_ASSEMBLY_R8_M6_0/A44_CAP_CORE128_M6_R1_0/CAP_BOTTOM_072 VDD pfet_03v3 ad=0 pd=0 as=0 ps=0 w=1.56u l=0.28u
X4328 VREFP A44_DCTRL_STRIP_W_R2_0/CTRL_OUT[7] A44_CDAC_CAP_BANK_ASSEMBLY_R8_M6_0/A44_CAP_CORE128_M6_R1_0/CAP_BOTTOM_072 VDD pfet_03v3 ad=0 pd=0 as=0 ps=0 w=1.56u l=0.28u
X4329 VREFP A44_DCTRL_STRIP_W_R2_0/CTRL_OUT[7] A44_CDAC_CAP_BANK_ASSEMBLY_R8_M6_0/A44_CAP_CORE128_M6_R1_0/CAP_BOTTOM_072 VDD pfet_03v3 ad=0 pd=0 as=0 ps=0 w=1.56u l=0.28u
X4330 VREFP A44_DCTRL_STRIP_W_R2_0/CTRL_OUT[7] A44_CDAC_CAP_BANK_ASSEMBLY_R8_M6_0/A44_CAP_CORE128_M6_R1_0/CAP_BOTTOM_072 VDD pfet_03v3 ad=0 pd=0 as=0 ps=0 w=1.56u l=0.28u
X4331 VREFP A44_DCTRL_STRIP_W_R2_0/CTRL_OUT[7] A44_CDAC_CAP_BANK_ASSEMBLY_R8_M6_0/A44_CAP_CORE128_M6_R1_0/CAP_BOTTOM_072 VDD pfet_03v3 ad=0 pd=0 as=0 ps=0 w=1.56u l=0.28u
X4332 VREFP A44_DCTRL_STRIP_W_R2_0/CTRL_OUT[7] A44_CDAC_CAP_BANK_ASSEMBLY_R8_M6_0/A44_CAP_CORE128_M6_R1_0/CAP_BOTTOM_072 VDD pfet_03v3 ad=0 pd=0 as=0 ps=0 w=1.56u l=0.28u
X4333 VREFP A44_DCTRL_STRIP_W_R2_0/CTRL_OUT[7] A44_CDAC_CAP_BANK_ASSEMBLY_R8_M6_0/A44_CAP_CORE128_M6_R1_0/CAP_BOTTOM_072 VDD pfet_03v3 ad=0 pd=0 as=0 ps=0 w=1.56u l=0.28u
X4334 VREFP A44_DCTRL_STRIP_W_R2_0/CTRL_OUT[7] A44_CDAC_CAP_BANK_ASSEMBLY_R8_M6_0/A44_CAP_CORE128_M6_R1_0/CAP_BOTTOM_072 VDD pfet_03v3 ad=0 pd=0 as=0 ps=0 w=1.56u l=0.28u
X4335 VREFP A44_DCTRL_STRIP_W_R2_0/CTRL_OUT[7] A44_CDAC_CAP_BANK_ASSEMBLY_R8_M6_0/A44_CAP_CORE128_M6_R1_0/CAP_BOTTOM_072 VDD pfet_03v3 ad=0 pd=0 as=0 ps=0 w=1.56u l=0.28u
X4336 VREFP A44_DCTRL_STRIP_W_R2_0/CTRL_OUT[7] A44_CDAC_CAP_BANK_ASSEMBLY_R8_M6_0/A44_CAP_CORE128_M6_R1_0/CAP_BOTTOM_072 VDD pfet_03v3 ad=0 pd=0 as=0 ps=0 w=1.56u l=0.28u
X4337 VREFP A44_DCTRL_STRIP_W_R2_0/CTRL_OUT[7] A44_CDAC_CAP_BANK_ASSEMBLY_R8_M6_0/A44_CAP_CORE128_M6_R1_0/CAP_BOTTOM_072 VDD pfet_03v3 ad=0 pd=0 as=0 ps=0 w=1.56u l=0.28u
X4338 VREFP A44_DCTRL_STRIP_W_R2_0/CTRL_OUT[7] A44_CDAC_CAP_BANK_ASSEMBLY_R8_M6_0/A44_CAP_CORE128_M6_R1_0/CAP_BOTTOM_072 VDD pfet_03v3 ad=0 pd=0 as=0 ps=0 w=1.56u l=0.28u
X4339 VREFP A44_DCTRL_STRIP_W_R2_0/CTRL_OUT[7] A44_CDAC_CAP_BANK_ASSEMBLY_R8_M6_0/A44_CAP_CORE128_M6_R1_0/CAP_BOTTOM_072 VDD pfet_03v3 ad=0 pd=0 as=0 ps=0 w=1.56u l=0.28u
X4340 VREFN A44_DCTRL_STRIP_W_R2_0/CTRL_OUT[7] A44_CDAC_CAP_BANK_ASSEMBLY_R8_M6_0/A44_CAP_CORE128_M6_R1_0/CAP_BOTTOM_072 GND nfet_03v3 ad=0 pd=0 as=16.6842p ps=77.76u w=1.56u l=0.28u
X4341 VREFN A44_DCTRL_STRIP_W_R2_0/CTRL_OUT[7] A44_CDAC_CAP_BANK_ASSEMBLY_R8_M6_0/A44_CAP_CORE128_M6_R1_0/CAP_BOTTOM_072 GND nfet_03v3 ad=0 pd=0 as=0 ps=0 w=1.56u l=0.28u
X4342 VREFN A44_DCTRL_STRIP_W_R2_0/CTRL_OUT[7] A44_CDAC_CAP_BANK_ASSEMBLY_R8_M6_0/A44_CAP_CORE128_M6_R1_0/CAP_BOTTOM_072 GND nfet_03v3 ad=0 pd=0 as=0 ps=0 w=1.56u l=0.28u
X4343 VREFN A44_DCTRL_STRIP_W_R2_0/CTRL_OUT[7] A44_CDAC_CAP_BANK_ASSEMBLY_R8_M6_0/A44_CAP_CORE128_M6_R1_0/CAP_BOTTOM_072 GND nfet_03v3 ad=0 pd=0 as=0 ps=0 w=1.56u l=0.28u
X4344 VREFN A44_DCTRL_STRIP_W_R2_0/CTRL_OUT[7] A44_CDAC_CAP_BANK_ASSEMBLY_R8_M6_0/A44_CAP_CORE128_M6_R1_0/CAP_BOTTOM_072 GND nfet_03v3 ad=0 pd=0 as=0 ps=0 w=1.56u l=0.28u
X4345 VREFN A44_DCTRL_STRIP_W_R2_0/CTRL_OUT[7] A44_CDAC_CAP_BANK_ASSEMBLY_R8_M6_0/A44_CAP_CORE128_M6_R1_0/CAP_BOTTOM_072 GND nfet_03v3 ad=0 pd=0 as=0 ps=0 w=1.56u l=0.28u
X4346 VREFN A44_DCTRL_STRIP_W_R2_0/CTRL_OUT[7] A44_CDAC_CAP_BANK_ASSEMBLY_R8_M6_0/A44_CAP_CORE128_M6_R1_0/CAP_BOTTOM_072 GND nfet_03v3 ad=0 pd=0 as=0 ps=0 w=1.56u l=0.28u
X4347 VREFN A44_DCTRL_STRIP_W_R2_0/CTRL_OUT[7] A44_CDAC_CAP_BANK_ASSEMBLY_R8_M6_0/A44_CAP_CORE128_M6_R1_0/CAP_BOTTOM_072 GND nfet_03v3 ad=0 pd=0 as=0 ps=0 w=1.56u l=0.28u
X4348 VREFN A44_DCTRL_STRIP_W_R2_0/CTRL_OUT[7] A44_CDAC_CAP_BANK_ASSEMBLY_R8_M6_0/A44_CAP_CORE128_M6_R1_0/CAP_BOTTOM_072 GND nfet_03v3 ad=0 pd=0 as=0 ps=0 w=1.56u l=0.28u
X4349 VREFN A44_DCTRL_STRIP_W_R2_0/CTRL_OUT[7] A44_CDAC_CAP_BANK_ASSEMBLY_R8_M6_0/A44_CAP_CORE128_M6_R1_0/CAP_BOTTOM_072 GND nfet_03v3 ad=0 pd=0 as=0 ps=0 w=1.56u l=0.28u
X4350 VREFN A44_DCTRL_STRIP_W_R2_0/CTRL_OUT[7] A44_CDAC_CAP_BANK_ASSEMBLY_R8_M6_0/A44_CAP_CORE128_M6_R1_0/CAP_BOTTOM_072 GND nfet_03v3 ad=0 pd=0 as=0 ps=0 w=1.56u l=0.28u
X4351 VREFN A44_DCTRL_STRIP_W_R2_0/CTRL_OUT[7] A44_CDAC_CAP_BANK_ASSEMBLY_R8_M6_0/A44_CAP_CORE128_M6_R1_0/CAP_BOTTOM_072 GND nfet_03v3 ad=0 pd=0 as=0 ps=0 w=1.56u l=0.28u
X4352 VREFN A44_DCTRL_STRIP_W_R2_0/CTRL_OUT[7] A44_CDAC_CAP_BANK_ASSEMBLY_R8_M6_0/A44_CAP_CORE128_M6_R1_0/CAP_BOTTOM_072 GND nfet_03v3 ad=0 pd=0 as=0 ps=0 w=1.56u l=0.28u
X4353 VREFN A44_DCTRL_STRIP_W_R2_0/CTRL_OUT[7] A44_CDAC_CAP_BANK_ASSEMBLY_R8_M6_0/A44_CAP_CORE128_M6_R1_0/CAP_BOTTOM_072 GND nfet_03v3 ad=0 pd=0 as=0 ps=0 w=1.56u l=0.28u
X4354 VREFN A44_DCTRL_STRIP_W_R2_0/CTRL_OUT[7] A44_CDAC_CAP_BANK_ASSEMBLY_R8_M6_0/A44_CAP_CORE128_M6_R1_0/CAP_BOTTOM_072 GND nfet_03v3 ad=0 pd=0 as=0 ps=0 w=1.56u l=0.28u
X4355 VREFN A44_DCTRL_STRIP_W_R2_0/CTRL_OUT[7] A44_CDAC_CAP_BANK_ASSEMBLY_R8_M6_0/A44_CAP_CORE128_M6_R1_0/CAP_BOTTOM_072 GND nfet_03v3 ad=0 pd=0 as=0 ps=0 w=1.56u l=0.28u
X4356 VREFN A44_DCTRL_STRIP_W_R2_0/CTRL_OUT[7] A44_CDAC_CAP_BANK_ASSEMBLY_R8_M6_0/A44_CAP_CORE128_M6_R1_0/CAP_BOTTOM_072 GND nfet_03v3 ad=0 pd=0 as=0 ps=0 w=1.56u l=0.28u
X4357 VREFN A44_DCTRL_STRIP_W_R2_0/CTRL_OUT[7] A44_CDAC_CAP_BANK_ASSEMBLY_R8_M6_0/A44_CAP_CORE128_M6_R1_0/CAP_BOTTOM_072 GND nfet_03v3 ad=0 pd=0 as=0 ps=0 w=1.56u l=0.28u
X4358 VREFP A44_DCTRL_STRIP_W_R2_0/CTRL_OUT[6] A44_CDAC_CAP_BANK_ASSEMBLY_R8_M6_0/A44_CAP_CORE128_M6_R1_0/CAP_BOTTOM_070 VDD pfet_03v3 ad=0 pd=0 as=16.6842p ps=77.76u w=1.56u l=0.28u
X4359 VREFP A44_DCTRL_STRIP_W_R2_0/CTRL_OUT[6] A44_CDAC_CAP_BANK_ASSEMBLY_R8_M6_0/A44_CAP_CORE128_M6_R1_0/CAP_BOTTOM_070 VDD pfet_03v3 ad=0 pd=0 as=0 ps=0 w=1.56u l=0.28u
X4360 VREFP A44_DCTRL_STRIP_W_R2_0/CTRL_OUT[6] A44_CDAC_CAP_BANK_ASSEMBLY_R8_M6_0/A44_CAP_CORE128_M6_R1_0/CAP_BOTTOM_070 VDD pfet_03v3 ad=0 pd=0 as=0 ps=0 w=1.56u l=0.28u
X4361 VREFP A44_DCTRL_STRIP_W_R2_0/CTRL_OUT[6] A44_CDAC_CAP_BANK_ASSEMBLY_R8_M6_0/A44_CAP_CORE128_M6_R1_0/CAP_BOTTOM_070 VDD pfet_03v3 ad=0 pd=0 as=0 ps=0 w=1.56u l=0.28u
X4362 VREFP A44_DCTRL_STRIP_W_R2_0/CTRL_OUT[6] A44_CDAC_CAP_BANK_ASSEMBLY_R8_M6_0/A44_CAP_CORE128_M6_R1_0/CAP_BOTTOM_070 VDD pfet_03v3 ad=0 pd=0 as=0 ps=0 w=1.56u l=0.28u
X4363 VREFP A44_DCTRL_STRIP_W_R2_0/CTRL_OUT[6] A44_CDAC_CAP_BANK_ASSEMBLY_R8_M6_0/A44_CAP_CORE128_M6_R1_0/CAP_BOTTOM_070 VDD pfet_03v3 ad=0 pd=0 as=0 ps=0 w=1.56u l=0.28u
X4364 VREFP A44_DCTRL_STRIP_W_R2_0/CTRL_OUT[6] A44_CDAC_CAP_BANK_ASSEMBLY_R8_M6_0/A44_CAP_CORE128_M6_R1_0/CAP_BOTTOM_070 VDD pfet_03v3 ad=0 pd=0 as=0 ps=0 w=1.56u l=0.28u
X4365 VREFP A44_DCTRL_STRIP_W_R2_0/CTRL_OUT[6] A44_CDAC_CAP_BANK_ASSEMBLY_R8_M6_0/A44_CAP_CORE128_M6_R1_0/CAP_BOTTOM_070 VDD pfet_03v3 ad=0 pd=0 as=0 ps=0 w=1.56u l=0.28u
X4366 VREFP A44_DCTRL_STRIP_W_R2_0/CTRL_OUT[6] A44_CDAC_CAP_BANK_ASSEMBLY_R8_M6_0/A44_CAP_CORE128_M6_R1_0/CAP_BOTTOM_070 VDD pfet_03v3 ad=0 pd=0 as=0 ps=0 w=1.56u l=0.28u
X4367 VREFP A44_DCTRL_STRIP_W_R2_0/CTRL_OUT[6] A44_CDAC_CAP_BANK_ASSEMBLY_R8_M6_0/A44_CAP_CORE128_M6_R1_0/CAP_BOTTOM_070 VDD pfet_03v3 ad=0 pd=0 as=0 ps=0 w=1.56u l=0.28u
X4368 VREFP A44_DCTRL_STRIP_W_R2_0/CTRL_OUT[6] A44_CDAC_CAP_BANK_ASSEMBLY_R8_M6_0/A44_CAP_CORE128_M6_R1_0/CAP_BOTTOM_070 VDD pfet_03v3 ad=0 pd=0 as=0 ps=0 w=1.56u l=0.28u
X4369 VREFP A44_DCTRL_STRIP_W_R2_0/CTRL_OUT[6] A44_CDAC_CAP_BANK_ASSEMBLY_R8_M6_0/A44_CAP_CORE128_M6_R1_0/CAP_BOTTOM_070 VDD pfet_03v3 ad=0 pd=0 as=0 ps=0 w=1.56u l=0.28u
X4370 VREFP A44_DCTRL_STRIP_W_R2_0/CTRL_OUT[6] A44_CDAC_CAP_BANK_ASSEMBLY_R8_M6_0/A44_CAP_CORE128_M6_R1_0/CAP_BOTTOM_070 VDD pfet_03v3 ad=0 pd=0 as=0 ps=0 w=1.56u l=0.28u
X4371 VREFP A44_DCTRL_STRIP_W_R2_0/CTRL_OUT[6] A44_CDAC_CAP_BANK_ASSEMBLY_R8_M6_0/A44_CAP_CORE128_M6_R1_0/CAP_BOTTOM_070 VDD pfet_03v3 ad=0 pd=0 as=0 ps=0 w=1.56u l=0.28u
X4372 VREFP A44_DCTRL_STRIP_W_R2_0/CTRL_OUT[6] A44_CDAC_CAP_BANK_ASSEMBLY_R8_M6_0/A44_CAP_CORE128_M6_R1_0/CAP_BOTTOM_070 VDD pfet_03v3 ad=0 pd=0 as=0 ps=0 w=1.56u l=0.28u
X4373 VREFP A44_DCTRL_STRIP_W_R2_0/CTRL_OUT[6] A44_CDAC_CAP_BANK_ASSEMBLY_R8_M6_0/A44_CAP_CORE128_M6_R1_0/CAP_BOTTOM_070 VDD pfet_03v3 ad=0 pd=0 as=0 ps=0 w=1.56u l=0.28u
X4374 VREFP A44_DCTRL_STRIP_W_R2_0/CTRL_OUT[6] A44_CDAC_CAP_BANK_ASSEMBLY_R8_M6_0/A44_CAP_CORE128_M6_R1_0/CAP_BOTTOM_070 VDD pfet_03v3 ad=0 pd=0 as=0 ps=0 w=1.56u l=0.28u
X4375 VREFP A44_DCTRL_STRIP_W_R2_0/CTRL_OUT[6] A44_CDAC_CAP_BANK_ASSEMBLY_R8_M6_0/A44_CAP_CORE128_M6_R1_0/CAP_BOTTOM_070 VDD pfet_03v3 ad=0 pd=0 as=0 ps=0 w=1.56u l=0.28u
X4376 VREFN A44_DCTRL_STRIP_W_R2_0/CTRL_OUT[6] A44_CDAC_CAP_BANK_ASSEMBLY_R8_M6_0/A44_CAP_CORE128_M6_R1_0/CAP_BOTTOM_070 GND nfet_03v3 ad=0 pd=0 as=16.6842p ps=77.76u w=1.56u l=0.28u
X4377 VREFN A44_DCTRL_STRIP_W_R2_0/CTRL_OUT[6] A44_CDAC_CAP_BANK_ASSEMBLY_R8_M6_0/A44_CAP_CORE128_M6_R1_0/CAP_BOTTOM_070 GND nfet_03v3 ad=0 pd=0 as=0 ps=0 w=1.56u l=0.28u
X4378 VREFN A44_DCTRL_STRIP_W_R2_0/CTRL_OUT[6] A44_CDAC_CAP_BANK_ASSEMBLY_R8_M6_0/A44_CAP_CORE128_M6_R1_0/CAP_BOTTOM_070 GND nfet_03v3 ad=0 pd=0 as=0 ps=0 w=1.56u l=0.28u
X4379 VREFN A44_DCTRL_STRIP_W_R2_0/CTRL_OUT[6] A44_CDAC_CAP_BANK_ASSEMBLY_R8_M6_0/A44_CAP_CORE128_M6_R1_0/CAP_BOTTOM_070 GND nfet_03v3 ad=0 pd=0 as=0 ps=0 w=1.56u l=0.28u
X4380 VREFN A44_DCTRL_STRIP_W_R2_0/CTRL_OUT[6] A44_CDAC_CAP_BANK_ASSEMBLY_R8_M6_0/A44_CAP_CORE128_M6_R1_0/CAP_BOTTOM_070 GND nfet_03v3 ad=0 pd=0 as=0 ps=0 w=1.56u l=0.28u
X4381 VREFN A44_DCTRL_STRIP_W_R2_0/CTRL_OUT[6] A44_CDAC_CAP_BANK_ASSEMBLY_R8_M6_0/A44_CAP_CORE128_M6_R1_0/CAP_BOTTOM_070 GND nfet_03v3 ad=0 pd=0 as=0 ps=0 w=1.56u l=0.28u
X4382 VREFN A44_DCTRL_STRIP_W_R2_0/CTRL_OUT[6] A44_CDAC_CAP_BANK_ASSEMBLY_R8_M6_0/A44_CAP_CORE128_M6_R1_0/CAP_BOTTOM_070 GND nfet_03v3 ad=0 pd=0 as=0 ps=0 w=1.56u l=0.28u
X4383 VREFN A44_DCTRL_STRIP_W_R2_0/CTRL_OUT[6] A44_CDAC_CAP_BANK_ASSEMBLY_R8_M6_0/A44_CAP_CORE128_M6_R1_0/CAP_BOTTOM_070 GND nfet_03v3 ad=0 pd=0 as=0 ps=0 w=1.56u l=0.28u
X4384 VREFN A44_DCTRL_STRIP_W_R2_0/CTRL_OUT[6] A44_CDAC_CAP_BANK_ASSEMBLY_R8_M6_0/A44_CAP_CORE128_M6_R1_0/CAP_BOTTOM_070 GND nfet_03v3 ad=0 pd=0 as=0 ps=0 w=1.56u l=0.28u
X4385 VREFN A44_DCTRL_STRIP_W_R2_0/CTRL_OUT[6] A44_CDAC_CAP_BANK_ASSEMBLY_R8_M6_0/A44_CAP_CORE128_M6_R1_0/CAP_BOTTOM_070 GND nfet_03v3 ad=0 pd=0 as=0 ps=0 w=1.56u l=0.28u
X4386 VREFN A44_DCTRL_STRIP_W_R2_0/CTRL_OUT[6] A44_CDAC_CAP_BANK_ASSEMBLY_R8_M6_0/A44_CAP_CORE128_M6_R1_0/CAP_BOTTOM_070 GND nfet_03v3 ad=0 pd=0 as=0 ps=0 w=1.56u l=0.28u
X4387 VREFN A44_DCTRL_STRIP_W_R2_0/CTRL_OUT[6] A44_CDAC_CAP_BANK_ASSEMBLY_R8_M6_0/A44_CAP_CORE128_M6_R1_0/CAP_BOTTOM_070 GND nfet_03v3 ad=0 pd=0 as=0 ps=0 w=1.56u l=0.28u
X4388 VREFN A44_DCTRL_STRIP_W_R2_0/CTRL_OUT[6] A44_CDAC_CAP_BANK_ASSEMBLY_R8_M6_0/A44_CAP_CORE128_M6_R1_0/CAP_BOTTOM_070 GND nfet_03v3 ad=0 pd=0 as=0 ps=0 w=1.56u l=0.28u
X4389 VREFN A44_DCTRL_STRIP_W_R2_0/CTRL_OUT[6] A44_CDAC_CAP_BANK_ASSEMBLY_R8_M6_0/A44_CAP_CORE128_M6_R1_0/CAP_BOTTOM_070 GND nfet_03v3 ad=0 pd=0 as=0 ps=0 w=1.56u l=0.28u
X4390 VREFN A44_DCTRL_STRIP_W_R2_0/CTRL_OUT[6] A44_CDAC_CAP_BANK_ASSEMBLY_R8_M6_0/A44_CAP_CORE128_M6_R1_0/CAP_BOTTOM_070 GND nfet_03v3 ad=0 pd=0 as=0 ps=0 w=1.56u l=0.28u
X4391 VREFN A44_DCTRL_STRIP_W_R2_0/CTRL_OUT[6] A44_CDAC_CAP_BANK_ASSEMBLY_R8_M6_0/A44_CAP_CORE128_M6_R1_0/CAP_BOTTOM_070 GND nfet_03v3 ad=0 pd=0 as=0 ps=0 w=1.56u l=0.28u
X4392 VREFN A44_DCTRL_STRIP_W_R2_0/CTRL_OUT[6] A44_CDAC_CAP_BANK_ASSEMBLY_R8_M6_0/A44_CAP_CORE128_M6_R1_0/CAP_BOTTOM_070 GND nfet_03v3 ad=0 pd=0 as=0 ps=0 w=1.56u l=0.28u
X4393 VREFN A44_DCTRL_STRIP_W_R2_0/CTRL_OUT[6] A44_CDAC_CAP_BANK_ASSEMBLY_R8_M6_0/A44_CAP_CORE128_M6_R1_0/CAP_BOTTOM_070 GND nfet_03v3 ad=0 pd=0 as=0 ps=0 w=1.56u l=0.28u
X4394 VREFP A44_DCTRL_STRIP_W_R2_0/CTRL_OUT[6] A44_CDAC_CAP_BANK_ASSEMBLY_R8_M6_0/A44_CAP_CORE128_M6_R1_0/CAP_BOTTOM_119 VDD pfet_03v3 ad=0 pd=0 as=16.6842p ps=77.76u w=1.56u l=0.28u
X4395 VREFP A44_DCTRL_STRIP_W_R2_0/CTRL_OUT[6] A44_CDAC_CAP_BANK_ASSEMBLY_R8_M6_0/A44_CAP_CORE128_M6_R1_0/CAP_BOTTOM_119 VDD pfet_03v3 ad=0 pd=0 as=0 ps=0 w=1.56u l=0.28u
X4396 VREFP A44_DCTRL_STRIP_W_R2_0/CTRL_OUT[6] A44_CDAC_CAP_BANK_ASSEMBLY_R8_M6_0/A44_CAP_CORE128_M6_R1_0/CAP_BOTTOM_119 VDD pfet_03v3 ad=0 pd=0 as=0 ps=0 w=1.56u l=0.28u
X4397 VREFP A44_DCTRL_STRIP_W_R2_0/CTRL_OUT[6] A44_CDAC_CAP_BANK_ASSEMBLY_R8_M6_0/A44_CAP_CORE128_M6_R1_0/CAP_BOTTOM_119 VDD pfet_03v3 ad=0 pd=0 as=0 ps=0 w=1.56u l=0.28u
X4398 VREFP A44_DCTRL_STRIP_W_R2_0/CTRL_OUT[6] A44_CDAC_CAP_BANK_ASSEMBLY_R8_M6_0/A44_CAP_CORE128_M6_R1_0/CAP_BOTTOM_119 VDD pfet_03v3 ad=0 pd=0 as=0 ps=0 w=1.56u l=0.28u
X4399 VREFP A44_DCTRL_STRIP_W_R2_0/CTRL_OUT[6] A44_CDAC_CAP_BANK_ASSEMBLY_R8_M6_0/A44_CAP_CORE128_M6_R1_0/CAP_BOTTOM_119 VDD pfet_03v3 ad=0 pd=0 as=0 ps=0 w=1.56u l=0.28u
X4400 VREFP A44_DCTRL_STRIP_W_R2_0/CTRL_OUT[6] A44_CDAC_CAP_BANK_ASSEMBLY_R8_M6_0/A44_CAP_CORE128_M6_R1_0/CAP_BOTTOM_119 VDD pfet_03v3 ad=0 pd=0 as=0 ps=0 w=1.56u l=0.28u
X4401 VREFP A44_DCTRL_STRIP_W_R2_0/CTRL_OUT[6] A44_CDAC_CAP_BANK_ASSEMBLY_R8_M6_0/A44_CAP_CORE128_M6_R1_0/CAP_BOTTOM_119 VDD pfet_03v3 ad=0 pd=0 as=0 ps=0 w=1.56u l=0.28u
X4402 VREFP A44_DCTRL_STRIP_W_R2_0/CTRL_OUT[6] A44_CDAC_CAP_BANK_ASSEMBLY_R8_M6_0/A44_CAP_CORE128_M6_R1_0/CAP_BOTTOM_119 VDD pfet_03v3 ad=0 pd=0 as=0 ps=0 w=1.56u l=0.28u
X4403 VREFP A44_DCTRL_STRIP_W_R2_0/CTRL_OUT[6] A44_CDAC_CAP_BANK_ASSEMBLY_R8_M6_0/A44_CAP_CORE128_M6_R1_0/CAP_BOTTOM_119 VDD pfet_03v3 ad=0 pd=0 as=0 ps=0 w=1.56u l=0.28u
X4404 VREFP A44_DCTRL_STRIP_W_R2_0/CTRL_OUT[6] A44_CDAC_CAP_BANK_ASSEMBLY_R8_M6_0/A44_CAP_CORE128_M6_R1_0/CAP_BOTTOM_119 VDD pfet_03v3 ad=0 pd=0 as=0 ps=0 w=1.56u l=0.28u
X4405 VREFP A44_DCTRL_STRIP_W_R2_0/CTRL_OUT[6] A44_CDAC_CAP_BANK_ASSEMBLY_R8_M6_0/A44_CAP_CORE128_M6_R1_0/CAP_BOTTOM_119 VDD pfet_03v3 ad=0 pd=0 as=0 ps=0 w=1.56u l=0.28u
X4406 VREFP A44_DCTRL_STRIP_W_R2_0/CTRL_OUT[6] A44_CDAC_CAP_BANK_ASSEMBLY_R8_M6_0/A44_CAP_CORE128_M6_R1_0/CAP_BOTTOM_119 VDD pfet_03v3 ad=0 pd=0 as=0 ps=0 w=1.56u l=0.28u
X4407 VREFP A44_DCTRL_STRIP_W_R2_0/CTRL_OUT[6] A44_CDAC_CAP_BANK_ASSEMBLY_R8_M6_0/A44_CAP_CORE128_M6_R1_0/CAP_BOTTOM_119 VDD pfet_03v3 ad=0 pd=0 as=0 ps=0 w=1.56u l=0.28u
X4408 VREFP A44_DCTRL_STRIP_W_R2_0/CTRL_OUT[6] A44_CDAC_CAP_BANK_ASSEMBLY_R8_M6_0/A44_CAP_CORE128_M6_R1_0/CAP_BOTTOM_119 VDD pfet_03v3 ad=0 pd=0 as=0 ps=0 w=1.56u l=0.28u
X4409 VREFP A44_DCTRL_STRIP_W_R2_0/CTRL_OUT[6] A44_CDAC_CAP_BANK_ASSEMBLY_R8_M6_0/A44_CAP_CORE128_M6_R1_0/CAP_BOTTOM_119 VDD pfet_03v3 ad=0 pd=0 as=0 ps=0 w=1.56u l=0.28u
X4410 VREFP A44_DCTRL_STRIP_W_R2_0/CTRL_OUT[6] A44_CDAC_CAP_BANK_ASSEMBLY_R8_M6_0/A44_CAP_CORE128_M6_R1_0/CAP_BOTTOM_119 VDD pfet_03v3 ad=0 pd=0 as=0 ps=0 w=1.56u l=0.28u
X4411 VREFP A44_DCTRL_STRIP_W_R2_0/CTRL_OUT[6] A44_CDAC_CAP_BANK_ASSEMBLY_R8_M6_0/A44_CAP_CORE128_M6_R1_0/CAP_BOTTOM_119 VDD pfet_03v3 ad=0 pd=0 as=0 ps=0 w=1.56u l=0.28u
X4412 VREFN A44_DCTRL_STRIP_W_R2_0/CTRL_OUT[6] A44_CDAC_CAP_BANK_ASSEMBLY_R8_M6_0/A44_CAP_CORE128_M6_R1_0/CAP_BOTTOM_119 GND nfet_03v3 ad=0 pd=0 as=16.6842p ps=77.76u w=1.56u l=0.28u
X4413 VREFN A44_DCTRL_STRIP_W_R2_0/CTRL_OUT[6] A44_CDAC_CAP_BANK_ASSEMBLY_R8_M6_0/A44_CAP_CORE128_M6_R1_0/CAP_BOTTOM_119 GND nfet_03v3 ad=0 pd=0 as=0 ps=0 w=1.56u l=0.28u
X4414 VREFN A44_DCTRL_STRIP_W_R2_0/CTRL_OUT[6] A44_CDAC_CAP_BANK_ASSEMBLY_R8_M6_0/A44_CAP_CORE128_M6_R1_0/CAP_BOTTOM_119 GND nfet_03v3 ad=0 pd=0 as=0 ps=0 w=1.56u l=0.28u
X4415 VREFN A44_DCTRL_STRIP_W_R2_0/CTRL_OUT[6] A44_CDAC_CAP_BANK_ASSEMBLY_R8_M6_0/A44_CAP_CORE128_M6_R1_0/CAP_BOTTOM_119 GND nfet_03v3 ad=0 pd=0 as=0 ps=0 w=1.56u l=0.28u
X4416 VREFN A44_DCTRL_STRIP_W_R2_0/CTRL_OUT[6] A44_CDAC_CAP_BANK_ASSEMBLY_R8_M6_0/A44_CAP_CORE128_M6_R1_0/CAP_BOTTOM_119 GND nfet_03v3 ad=0 pd=0 as=0 ps=0 w=1.56u l=0.28u
X4417 VREFN A44_DCTRL_STRIP_W_R2_0/CTRL_OUT[6] A44_CDAC_CAP_BANK_ASSEMBLY_R8_M6_0/A44_CAP_CORE128_M6_R1_0/CAP_BOTTOM_119 GND nfet_03v3 ad=0 pd=0 as=0 ps=0 w=1.56u l=0.28u
X4418 VREFN A44_DCTRL_STRIP_W_R2_0/CTRL_OUT[6] A44_CDAC_CAP_BANK_ASSEMBLY_R8_M6_0/A44_CAP_CORE128_M6_R1_0/CAP_BOTTOM_119 GND nfet_03v3 ad=0 pd=0 as=0 ps=0 w=1.56u l=0.28u
X4419 VREFN A44_DCTRL_STRIP_W_R2_0/CTRL_OUT[6] A44_CDAC_CAP_BANK_ASSEMBLY_R8_M6_0/A44_CAP_CORE128_M6_R1_0/CAP_BOTTOM_119 GND nfet_03v3 ad=0 pd=0 as=0 ps=0 w=1.56u l=0.28u
X4420 VREFN A44_DCTRL_STRIP_W_R2_0/CTRL_OUT[6] A44_CDAC_CAP_BANK_ASSEMBLY_R8_M6_0/A44_CAP_CORE128_M6_R1_0/CAP_BOTTOM_119 GND nfet_03v3 ad=0 pd=0 as=0 ps=0 w=1.56u l=0.28u
X4421 VREFN A44_DCTRL_STRIP_W_R2_0/CTRL_OUT[6] A44_CDAC_CAP_BANK_ASSEMBLY_R8_M6_0/A44_CAP_CORE128_M6_R1_0/CAP_BOTTOM_119 GND nfet_03v3 ad=0 pd=0 as=0 ps=0 w=1.56u l=0.28u
X4422 VREFN A44_DCTRL_STRIP_W_R2_0/CTRL_OUT[6] A44_CDAC_CAP_BANK_ASSEMBLY_R8_M6_0/A44_CAP_CORE128_M6_R1_0/CAP_BOTTOM_119 GND nfet_03v3 ad=0 pd=0 as=0 ps=0 w=1.56u l=0.28u
X4423 VREFN A44_DCTRL_STRIP_W_R2_0/CTRL_OUT[6] A44_CDAC_CAP_BANK_ASSEMBLY_R8_M6_0/A44_CAP_CORE128_M6_R1_0/CAP_BOTTOM_119 GND nfet_03v3 ad=0 pd=0 as=0 ps=0 w=1.56u l=0.28u
X4424 VREFN A44_DCTRL_STRIP_W_R2_0/CTRL_OUT[6] A44_CDAC_CAP_BANK_ASSEMBLY_R8_M6_0/A44_CAP_CORE128_M6_R1_0/CAP_BOTTOM_119 GND nfet_03v3 ad=0 pd=0 as=0 ps=0 w=1.56u l=0.28u
X4425 VREFN A44_DCTRL_STRIP_W_R2_0/CTRL_OUT[6] A44_CDAC_CAP_BANK_ASSEMBLY_R8_M6_0/A44_CAP_CORE128_M6_R1_0/CAP_BOTTOM_119 GND nfet_03v3 ad=0 pd=0 as=0 ps=0 w=1.56u l=0.28u
X4426 VREFN A44_DCTRL_STRIP_W_R2_0/CTRL_OUT[6] A44_CDAC_CAP_BANK_ASSEMBLY_R8_M6_0/A44_CAP_CORE128_M6_R1_0/CAP_BOTTOM_119 GND nfet_03v3 ad=0 pd=0 as=0 ps=0 w=1.56u l=0.28u
X4427 VREFN A44_DCTRL_STRIP_W_R2_0/CTRL_OUT[6] A44_CDAC_CAP_BANK_ASSEMBLY_R8_M6_0/A44_CAP_CORE128_M6_R1_0/CAP_BOTTOM_119 GND nfet_03v3 ad=0 pd=0 as=0 ps=0 w=1.56u l=0.28u
X4428 VREFN A44_DCTRL_STRIP_W_R2_0/CTRL_OUT[6] A44_CDAC_CAP_BANK_ASSEMBLY_R8_M6_0/A44_CAP_CORE128_M6_R1_0/CAP_BOTTOM_119 GND nfet_03v3 ad=0 pd=0 as=0 ps=0 w=1.56u l=0.28u
X4429 VREFN A44_DCTRL_STRIP_W_R2_0/CTRL_OUT[6] A44_CDAC_CAP_BANK_ASSEMBLY_R8_M6_0/A44_CAP_CORE128_M6_R1_0/CAP_BOTTOM_119 GND nfet_03v3 ad=0 pd=0 as=0 ps=0 w=1.56u l=0.28u
X4430 VREFP A44_DCTRL_STRIP_W_R2_0/CTRL_OUT[7] A44_CDAC_CAP_BANK_ASSEMBLY_R8_M6_0/A44_CAP_CORE128_M6_R1_0/CAP_BOTTOM_116 VDD pfet_03v3 ad=0 pd=0 as=16.6842p ps=77.76u w=1.56u l=0.28u
X4431 VREFP A44_DCTRL_STRIP_W_R2_0/CTRL_OUT[7] A44_CDAC_CAP_BANK_ASSEMBLY_R8_M6_0/A44_CAP_CORE128_M6_R1_0/CAP_BOTTOM_116 VDD pfet_03v3 ad=0 pd=0 as=0 ps=0 w=1.56u l=0.28u
X4432 VREFP A44_DCTRL_STRIP_W_R2_0/CTRL_OUT[7] A44_CDAC_CAP_BANK_ASSEMBLY_R8_M6_0/A44_CAP_CORE128_M6_R1_0/CAP_BOTTOM_116 VDD pfet_03v3 ad=0 pd=0 as=0 ps=0 w=1.56u l=0.28u
X4433 VREFP A44_DCTRL_STRIP_W_R2_0/CTRL_OUT[7] A44_CDAC_CAP_BANK_ASSEMBLY_R8_M6_0/A44_CAP_CORE128_M6_R1_0/CAP_BOTTOM_116 VDD pfet_03v3 ad=0 pd=0 as=0 ps=0 w=1.56u l=0.28u
X4434 VREFP A44_DCTRL_STRIP_W_R2_0/CTRL_OUT[7] A44_CDAC_CAP_BANK_ASSEMBLY_R8_M6_0/A44_CAP_CORE128_M6_R1_0/CAP_BOTTOM_116 VDD pfet_03v3 ad=0 pd=0 as=0 ps=0 w=1.56u l=0.28u
X4435 VREFP A44_DCTRL_STRIP_W_R2_0/CTRL_OUT[7] A44_CDAC_CAP_BANK_ASSEMBLY_R8_M6_0/A44_CAP_CORE128_M6_R1_0/CAP_BOTTOM_116 VDD pfet_03v3 ad=0 pd=0 as=0 ps=0 w=1.56u l=0.28u
X4436 VREFP A44_DCTRL_STRIP_W_R2_0/CTRL_OUT[7] A44_CDAC_CAP_BANK_ASSEMBLY_R8_M6_0/A44_CAP_CORE128_M6_R1_0/CAP_BOTTOM_116 VDD pfet_03v3 ad=0 pd=0 as=0 ps=0 w=1.56u l=0.28u
X4437 VREFP A44_DCTRL_STRIP_W_R2_0/CTRL_OUT[7] A44_CDAC_CAP_BANK_ASSEMBLY_R8_M6_0/A44_CAP_CORE128_M6_R1_0/CAP_BOTTOM_116 VDD pfet_03v3 ad=0 pd=0 as=0 ps=0 w=1.56u l=0.28u
X4438 VREFP A44_DCTRL_STRIP_W_R2_0/CTRL_OUT[7] A44_CDAC_CAP_BANK_ASSEMBLY_R8_M6_0/A44_CAP_CORE128_M6_R1_0/CAP_BOTTOM_116 VDD pfet_03v3 ad=0 pd=0 as=0 ps=0 w=1.56u l=0.28u
X4439 VREFP A44_DCTRL_STRIP_W_R2_0/CTRL_OUT[7] A44_CDAC_CAP_BANK_ASSEMBLY_R8_M6_0/A44_CAP_CORE128_M6_R1_0/CAP_BOTTOM_116 VDD pfet_03v3 ad=0 pd=0 as=0 ps=0 w=1.56u l=0.28u
X4440 VREFP A44_DCTRL_STRIP_W_R2_0/CTRL_OUT[7] A44_CDAC_CAP_BANK_ASSEMBLY_R8_M6_0/A44_CAP_CORE128_M6_R1_0/CAP_BOTTOM_116 VDD pfet_03v3 ad=0 pd=0 as=0 ps=0 w=1.56u l=0.28u
X4441 VREFP A44_DCTRL_STRIP_W_R2_0/CTRL_OUT[7] A44_CDAC_CAP_BANK_ASSEMBLY_R8_M6_0/A44_CAP_CORE128_M6_R1_0/CAP_BOTTOM_116 VDD pfet_03v3 ad=0 pd=0 as=0 ps=0 w=1.56u l=0.28u
X4442 VREFP A44_DCTRL_STRIP_W_R2_0/CTRL_OUT[7] A44_CDAC_CAP_BANK_ASSEMBLY_R8_M6_0/A44_CAP_CORE128_M6_R1_0/CAP_BOTTOM_116 VDD pfet_03v3 ad=0 pd=0 as=0 ps=0 w=1.56u l=0.28u
X4443 VREFP A44_DCTRL_STRIP_W_R2_0/CTRL_OUT[7] A44_CDAC_CAP_BANK_ASSEMBLY_R8_M6_0/A44_CAP_CORE128_M6_R1_0/CAP_BOTTOM_116 VDD pfet_03v3 ad=0 pd=0 as=0 ps=0 w=1.56u l=0.28u
X4444 VREFP A44_DCTRL_STRIP_W_R2_0/CTRL_OUT[7] A44_CDAC_CAP_BANK_ASSEMBLY_R8_M6_0/A44_CAP_CORE128_M6_R1_0/CAP_BOTTOM_116 VDD pfet_03v3 ad=0 pd=0 as=0 ps=0 w=1.56u l=0.28u
X4445 VREFP A44_DCTRL_STRIP_W_R2_0/CTRL_OUT[7] A44_CDAC_CAP_BANK_ASSEMBLY_R8_M6_0/A44_CAP_CORE128_M6_R1_0/CAP_BOTTOM_116 VDD pfet_03v3 ad=0 pd=0 as=0 ps=0 w=1.56u l=0.28u
X4446 VREFP A44_DCTRL_STRIP_W_R2_0/CTRL_OUT[7] A44_CDAC_CAP_BANK_ASSEMBLY_R8_M6_0/A44_CAP_CORE128_M6_R1_0/CAP_BOTTOM_116 VDD pfet_03v3 ad=0 pd=0 as=0 ps=0 w=1.56u l=0.28u
X4447 VREFP A44_DCTRL_STRIP_W_R2_0/CTRL_OUT[7] A44_CDAC_CAP_BANK_ASSEMBLY_R8_M6_0/A44_CAP_CORE128_M6_R1_0/CAP_BOTTOM_116 VDD pfet_03v3 ad=0 pd=0 as=0 ps=0 w=1.56u l=0.28u
X4448 VREFN A44_DCTRL_STRIP_W_R2_0/CTRL_OUT[7] A44_CDAC_CAP_BANK_ASSEMBLY_R8_M6_0/A44_CAP_CORE128_M6_R1_0/CAP_BOTTOM_116 GND nfet_03v3 ad=0 pd=0 as=16.6842p ps=77.76u w=1.56u l=0.28u
X4449 VREFN A44_DCTRL_STRIP_W_R2_0/CTRL_OUT[7] A44_CDAC_CAP_BANK_ASSEMBLY_R8_M6_0/A44_CAP_CORE128_M6_R1_0/CAP_BOTTOM_116 GND nfet_03v3 ad=0 pd=0 as=0 ps=0 w=1.56u l=0.28u
X4450 VREFN A44_DCTRL_STRIP_W_R2_0/CTRL_OUT[7] A44_CDAC_CAP_BANK_ASSEMBLY_R8_M6_0/A44_CAP_CORE128_M6_R1_0/CAP_BOTTOM_116 GND nfet_03v3 ad=0 pd=0 as=0 ps=0 w=1.56u l=0.28u
X4451 VREFN A44_DCTRL_STRIP_W_R2_0/CTRL_OUT[7] A44_CDAC_CAP_BANK_ASSEMBLY_R8_M6_0/A44_CAP_CORE128_M6_R1_0/CAP_BOTTOM_116 GND nfet_03v3 ad=0 pd=0 as=0 ps=0 w=1.56u l=0.28u
X4452 VREFN A44_DCTRL_STRIP_W_R2_0/CTRL_OUT[7] A44_CDAC_CAP_BANK_ASSEMBLY_R8_M6_0/A44_CAP_CORE128_M6_R1_0/CAP_BOTTOM_116 GND nfet_03v3 ad=0 pd=0 as=0 ps=0 w=1.56u l=0.28u
X4453 VREFN A44_DCTRL_STRIP_W_R2_0/CTRL_OUT[7] A44_CDAC_CAP_BANK_ASSEMBLY_R8_M6_0/A44_CAP_CORE128_M6_R1_0/CAP_BOTTOM_116 GND nfet_03v3 ad=0 pd=0 as=0 ps=0 w=1.56u l=0.28u
X4454 VREFN A44_DCTRL_STRIP_W_R2_0/CTRL_OUT[7] A44_CDAC_CAP_BANK_ASSEMBLY_R8_M6_0/A44_CAP_CORE128_M6_R1_0/CAP_BOTTOM_116 GND nfet_03v3 ad=0 pd=0 as=0 ps=0 w=1.56u l=0.28u
X4455 VREFN A44_DCTRL_STRIP_W_R2_0/CTRL_OUT[7] A44_CDAC_CAP_BANK_ASSEMBLY_R8_M6_0/A44_CAP_CORE128_M6_R1_0/CAP_BOTTOM_116 GND nfet_03v3 ad=0 pd=0 as=0 ps=0 w=1.56u l=0.28u
X4456 VREFN A44_DCTRL_STRIP_W_R2_0/CTRL_OUT[7] A44_CDAC_CAP_BANK_ASSEMBLY_R8_M6_0/A44_CAP_CORE128_M6_R1_0/CAP_BOTTOM_116 GND nfet_03v3 ad=0 pd=0 as=0 ps=0 w=1.56u l=0.28u
X4457 VREFN A44_DCTRL_STRIP_W_R2_0/CTRL_OUT[7] A44_CDAC_CAP_BANK_ASSEMBLY_R8_M6_0/A44_CAP_CORE128_M6_R1_0/CAP_BOTTOM_116 GND nfet_03v3 ad=0 pd=0 as=0 ps=0 w=1.56u l=0.28u
X4458 VREFN A44_DCTRL_STRIP_W_R2_0/CTRL_OUT[7] A44_CDAC_CAP_BANK_ASSEMBLY_R8_M6_0/A44_CAP_CORE128_M6_R1_0/CAP_BOTTOM_116 GND nfet_03v3 ad=0 pd=0 as=0 ps=0 w=1.56u l=0.28u
X4459 VREFN A44_DCTRL_STRIP_W_R2_0/CTRL_OUT[7] A44_CDAC_CAP_BANK_ASSEMBLY_R8_M6_0/A44_CAP_CORE128_M6_R1_0/CAP_BOTTOM_116 GND nfet_03v3 ad=0 pd=0 as=0 ps=0 w=1.56u l=0.28u
X4460 VREFN A44_DCTRL_STRIP_W_R2_0/CTRL_OUT[7] A44_CDAC_CAP_BANK_ASSEMBLY_R8_M6_0/A44_CAP_CORE128_M6_R1_0/CAP_BOTTOM_116 GND nfet_03v3 ad=0 pd=0 as=0 ps=0 w=1.56u l=0.28u
X4461 VREFN A44_DCTRL_STRIP_W_R2_0/CTRL_OUT[7] A44_CDAC_CAP_BANK_ASSEMBLY_R8_M6_0/A44_CAP_CORE128_M6_R1_0/CAP_BOTTOM_116 GND nfet_03v3 ad=0 pd=0 as=0 ps=0 w=1.56u l=0.28u
X4462 VREFN A44_DCTRL_STRIP_W_R2_0/CTRL_OUT[7] A44_CDAC_CAP_BANK_ASSEMBLY_R8_M6_0/A44_CAP_CORE128_M6_R1_0/CAP_BOTTOM_116 GND nfet_03v3 ad=0 pd=0 as=0 ps=0 w=1.56u l=0.28u
X4463 VREFN A44_DCTRL_STRIP_W_R2_0/CTRL_OUT[7] A44_CDAC_CAP_BANK_ASSEMBLY_R8_M6_0/A44_CAP_CORE128_M6_R1_0/CAP_BOTTOM_116 GND nfet_03v3 ad=0 pd=0 as=0 ps=0 w=1.56u l=0.28u
X4464 VREFN A44_DCTRL_STRIP_W_R2_0/CTRL_OUT[7] A44_CDAC_CAP_BANK_ASSEMBLY_R8_M6_0/A44_CAP_CORE128_M6_R1_0/CAP_BOTTOM_116 GND nfet_03v3 ad=0 pd=0 as=0 ps=0 w=1.56u l=0.28u
X4465 VREFN A44_DCTRL_STRIP_W_R2_0/CTRL_OUT[7] A44_CDAC_CAP_BANK_ASSEMBLY_R8_M6_0/A44_CAP_CORE128_M6_R1_0/CAP_BOTTOM_116 GND nfet_03v3 ad=0 pd=0 as=0 ps=0 w=1.56u l=0.28u
X4466 VREFP A44_DCTRL_STRIP_W_R2_0/CTRL_OUT[5] A44_CDAC_CAP_BANK_ASSEMBLY_R8_M6_0/A44_CAP_CORE128_M6_R1_0/CAP_BOTTOM_108 VDD pfet_03v3 ad=0 pd=0 as=16.6842p ps=77.76u w=1.56u l=0.28u
X4467 VREFP A44_DCTRL_STRIP_W_R2_0/CTRL_OUT[5] A44_CDAC_CAP_BANK_ASSEMBLY_R8_M6_0/A44_CAP_CORE128_M6_R1_0/CAP_BOTTOM_108 VDD pfet_03v3 ad=0 pd=0 as=0 ps=0 w=1.56u l=0.28u
X4468 VREFP A44_DCTRL_STRIP_W_R2_0/CTRL_OUT[5] A44_CDAC_CAP_BANK_ASSEMBLY_R8_M6_0/A44_CAP_CORE128_M6_R1_0/CAP_BOTTOM_108 VDD pfet_03v3 ad=0 pd=0 as=0 ps=0 w=1.56u l=0.28u
X4469 VREFP A44_DCTRL_STRIP_W_R2_0/CTRL_OUT[5] A44_CDAC_CAP_BANK_ASSEMBLY_R8_M6_0/A44_CAP_CORE128_M6_R1_0/CAP_BOTTOM_108 VDD pfet_03v3 ad=0 pd=0 as=0 ps=0 w=1.56u l=0.28u
X4470 VREFP A44_DCTRL_STRIP_W_R2_0/CTRL_OUT[5] A44_CDAC_CAP_BANK_ASSEMBLY_R8_M6_0/A44_CAP_CORE128_M6_R1_0/CAP_BOTTOM_108 VDD pfet_03v3 ad=0 pd=0 as=0 ps=0 w=1.56u l=0.28u
X4471 VREFP A44_DCTRL_STRIP_W_R2_0/CTRL_OUT[5] A44_CDAC_CAP_BANK_ASSEMBLY_R8_M6_0/A44_CAP_CORE128_M6_R1_0/CAP_BOTTOM_108 VDD pfet_03v3 ad=0 pd=0 as=0 ps=0 w=1.56u l=0.28u
X4472 VREFP A44_DCTRL_STRIP_W_R2_0/CTRL_OUT[5] A44_CDAC_CAP_BANK_ASSEMBLY_R8_M6_0/A44_CAP_CORE128_M6_R1_0/CAP_BOTTOM_108 VDD pfet_03v3 ad=0 pd=0 as=0 ps=0 w=1.56u l=0.28u
X4473 VREFP A44_DCTRL_STRIP_W_R2_0/CTRL_OUT[5] A44_CDAC_CAP_BANK_ASSEMBLY_R8_M6_0/A44_CAP_CORE128_M6_R1_0/CAP_BOTTOM_108 VDD pfet_03v3 ad=0 pd=0 as=0 ps=0 w=1.56u l=0.28u
X4474 VREFP A44_DCTRL_STRIP_W_R2_0/CTRL_OUT[5] A44_CDAC_CAP_BANK_ASSEMBLY_R8_M6_0/A44_CAP_CORE128_M6_R1_0/CAP_BOTTOM_108 VDD pfet_03v3 ad=0 pd=0 as=0 ps=0 w=1.56u l=0.28u
X4475 VREFP A44_DCTRL_STRIP_W_R2_0/CTRL_OUT[5] A44_CDAC_CAP_BANK_ASSEMBLY_R8_M6_0/A44_CAP_CORE128_M6_R1_0/CAP_BOTTOM_108 VDD pfet_03v3 ad=0 pd=0 as=0 ps=0 w=1.56u l=0.28u
X4476 VREFP A44_DCTRL_STRIP_W_R2_0/CTRL_OUT[5] A44_CDAC_CAP_BANK_ASSEMBLY_R8_M6_0/A44_CAP_CORE128_M6_R1_0/CAP_BOTTOM_108 VDD pfet_03v3 ad=0 pd=0 as=0 ps=0 w=1.56u l=0.28u
X4477 VREFP A44_DCTRL_STRIP_W_R2_0/CTRL_OUT[5] A44_CDAC_CAP_BANK_ASSEMBLY_R8_M6_0/A44_CAP_CORE128_M6_R1_0/CAP_BOTTOM_108 VDD pfet_03v3 ad=0 pd=0 as=0 ps=0 w=1.56u l=0.28u
X4478 VREFP A44_DCTRL_STRIP_W_R2_0/CTRL_OUT[5] A44_CDAC_CAP_BANK_ASSEMBLY_R8_M6_0/A44_CAP_CORE128_M6_R1_0/CAP_BOTTOM_108 VDD pfet_03v3 ad=0 pd=0 as=0 ps=0 w=1.56u l=0.28u
X4479 VREFP A44_DCTRL_STRIP_W_R2_0/CTRL_OUT[5] A44_CDAC_CAP_BANK_ASSEMBLY_R8_M6_0/A44_CAP_CORE128_M6_R1_0/CAP_BOTTOM_108 VDD pfet_03v3 ad=0 pd=0 as=0 ps=0 w=1.56u l=0.28u
X4480 VREFP A44_DCTRL_STRIP_W_R2_0/CTRL_OUT[5] A44_CDAC_CAP_BANK_ASSEMBLY_R8_M6_0/A44_CAP_CORE128_M6_R1_0/CAP_BOTTOM_108 VDD pfet_03v3 ad=0 pd=0 as=0 ps=0 w=1.56u l=0.28u
X4481 VREFP A44_DCTRL_STRIP_W_R2_0/CTRL_OUT[5] A44_CDAC_CAP_BANK_ASSEMBLY_R8_M6_0/A44_CAP_CORE128_M6_R1_0/CAP_BOTTOM_108 VDD pfet_03v3 ad=0 pd=0 as=0 ps=0 w=1.56u l=0.28u
X4482 VREFP A44_DCTRL_STRIP_W_R2_0/CTRL_OUT[5] A44_CDAC_CAP_BANK_ASSEMBLY_R8_M6_0/A44_CAP_CORE128_M6_R1_0/CAP_BOTTOM_108 VDD pfet_03v3 ad=0 pd=0 as=0 ps=0 w=1.56u l=0.28u
X4483 VREFP A44_DCTRL_STRIP_W_R2_0/CTRL_OUT[5] A44_CDAC_CAP_BANK_ASSEMBLY_R8_M6_0/A44_CAP_CORE128_M6_R1_0/CAP_BOTTOM_108 VDD pfet_03v3 ad=0 pd=0 as=0 ps=0 w=1.56u l=0.28u
X4484 VREFN A44_DCTRL_STRIP_W_R2_0/CTRL_OUT[5] A44_CDAC_CAP_BANK_ASSEMBLY_R8_M6_0/A44_CAP_CORE128_M6_R1_0/CAP_BOTTOM_108 GND nfet_03v3 ad=0 pd=0 as=16.6842p ps=77.76u w=1.56u l=0.28u
X4485 VREFN A44_DCTRL_STRIP_W_R2_0/CTRL_OUT[5] A44_CDAC_CAP_BANK_ASSEMBLY_R8_M6_0/A44_CAP_CORE128_M6_R1_0/CAP_BOTTOM_108 GND nfet_03v3 ad=0 pd=0 as=0 ps=0 w=1.56u l=0.28u
X4486 VREFN A44_DCTRL_STRIP_W_R2_0/CTRL_OUT[5] A44_CDAC_CAP_BANK_ASSEMBLY_R8_M6_0/A44_CAP_CORE128_M6_R1_0/CAP_BOTTOM_108 GND nfet_03v3 ad=0 pd=0 as=0 ps=0 w=1.56u l=0.28u
X4487 VREFN A44_DCTRL_STRIP_W_R2_0/CTRL_OUT[5] A44_CDAC_CAP_BANK_ASSEMBLY_R8_M6_0/A44_CAP_CORE128_M6_R1_0/CAP_BOTTOM_108 GND nfet_03v3 ad=0 pd=0 as=0 ps=0 w=1.56u l=0.28u
X4488 VREFN A44_DCTRL_STRIP_W_R2_0/CTRL_OUT[5] A44_CDAC_CAP_BANK_ASSEMBLY_R8_M6_0/A44_CAP_CORE128_M6_R1_0/CAP_BOTTOM_108 GND nfet_03v3 ad=0 pd=0 as=0 ps=0 w=1.56u l=0.28u
X4489 VREFN A44_DCTRL_STRIP_W_R2_0/CTRL_OUT[5] A44_CDAC_CAP_BANK_ASSEMBLY_R8_M6_0/A44_CAP_CORE128_M6_R1_0/CAP_BOTTOM_108 GND nfet_03v3 ad=0 pd=0 as=0 ps=0 w=1.56u l=0.28u
X4490 VREFN A44_DCTRL_STRIP_W_R2_0/CTRL_OUT[5] A44_CDAC_CAP_BANK_ASSEMBLY_R8_M6_0/A44_CAP_CORE128_M6_R1_0/CAP_BOTTOM_108 GND nfet_03v3 ad=0 pd=0 as=0 ps=0 w=1.56u l=0.28u
X4491 VREFN A44_DCTRL_STRIP_W_R2_0/CTRL_OUT[5] A44_CDAC_CAP_BANK_ASSEMBLY_R8_M6_0/A44_CAP_CORE128_M6_R1_0/CAP_BOTTOM_108 GND nfet_03v3 ad=0 pd=0 as=0 ps=0 w=1.56u l=0.28u
X4492 VREFN A44_DCTRL_STRIP_W_R2_0/CTRL_OUT[5] A44_CDAC_CAP_BANK_ASSEMBLY_R8_M6_0/A44_CAP_CORE128_M6_R1_0/CAP_BOTTOM_108 GND nfet_03v3 ad=0 pd=0 as=0 ps=0 w=1.56u l=0.28u
X4493 VREFN A44_DCTRL_STRIP_W_R2_0/CTRL_OUT[5] A44_CDAC_CAP_BANK_ASSEMBLY_R8_M6_0/A44_CAP_CORE128_M6_R1_0/CAP_BOTTOM_108 GND nfet_03v3 ad=0 pd=0 as=0 ps=0 w=1.56u l=0.28u
X4494 VREFN A44_DCTRL_STRIP_W_R2_0/CTRL_OUT[5] A44_CDAC_CAP_BANK_ASSEMBLY_R8_M6_0/A44_CAP_CORE128_M6_R1_0/CAP_BOTTOM_108 GND nfet_03v3 ad=0 pd=0 as=0 ps=0 w=1.56u l=0.28u
X4495 VREFN A44_DCTRL_STRIP_W_R2_0/CTRL_OUT[5] A44_CDAC_CAP_BANK_ASSEMBLY_R8_M6_0/A44_CAP_CORE128_M6_R1_0/CAP_BOTTOM_108 GND nfet_03v3 ad=0 pd=0 as=0 ps=0 w=1.56u l=0.28u
X4496 VREFN A44_DCTRL_STRIP_W_R2_0/CTRL_OUT[5] A44_CDAC_CAP_BANK_ASSEMBLY_R8_M6_0/A44_CAP_CORE128_M6_R1_0/CAP_BOTTOM_108 GND nfet_03v3 ad=0 pd=0 as=0 ps=0 w=1.56u l=0.28u
X4497 VREFN A44_DCTRL_STRIP_W_R2_0/CTRL_OUT[5] A44_CDAC_CAP_BANK_ASSEMBLY_R8_M6_0/A44_CAP_CORE128_M6_R1_0/CAP_BOTTOM_108 GND nfet_03v3 ad=0 pd=0 as=0 ps=0 w=1.56u l=0.28u
X4498 VREFN A44_DCTRL_STRIP_W_R2_0/CTRL_OUT[5] A44_CDAC_CAP_BANK_ASSEMBLY_R8_M6_0/A44_CAP_CORE128_M6_R1_0/CAP_BOTTOM_108 GND nfet_03v3 ad=0 pd=0 as=0 ps=0 w=1.56u l=0.28u
X4499 VREFN A44_DCTRL_STRIP_W_R2_0/CTRL_OUT[5] A44_CDAC_CAP_BANK_ASSEMBLY_R8_M6_0/A44_CAP_CORE128_M6_R1_0/CAP_BOTTOM_108 GND nfet_03v3 ad=0 pd=0 as=0 ps=0 w=1.56u l=0.28u
X4500 VREFN A44_DCTRL_STRIP_W_R2_0/CTRL_OUT[5] A44_CDAC_CAP_BANK_ASSEMBLY_R8_M6_0/A44_CAP_CORE128_M6_R1_0/CAP_BOTTOM_108 GND nfet_03v3 ad=0 pd=0 as=0 ps=0 w=1.56u l=0.28u
X4501 VREFN A44_DCTRL_STRIP_W_R2_0/CTRL_OUT[5] A44_CDAC_CAP_BANK_ASSEMBLY_R8_M6_0/A44_CAP_CORE128_M6_R1_0/CAP_BOTTOM_108 GND nfet_03v3 ad=0 pd=0 as=0 ps=0 w=1.56u l=0.28u
X4502 VREFP A44_DCTRL_STRIP_W_R2_0/CTRL_OUT[6] A44_CDAC_CAP_BANK_ASSEMBLY_R8_M6_0/A44_CAP_CORE128_M6_R1_0/CAP_BOTTOM_106 VDD pfet_03v3 ad=0 pd=0 as=16.6842p ps=77.76u w=1.56u l=0.28u
X4503 VREFP A44_DCTRL_STRIP_W_R2_0/CTRL_OUT[6] A44_CDAC_CAP_BANK_ASSEMBLY_R8_M6_0/A44_CAP_CORE128_M6_R1_0/CAP_BOTTOM_106 VDD pfet_03v3 ad=0 pd=0 as=0 ps=0 w=1.56u l=0.28u
X4504 VREFP A44_DCTRL_STRIP_W_R2_0/CTRL_OUT[6] A44_CDAC_CAP_BANK_ASSEMBLY_R8_M6_0/A44_CAP_CORE128_M6_R1_0/CAP_BOTTOM_106 VDD pfet_03v3 ad=0 pd=0 as=0 ps=0 w=1.56u l=0.28u
X4505 VREFP A44_DCTRL_STRIP_W_R2_0/CTRL_OUT[6] A44_CDAC_CAP_BANK_ASSEMBLY_R8_M6_0/A44_CAP_CORE128_M6_R1_0/CAP_BOTTOM_106 VDD pfet_03v3 ad=0 pd=0 as=0 ps=0 w=1.56u l=0.28u
X4506 VREFP A44_DCTRL_STRIP_W_R2_0/CTRL_OUT[6] A44_CDAC_CAP_BANK_ASSEMBLY_R8_M6_0/A44_CAP_CORE128_M6_R1_0/CAP_BOTTOM_106 VDD pfet_03v3 ad=0 pd=0 as=0 ps=0 w=1.56u l=0.28u
X4507 VREFP A44_DCTRL_STRIP_W_R2_0/CTRL_OUT[6] A44_CDAC_CAP_BANK_ASSEMBLY_R8_M6_0/A44_CAP_CORE128_M6_R1_0/CAP_BOTTOM_106 VDD pfet_03v3 ad=0 pd=0 as=0 ps=0 w=1.56u l=0.28u
X4508 VREFP A44_DCTRL_STRIP_W_R2_0/CTRL_OUT[6] A44_CDAC_CAP_BANK_ASSEMBLY_R8_M6_0/A44_CAP_CORE128_M6_R1_0/CAP_BOTTOM_106 VDD pfet_03v3 ad=0 pd=0 as=0 ps=0 w=1.56u l=0.28u
X4509 VREFP A44_DCTRL_STRIP_W_R2_0/CTRL_OUT[6] A44_CDAC_CAP_BANK_ASSEMBLY_R8_M6_0/A44_CAP_CORE128_M6_R1_0/CAP_BOTTOM_106 VDD pfet_03v3 ad=0 pd=0 as=0 ps=0 w=1.56u l=0.28u
X4510 VREFP A44_DCTRL_STRIP_W_R2_0/CTRL_OUT[6] A44_CDAC_CAP_BANK_ASSEMBLY_R8_M6_0/A44_CAP_CORE128_M6_R1_0/CAP_BOTTOM_106 VDD pfet_03v3 ad=0 pd=0 as=0 ps=0 w=1.56u l=0.28u
X4511 VREFP A44_DCTRL_STRIP_W_R2_0/CTRL_OUT[6] A44_CDAC_CAP_BANK_ASSEMBLY_R8_M6_0/A44_CAP_CORE128_M6_R1_0/CAP_BOTTOM_106 VDD pfet_03v3 ad=0 pd=0 as=0 ps=0 w=1.56u l=0.28u
X4512 VREFP A44_DCTRL_STRIP_W_R2_0/CTRL_OUT[6] A44_CDAC_CAP_BANK_ASSEMBLY_R8_M6_0/A44_CAP_CORE128_M6_R1_0/CAP_BOTTOM_106 VDD pfet_03v3 ad=0 pd=0 as=0 ps=0 w=1.56u l=0.28u
X4513 VREFP A44_DCTRL_STRIP_W_R2_0/CTRL_OUT[6] A44_CDAC_CAP_BANK_ASSEMBLY_R8_M6_0/A44_CAP_CORE128_M6_R1_0/CAP_BOTTOM_106 VDD pfet_03v3 ad=0 pd=0 as=0 ps=0 w=1.56u l=0.28u
X4514 VREFP A44_DCTRL_STRIP_W_R2_0/CTRL_OUT[6] A44_CDAC_CAP_BANK_ASSEMBLY_R8_M6_0/A44_CAP_CORE128_M6_R1_0/CAP_BOTTOM_106 VDD pfet_03v3 ad=0 pd=0 as=0 ps=0 w=1.56u l=0.28u
X4515 VREFP A44_DCTRL_STRIP_W_R2_0/CTRL_OUT[6] A44_CDAC_CAP_BANK_ASSEMBLY_R8_M6_0/A44_CAP_CORE128_M6_R1_0/CAP_BOTTOM_106 VDD pfet_03v3 ad=0 pd=0 as=0 ps=0 w=1.56u l=0.28u
X4516 VREFP A44_DCTRL_STRIP_W_R2_0/CTRL_OUT[6] A44_CDAC_CAP_BANK_ASSEMBLY_R8_M6_0/A44_CAP_CORE128_M6_R1_0/CAP_BOTTOM_106 VDD pfet_03v3 ad=0 pd=0 as=0 ps=0 w=1.56u l=0.28u
X4517 VREFP A44_DCTRL_STRIP_W_R2_0/CTRL_OUT[6] A44_CDAC_CAP_BANK_ASSEMBLY_R8_M6_0/A44_CAP_CORE128_M6_R1_0/CAP_BOTTOM_106 VDD pfet_03v3 ad=0 pd=0 as=0 ps=0 w=1.56u l=0.28u
X4518 VREFP A44_DCTRL_STRIP_W_R2_0/CTRL_OUT[6] A44_CDAC_CAP_BANK_ASSEMBLY_R8_M6_0/A44_CAP_CORE128_M6_R1_0/CAP_BOTTOM_106 VDD pfet_03v3 ad=0 pd=0 as=0 ps=0 w=1.56u l=0.28u
X4519 VREFP A44_DCTRL_STRIP_W_R2_0/CTRL_OUT[6] A44_CDAC_CAP_BANK_ASSEMBLY_R8_M6_0/A44_CAP_CORE128_M6_R1_0/CAP_BOTTOM_106 VDD pfet_03v3 ad=0 pd=0 as=0 ps=0 w=1.56u l=0.28u
X4520 VREFN A44_DCTRL_STRIP_W_R2_0/CTRL_OUT[6] A44_CDAC_CAP_BANK_ASSEMBLY_R8_M6_0/A44_CAP_CORE128_M6_R1_0/CAP_BOTTOM_106 GND nfet_03v3 ad=0 pd=0 as=16.6842p ps=77.76u w=1.56u l=0.28u
X4521 VREFN A44_DCTRL_STRIP_W_R2_0/CTRL_OUT[6] A44_CDAC_CAP_BANK_ASSEMBLY_R8_M6_0/A44_CAP_CORE128_M6_R1_0/CAP_BOTTOM_106 GND nfet_03v3 ad=0 pd=0 as=0 ps=0 w=1.56u l=0.28u
X4522 VREFN A44_DCTRL_STRIP_W_R2_0/CTRL_OUT[6] A44_CDAC_CAP_BANK_ASSEMBLY_R8_M6_0/A44_CAP_CORE128_M6_R1_0/CAP_BOTTOM_106 GND nfet_03v3 ad=0 pd=0 as=0 ps=0 w=1.56u l=0.28u
X4523 VREFN A44_DCTRL_STRIP_W_R2_0/CTRL_OUT[6] A44_CDAC_CAP_BANK_ASSEMBLY_R8_M6_0/A44_CAP_CORE128_M6_R1_0/CAP_BOTTOM_106 GND nfet_03v3 ad=0 pd=0 as=0 ps=0 w=1.56u l=0.28u
X4524 VREFN A44_DCTRL_STRIP_W_R2_0/CTRL_OUT[6] A44_CDAC_CAP_BANK_ASSEMBLY_R8_M6_0/A44_CAP_CORE128_M6_R1_0/CAP_BOTTOM_106 GND nfet_03v3 ad=0 pd=0 as=0 ps=0 w=1.56u l=0.28u
X4525 VREFN A44_DCTRL_STRIP_W_R2_0/CTRL_OUT[6] A44_CDAC_CAP_BANK_ASSEMBLY_R8_M6_0/A44_CAP_CORE128_M6_R1_0/CAP_BOTTOM_106 GND nfet_03v3 ad=0 pd=0 as=0 ps=0 w=1.56u l=0.28u
X4526 VREFN A44_DCTRL_STRIP_W_R2_0/CTRL_OUT[6] A44_CDAC_CAP_BANK_ASSEMBLY_R8_M6_0/A44_CAP_CORE128_M6_R1_0/CAP_BOTTOM_106 GND nfet_03v3 ad=0 pd=0 as=0 ps=0 w=1.56u l=0.28u
X4527 VREFN A44_DCTRL_STRIP_W_R2_0/CTRL_OUT[6] A44_CDAC_CAP_BANK_ASSEMBLY_R8_M6_0/A44_CAP_CORE128_M6_R1_0/CAP_BOTTOM_106 GND nfet_03v3 ad=0 pd=0 as=0 ps=0 w=1.56u l=0.28u
X4528 VREFN A44_DCTRL_STRIP_W_R2_0/CTRL_OUT[6] A44_CDAC_CAP_BANK_ASSEMBLY_R8_M6_0/A44_CAP_CORE128_M6_R1_0/CAP_BOTTOM_106 GND nfet_03v3 ad=0 pd=0 as=0 ps=0 w=1.56u l=0.28u
X4529 VREFN A44_DCTRL_STRIP_W_R2_0/CTRL_OUT[6] A44_CDAC_CAP_BANK_ASSEMBLY_R8_M6_0/A44_CAP_CORE128_M6_R1_0/CAP_BOTTOM_106 GND nfet_03v3 ad=0 pd=0 as=0 ps=0 w=1.56u l=0.28u
X4530 VREFN A44_DCTRL_STRIP_W_R2_0/CTRL_OUT[6] A44_CDAC_CAP_BANK_ASSEMBLY_R8_M6_0/A44_CAP_CORE128_M6_R1_0/CAP_BOTTOM_106 GND nfet_03v3 ad=0 pd=0 as=0 ps=0 w=1.56u l=0.28u
X4531 VREFN A44_DCTRL_STRIP_W_R2_0/CTRL_OUT[6] A44_CDAC_CAP_BANK_ASSEMBLY_R8_M6_0/A44_CAP_CORE128_M6_R1_0/CAP_BOTTOM_106 GND nfet_03v3 ad=0 pd=0 as=0 ps=0 w=1.56u l=0.28u
X4532 VREFN A44_DCTRL_STRIP_W_R2_0/CTRL_OUT[6] A44_CDAC_CAP_BANK_ASSEMBLY_R8_M6_0/A44_CAP_CORE128_M6_R1_0/CAP_BOTTOM_106 GND nfet_03v3 ad=0 pd=0 as=0 ps=0 w=1.56u l=0.28u
X4533 VREFN A44_DCTRL_STRIP_W_R2_0/CTRL_OUT[6] A44_CDAC_CAP_BANK_ASSEMBLY_R8_M6_0/A44_CAP_CORE128_M6_R1_0/CAP_BOTTOM_106 GND nfet_03v3 ad=0 pd=0 as=0 ps=0 w=1.56u l=0.28u
X4534 VREFN A44_DCTRL_STRIP_W_R2_0/CTRL_OUT[6] A44_CDAC_CAP_BANK_ASSEMBLY_R8_M6_0/A44_CAP_CORE128_M6_R1_0/CAP_BOTTOM_106 GND nfet_03v3 ad=0 pd=0 as=0 ps=0 w=1.56u l=0.28u
X4535 VREFN A44_DCTRL_STRIP_W_R2_0/CTRL_OUT[6] A44_CDAC_CAP_BANK_ASSEMBLY_R8_M6_0/A44_CAP_CORE128_M6_R1_0/CAP_BOTTOM_106 GND nfet_03v3 ad=0 pd=0 as=0 ps=0 w=1.56u l=0.28u
X4536 VREFN A44_DCTRL_STRIP_W_R2_0/CTRL_OUT[6] A44_CDAC_CAP_BANK_ASSEMBLY_R8_M6_0/A44_CAP_CORE128_M6_R1_0/CAP_BOTTOM_106 GND nfet_03v3 ad=0 pd=0 as=0 ps=0 w=1.56u l=0.28u
X4537 VREFN A44_DCTRL_STRIP_W_R2_0/CTRL_OUT[6] A44_CDAC_CAP_BANK_ASSEMBLY_R8_M6_0/A44_CAP_CORE128_M6_R1_0/CAP_BOTTOM_106 GND nfet_03v3 ad=0 pd=0 as=0 ps=0 w=1.56u l=0.28u
X4538 VREFP A44_DCTRL_STRIP_W_R2_0/CTRL_OUT[5] A44_CDAC_CAP_BANK_ASSEMBLY_R8_M6_0/A44_CAP_CORE128_M6_R1_0/CAP_BOTTOM_090 VDD pfet_03v3 ad=0 pd=0 as=16.6842p ps=77.76u w=1.56u l=0.28u
X4539 VREFP A44_DCTRL_STRIP_W_R2_0/CTRL_OUT[5] A44_CDAC_CAP_BANK_ASSEMBLY_R8_M6_0/A44_CAP_CORE128_M6_R1_0/CAP_BOTTOM_090 VDD pfet_03v3 ad=0 pd=0 as=0 ps=0 w=1.56u l=0.28u
X4540 VREFP A44_DCTRL_STRIP_W_R2_0/CTRL_OUT[5] A44_CDAC_CAP_BANK_ASSEMBLY_R8_M6_0/A44_CAP_CORE128_M6_R1_0/CAP_BOTTOM_090 VDD pfet_03v3 ad=0 pd=0 as=0 ps=0 w=1.56u l=0.28u
X4541 VREFP A44_DCTRL_STRIP_W_R2_0/CTRL_OUT[5] A44_CDAC_CAP_BANK_ASSEMBLY_R8_M6_0/A44_CAP_CORE128_M6_R1_0/CAP_BOTTOM_090 VDD pfet_03v3 ad=0 pd=0 as=0 ps=0 w=1.56u l=0.28u
X4542 VREFP A44_DCTRL_STRIP_W_R2_0/CTRL_OUT[5] A44_CDAC_CAP_BANK_ASSEMBLY_R8_M6_0/A44_CAP_CORE128_M6_R1_0/CAP_BOTTOM_090 VDD pfet_03v3 ad=0 pd=0 as=0 ps=0 w=1.56u l=0.28u
X4543 VREFP A44_DCTRL_STRIP_W_R2_0/CTRL_OUT[5] A44_CDAC_CAP_BANK_ASSEMBLY_R8_M6_0/A44_CAP_CORE128_M6_R1_0/CAP_BOTTOM_090 VDD pfet_03v3 ad=0 pd=0 as=0 ps=0 w=1.56u l=0.28u
X4544 VREFP A44_DCTRL_STRIP_W_R2_0/CTRL_OUT[5] A44_CDAC_CAP_BANK_ASSEMBLY_R8_M6_0/A44_CAP_CORE128_M6_R1_0/CAP_BOTTOM_090 VDD pfet_03v3 ad=0 pd=0 as=0 ps=0 w=1.56u l=0.28u
X4545 VREFP A44_DCTRL_STRIP_W_R2_0/CTRL_OUT[5] A44_CDAC_CAP_BANK_ASSEMBLY_R8_M6_0/A44_CAP_CORE128_M6_R1_0/CAP_BOTTOM_090 VDD pfet_03v3 ad=0 pd=0 as=0 ps=0 w=1.56u l=0.28u
X4546 VREFP A44_DCTRL_STRIP_W_R2_0/CTRL_OUT[5] A44_CDAC_CAP_BANK_ASSEMBLY_R8_M6_0/A44_CAP_CORE128_M6_R1_0/CAP_BOTTOM_090 VDD pfet_03v3 ad=0 pd=0 as=0 ps=0 w=1.56u l=0.28u
X4547 VREFP A44_DCTRL_STRIP_W_R2_0/CTRL_OUT[5] A44_CDAC_CAP_BANK_ASSEMBLY_R8_M6_0/A44_CAP_CORE128_M6_R1_0/CAP_BOTTOM_090 VDD pfet_03v3 ad=0 pd=0 as=0 ps=0 w=1.56u l=0.28u
X4548 VREFP A44_DCTRL_STRIP_W_R2_0/CTRL_OUT[5] A44_CDAC_CAP_BANK_ASSEMBLY_R8_M6_0/A44_CAP_CORE128_M6_R1_0/CAP_BOTTOM_090 VDD pfet_03v3 ad=0 pd=0 as=0 ps=0 w=1.56u l=0.28u
X4549 VREFP A44_DCTRL_STRIP_W_R2_0/CTRL_OUT[5] A44_CDAC_CAP_BANK_ASSEMBLY_R8_M6_0/A44_CAP_CORE128_M6_R1_0/CAP_BOTTOM_090 VDD pfet_03v3 ad=0 pd=0 as=0 ps=0 w=1.56u l=0.28u
X4550 VREFP A44_DCTRL_STRIP_W_R2_0/CTRL_OUT[5] A44_CDAC_CAP_BANK_ASSEMBLY_R8_M6_0/A44_CAP_CORE128_M6_R1_0/CAP_BOTTOM_090 VDD pfet_03v3 ad=0 pd=0 as=0 ps=0 w=1.56u l=0.28u
X4551 VREFP A44_DCTRL_STRIP_W_R2_0/CTRL_OUT[5] A44_CDAC_CAP_BANK_ASSEMBLY_R8_M6_0/A44_CAP_CORE128_M6_R1_0/CAP_BOTTOM_090 VDD pfet_03v3 ad=0 pd=0 as=0 ps=0 w=1.56u l=0.28u
X4552 VREFP A44_DCTRL_STRIP_W_R2_0/CTRL_OUT[5] A44_CDAC_CAP_BANK_ASSEMBLY_R8_M6_0/A44_CAP_CORE128_M6_R1_0/CAP_BOTTOM_090 VDD pfet_03v3 ad=0 pd=0 as=0 ps=0 w=1.56u l=0.28u
X4553 VREFP A44_DCTRL_STRIP_W_R2_0/CTRL_OUT[5] A44_CDAC_CAP_BANK_ASSEMBLY_R8_M6_0/A44_CAP_CORE128_M6_R1_0/CAP_BOTTOM_090 VDD pfet_03v3 ad=0 pd=0 as=0 ps=0 w=1.56u l=0.28u
X4554 VREFP A44_DCTRL_STRIP_W_R2_0/CTRL_OUT[5] A44_CDAC_CAP_BANK_ASSEMBLY_R8_M6_0/A44_CAP_CORE128_M6_R1_0/CAP_BOTTOM_090 VDD pfet_03v3 ad=0 pd=0 as=0 ps=0 w=1.56u l=0.28u
X4555 VREFP A44_DCTRL_STRIP_W_R2_0/CTRL_OUT[5] A44_CDAC_CAP_BANK_ASSEMBLY_R8_M6_0/A44_CAP_CORE128_M6_R1_0/CAP_BOTTOM_090 VDD pfet_03v3 ad=0 pd=0 as=0 ps=0 w=1.56u l=0.28u
X4556 VREFN A44_DCTRL_STRIP_W_R2_0/CTRL_OUT[5] A44_CDAC_CAP_BANK_ASSEMBLY_R8_M6_0/A44_CAP_CORE128_M6_R1_0/CAP_BOTTOM_090 GND nfet_03v3 ad=0 pd=0 as=16.6842p ps=77.76u w=1.56u l=0.28u
X4557 VREFN A44_DCTRL_STRIP_W_R2_0/CTRL_OUT[5] A44_CDAC_CAP_BANK_ASSEMBLY_R8_M6_0/A44_CAP_CORE128_M6_R1_0/CAP_BOTTOM_090 GND nfet_03v3 ad=0 pd=0 as=0 ps=0 w=1.56u l=0.28u
X4558 VREFN A44_DCTRL_STRIP_W_R2_0/CTRL_OUT[5] A44_CDAC_CAP_BANK_ASSEMBLY_R8_M6_0/A44_CAP_CORE128_M6_R1_0/CAP_BOTTOM_090 GND nfet_03v3 ad=0 pd=0 as=0 ps=0 w=1.56u l=0.28u
X4559 VREFN A44_DCTRL_STRIP_W_R2_0/CTRL_OUT[5] A44_CDAC_CAP_BANK_ASSEMBLY_R8_M6_0/A44_CAP_CORE128_M6_R1_0/CAP_BOTTOM_090 GND nfet_03v3 ad=0 pd=0 as=0 ps=0 w=1.56u l=0.28u
X4560 VREFN A44_DCTRL_STRIP_W_R2_0/CTRL_OUT[5] A44_CDAC_CAP_BANK_ASSEMBLY_R8_M6_0/A44_CAP_CORE128_M6_R1_0/CAP_BOTTOM_090 GND nfet_03v3 ad=0 pd=0 as=0 ps=0 w=1.56u l=0.28u
X4561 VREFN A44_DCTRL_STRIP_W_R2_0/CTRL_OUT[5] A44_CDAC_CAP_BANK_ASSEMBLY_R8_M6_0/A44_CAP_CORE128_M6_R1_0/CAP_BOTTOM_090 GND nfet_03v3 ad=0 pd=0 as=0 ps=0 w=1.56u l=0.28u
X4562 VREFN A44_DCTRL_STRIP_W_R2_0/CTRL_OUT[5] A44_CDAC_CAP_BANK_ASSEMBLY_R8_M6_0/A44_CAP_CORE128_M6_R1_0/CAP_BOTTOM_090 GND nfet_03v3 ad=0 pd=0 as=0 ps=0 w=1.56u l=0.28u
X4563 VREFN A44_DCTRL_STRIP_W_R2_0/CTRL_OUT[5] A44_CDAC_CAP_BANK_ASSEMBLY_R8_M6_0/A44_CAP_CORE128_M6_R1_0/CAP_BOTTOM_090 GND nfet_03v3 ad=0 pd=0 as=0 ps=0 w=1.56u l=0.28u
X4564 VREFN A44_DCTRL_STRIP_W_R2_0/CTRL_OUT[5] A44_CDAC_CAP_BANK_ASSEMBLY_R8_M6_0/A44_CAP_CORE128_M6_R1_0/CAP_BOTTOM_090 GND nfet_03v3 ad=0 pd=0 as=0 ps=0 w=1.56u l=0.28u
X4565 VREFN A44_DCTRL_STRIP_W_R2_0/CTRL_OUT[5] A44_CDAC_CAP_BANK_ASSEMBLY_R8_M6_0/A44_CAP_CORE128_M6_R1_0/CAP_BOTTOM_090 GND nfet_03v3 ad=0 pd=0 as=0 ps=0 w=1.56u l=0.28u
X4566 VREFN A44_DCTRL_STRIP_W_R2_0/CTRL_OUT[5] A44_CDAC_CAP_BANK_ASSEMBLY_R8_M6_0/A44_CAP_CORE128_M6_R1_0/CAP_BOTTOM_090 GND nfet_03v3 ad=0 pd=0 as=0 ps=0 w=1.56u l=0.28u
X4567 VREFN A44_DCTRL_STRIP_W_R2_0/CTRL_OUT[5] A44_CDAC_CAP_BANK_ASSEMBLY_R8_M6_0/A44_CAP_CORE128_M6_R1_0/CAP_BOTTOM_090 GND nfet_03v3 ad=0 pd=0 as=0 ps=0 w=1.56u l=0.28u
X4568 VREFN A44_DCTRL_STRIP_W_R2_0/CTRL_OUT[5] A44_CDAC_CAP_BANK_ASSEMBLY_R8_M6_0/A44_CAP_CORE128_M6_R1_0/CAP_BOTTOM_090 GND nfet_03v3 ad=0 pd=0 as=0 ps=0 w=1.56u l=0.28u
X4569 VREFN A44_DCTRL_STRIP_W_R2_0/CTRL_OUT[5] A44_CDAC_CAP_BANK_ASSEMBLY_R8_M6_0/A44_CAP_CORE128_M6_R1_0/CAP_BOTTOM_090 GND nfet_03v3 ad=0 pd=0 as=0 ps=0 w=1.56u l=0.28u
X4570 VREFN A44_DCTRL_STRIP_W_R2_0/CTRL_OUT[5] A44_CDAC_CAP_BANK_ASSEMBLY_R8_M6_0/A44_CAP_CORE128_M6_R1_0/CAP_BOTTOM_090 GND nfet_03v3 ad=0 pd=0 as=0 ps=0 w=1.56u l=0.28u
X4571 VREFN A44_DCTRL_STRIP_W_R2_0/CTRL_OUT[5] A44_CDAC_CAP_BANK_ASSEMBLY_R8_M6_0/A44_CAP_CORE128_M6_R1_0/CAP_BOTTOM_090 GND nfet_03v3 ad=0 pd=0 as=0 ps=0 w=1.56u l=0.28u
X4572 VREFN A44_DCTRL_STRIP_W_R2_0/CTRL_OUT[5] A44_CDAC_CAP_BANK_ASSEMBLY_R8_M6_0/A44_CAP_CORE128_M6_R1_0/CAP_BOTTOM_090 GND nfet_03v3 ad=0 pd=0 as=0 ps=0 w=1.56u l=0.28u
X4573 VREFN A44_DCTRL_STRIP_W_R2_0/CTRL_OUT[5] A44_CDAC_CAP_BANK_ASSEMBLY_R8_M6_0/A44_CAP_CORE128_M6_R1_0/CAP_BOTTOM_090 GND nfet_03v3 ad=0 pd=0 as=0 ps=0 w=1.56u l=0.28u
X4574 VREFP A44_DCTRL_STRIP_W_R2_0/CTRL_OUT[7] A44_CDAC_CAP_BANK_ASSEMBLY_R8_M6_0/A44_CAP_CORE128_M6_R1_0/CAP_BOTTOM_103 VDD pfet_03v3 ad=0 pd=0 as=16.6842p ps=77.76u w=1.56u l=0.28u
X4575 VREFP A44_DCTRL_STRIP_W_R2_0/CTRL_OUT[7] A44_CDAC_CAP_BANK_ASSEMBLY_R8_M6_0/A44_CAP_CORE128_M6_R1_0/CAP_BOTTOM_103 VDD pfet_03v3 ad=0 pd=0 as=0 ps=0 w=1.56u l=0.28u
X4576 VREFP A44_DCTRL_STRIP_W_R2_0/CTRL_OUT[7] A44_CDAC_CAP_BANK_ASSEMBLY_R8_M6_0/A44_CAP_CORE128_M6_R1_0/CAP_BOTTOM_103 VDD pfet_03v3 ad=0 pd=0 as=0 ps=0 w=1.56u l=0.28u
X4577 VREFP A44_DCTRL_STRIP_W_R2_0/CTRL_OUT[7] A44_CDAC_CAP_BANK_ASSEMBLY_R8_M6_0/A44_CAP_CORE128_M6_R1_0/CAP_BOTTOM_103 VDD pfet_03v3 ad=0 pd=0 as=0 ps=0 w=1.56u l=0.28u
X4578 VREFP A44_DCTRL_STRIP_W_R2_0/CTRL_OUT[7] A44_CDAC_CAP_BANK_ASSEMBLY_R8_M6_0/A44_CAP_CORE128_M6_R1_0/CAP_BOTTOM_103 VDD pfet_03v3 ad=0 pd=0 as=0 ps=0 w=1.56u l=0.28u
X4579 VREFP A44_DCTRL_STRIP_W_R2_0/CTRL_OUT[7] A44_CDAC_CAP_BANK_ASSEMBLY_R8_M6_0/A44_CAP_CORE128_M6_R1_0/CAP_BOTTOM_103 VDD pfet_03v3 ad=0 pd=0 as=0 ps=0 w=1.56u l=0.28u
X4580 VREFP A44_DCTRL_STRIP_W_R2_0/CTRL_OUT[7] A44_CDAC_CAP_BANK_ASSEMBLY_R8_M6_0/A44_CAP_CORE128_M6_R1_0/CAP_BOTTOM_103 VDD pfet_03v3 ad=0 pd=0 as=0 ps=0 w=1.56u l=0.28u
X4581 VREFP A44_DCTRL_STRIP_W_R2_0/CTRL_OUT[7] A44_CDAC_CAP_BANK_ASSEMBLY_R8_M6_0/A44_CAP_CORE128_M6_R1_0/CAP_BOTTOM_103 VDD pfet_03v3 ad=0 pd=0 as=0 ps=0 w=1.56u l=0.28u
X4582 VREFP A44_DCTRL_STRIP_W_R2_0/CTRL_OUT[7] A44_CDAC_CAP_BANK_ASSEMBLY_R8_M6_0/A44_CAP_CORE128_M6_R1_0/CAP_BOTTOM_103 VDD pfet_03v3 ad=0 pd=0 as=0 ps=0 w=1.56u l=0.28u
X4583 VREFP A44_DCTRL_STRIP_W_R2_0/CTRL_OUT[7] A44_CDAC_CAP_BANK_ASSEMBLY_R8_M6_0/A44_CAP_CORE128_M6_R1_0/CAP_BOTTOM_103 VDD pfet_03v3 ad=0 pd=0 as=0 ps=0 w=1.56u l=0.28u
X4584 VREFP A44_DCTRL_STRIP_W_R2_0/CTRL_OUT[7] A44_CDAC_CAP_BANK_ASSEMBLY_R8_M6_0/A44_CAP_CORE128_M6_R1_0/CAP_BOTTOM_103 VDD pfet_03v3 ad=0 pd=0 as=0 ps=0 w=1.56u l=0.28u
X4585 VREFP A44_DCTRL_STRIP_W_R2_0/CTRL_OUT[7] A44_CDAC_CAP_BANK_ASSEMBLY_R8_M6_0/A44_CAP_CORE128_M6_R1_0/CAP_BOTTOM_103 VDD pfet_03v3 ad=0 pd=0 as=0 ps=0 w=1.56u l=0.28u
X4586 VREFP A44_DCTRL_STRIP_W_R2_0/CTRL_OUT[7] A44_CDAC_CAP_BANK_ASSEMBLY_R8_M6_0/A44_CAP_CORE128_M6_R1_0/CAP_BOTTOM_103 VDD pfet_03v3 ad=0 pd=0 as=0 ps=0 w=1.56u l=0.28u
X4587 VREFP A44_DCTRL_STRIP_W_R2_0/CTRL_OUT[7] A44_CDAC_CAP_BANK_ASSEMBLY_R8_M6_0/A44_CAP_CORE128_M6_R1_0/CAP_BOTTOM_103 VDD pfet_03v3 ad=0 pd=0 as=0 ps=0 w=1.56u l=0.28u
X4588 VREFP A44_DCTRL_STRIP_W_R2_0/CTRL_OUT[7] A44_CDAC_CAP_BANK_ASSEMBLY_R8_M6_0/A44_CAP_CORE128_M6_R1_0/CAP_BOTTOM_103 VDD pfet_03v3 ad=0 pd=0 as=0 ps=0 w=1.56u l=0.28u
X4589 VREFP A44_DCTRL_STRIP_W_R2_0/CTRL_OUT[7] A44_CDAC_CAP_BANK_ASSEMBLY_R8_M6_0/A44_CAP_CORE128_M6_R1_0/CAP_BOTTOM_103 VDD pfet_03v3 ad=0 pd=0 as=0 ps=0 w=1.56u l=0.28u
X4590 VREFP A44_DCTRL_STRIP_W_R2_0/CTRL_OUT[7] A44_CDAC_CAP_BANK_ASSEMBLY_R8_M6_0/A44_CAP_CORE128_M6_R1_0/CAP_BOTTOM_103 VDD pfet_03v3 ad=0 pd=0 as=0 ps=0 w=1.56u l=0.28u
X4591 VREFP A44_DCTRL_STRIP_W_R2_0/CTRL_OUT[7] A44_CDAC_CAP_BANK_ASSEMBLY_R8_M6_0/A44_CAP_CORE128_M6_R1_0/CAP_BOTTOM_103 VDD pfet_03v3 ad=0 pd=0 as=0 ps=0 w=1.56u l=0.28u
X4592 VREFN A44_DCTRL_STRIP_W_R2_0/CTRL_OUT[7] A44_CDAC_CAP_BANK_ASSEMBLY_R8_M6_0/A44_CAP_CORE128_M6_R1_0/CAP_BOTTOM_103 GND nfet_03v3 ad=0 pd=0 as=16.6842p ps=77.76u w=1.56u l=0.28u
X4593 VREFN A44_DCTRL_STRIP_W_R2_0/CTRL_OUT[7] A44_CDAC_CAP_BANK_ASSEMBLY_R8_M6_0/A44_CAP_CORE128_M6_R1_0/CAP_BOTTOM_103 GND nfet_03v3 ad=0 pd=0 as=0 ps=0 w=1.56u l=0.28u
X4594 VREFN A44_DCTRL_STRIP_W_R2_0/CTRL_OUT[7] A44_CDAC_CAP_BANK_ASSEMBLY_R8_M6_0/A44_CAP_CORE128_M6_R1_0/CAP_BOTTOM_103 GND nfet_03v3 ad=0 pd=0 as=0 ps=0 w=1.56u l=0.28u
X4595 VREFN A44_DCTRL_STRIP_W_R2_0/CTRL_OUT[7] A44_CDAC_CAP_BANK_ASSEMBLY_R8_M6_0/A44_CAP_CORE128_M6_R1_0/CAP_BOTTOM_103 GND nfet_03v3 ad=0 pd=0 as=0 ps=0 w=1.56u l=0.28u
X4596 VREFN A44_DCTRL_STRIP_W_R2_0/CTRL_OUT[7] A44_CDAC_CAP_BANK_ASSEMBLY_R8_M6_0/A44_CAP_CORE128_M6_R1_0/CAP_BOTTOM_103 GND nfet_03v3 ad=0 pd=0 as=0 ps=0 w=1.56u l=0.28u
X4597 VREFN A44_DCTRL_STRIP_W_R2_0/CTRL_OUT[7] A44_CDAC_CAP_BANK_ASSEMBLY_R8_M6_0/A44_CAP_CORE128_M6_R1_0/CAP_BOTTOM_103 GND nfet_03v3 ad=0 pd=0 as=0 ps=0 w=1.56u l=0.28u
X4598 VREFN A44_DCTRL_STRIP_W_R2_0/CTRL_OUT[7] A44_CDAC_CAP_BANK_ASSEMBLY_R8_M6_0/A44_CAP_CORE128_M6_R1_0/CAP_BOTTOM_103 GND nfet_03v3 ad=0 pd=0 as=0 ps=0 w=1.56u l=0.28u
X4599 VREFN A44_DCTRL_STRIP_W_R2_0/CTRL_OUT[7] A44_CDAC_CAP_BANK_ASSEMBLY_R8_M6_0/A44_CAP_CORE128_M6_R1_0/CAP_BOTTOM_103 GND nfet_03v3 ad=0 pd=0 as=0 ps=0 w=1.56u l=0.28u
X4600 VREFN A44_DCTRL_STRIP_W_R2_0/CTRL_OUT[7] A44_CDAC_CAP_BANK_ASSEMBLY_R8_M6_0/A44_CAP_CORE128_M6_R1_0/CAP_BOTTOM_103 GND nfet_03v3 ad=0 pd=0 as=0 ps=0 w=1.56u l=0.28u
X4601 VREFN A44_DCTRL_STRIP_W_R2_0/CTRL_OUT[7] A44_CDAC_CAP_BANK_ASSEMBLY_R8_M6_0/A44_CAP_CORE128_M6_R1_0/CAP_BOTTOM_103 GND nfet_03v3 ad=0 pd=0 as=0 ps=0 w=1.56u l=0.28u
X4602 VREFN A44_DCTRL_STRIP_W_R2_0/CTRL_OUT[7] A44_CDAC_CAP_BANK_ASSEMBLY_R8_M6_0/A44_CAP_CORE128_M6_R1_0/CAP_BOTTOM_103 GND nfet_03v3 ad=0 pd=0 as=0 ps=0 w=1.56u l=0.28u
X4603 VREFN A44_DCTRL_STRIP_W_R2_0/CTRL_OUT[7] A44_CDAC_CAP_BANK_ASSEMBLY_R8_M6_0/A44_CAP_CORE128_M6_R1_0/CAP_BOTTOM_103 GND nfet_03v3 ad=0 pd=0 as=0 ps=0 w=1.56u l=0.28u
X4604 VREFN A44_DCTRL_STRIP_W_R2_0/CTRL_OUT[7] A44_CDAC_CAP_BANK_ASSEMBLY_R8_M6_0/A44_CAP_CORE128_M6_R1_0/CAP_BOTTOM_103 GND nfet_03v3 ad=0 pd=0 as=0 ps=0 w=1.56u l=0.28u
X4605 VREFN A44_DCTRL_STRIP_W_R2_0/CTRL_OUT[7] A44_CDAC_CAP_BANK_ASSEMBLY_R8_M6_0/A44_CAP_CORE128_M6_R1_0/CAP_BOTTOM_103 GND nfet_03v3 ad=0 pd=0 as=0 ps=0 w=1.56u l=0.28u
X4606 VREFN A44_DCTRL_STRIP_W_R2_0/CTRL_OUT[7] A44_CDAC_CAP_BANK_ASSEMBLY_R8_M6_0/A44_CAP_CORE128_M6_R1_0/CAP_BOTTOM_103 GND nfet_03v3 ad=0 pd=0 as=0 ps=0 w=1.56u l=0.28u
X4607 VREFN A44_DCTRL_STRIP_W_R2_0/CTRL_OUT[7] A44_CDAC_CAP_BANK_ASSEMBLY_R8_M6_0/A44_CAP_CORE128_M6_R1_0/CAP_BOTTOM_103 GND nfet_03v3 ad=0 pd=0 as=0 ps=0 w=1.56u l=0.28u
X4608 VREFN A44_DCTRL_STRIP_W_R2_0/CTRL_OUT[7] A44_CDAC_CAP_BANK_ASSEMBLY_R8_M6_0/A44_CAP_CORE128_M6_R1_0/CAP_BOTTOM_103 GND nfet_03v3 ad=0 pd=0 as=0 ps=0 w=1.56u l=0.28u
X4609 VREFN A44_DCTRL_STRIP_W_R2_0/CTRL_OUT[7] A44_CDAC_CAP_BANK_ASSEMBLY_R8_M6_0/A44_CAP_CORE128_M6_R1_0/CAP_BOTTOM_103 GND nfet_03v3 ad=0 pd=0 as=0 ps=0 w=1.56u l=0.28u
X4610 VREFP A44_DCTRL_STRIP_W_R2_0/CTRL_OUT[7] A44_CDAC_CAP_BANK_ASSEMBLY_R8_M6_0/A44_CAP_CORE128_M6_R1_0/CAP_BOTTOM_074 VDD pfet_03v3 ad=0 pd=0 as=16.6842p ps=77.76u w=1.56u l=0.28u
X4611 VREFP A44_DCTRL_STRIP_W_R2_0/CTRL_OUT[7] A44_CDAC_CAP_BANK_ASSEMBLY_R8_M6_0/A44_CAP_CORE128_M6_R1_0/CAP_BOTTOM_074 VDD pfet_03v3 ad=0 pd=0 as=0 ps=0 w=1.56u l=0.28u
X4612 VREFP A44_DCTRL_STRIP_W_R2_0/CTRL_OUT[7] A44_CDAC_CAP_BANK_ASSEMBLY_R8_M6_0/A44_CAP_CORE128_M6_R1_0/CAP_BOTTOM_074 VDD pfet_03v3 ad=0 pd=0 as=0 ps=0 w=1.56u l=0.28u
X4613 VREFP A44_DCTRL_STRIP_W_R2_0/CTRL_OUT[7] A44_CDAC_CAP_BANK_ASSEMBLY_R8_M6_0/A44_CAP_CORE128_M6_R1_0/CAP_BOTTOM_074 VDD pfet_03v3 ad=0 pd=0 as=0 ps=0 w=1.56u l=0.28u
X4614 VREFP A44_DCTRL_STRIP_W_R2_0/CTRL_OUT[7] A44_CDAC_CAP_BANK_ASSEMBLY_R8_M6_0/A44_CAP_CORE128_M6_R1_0/CAP_BOTTOM_074 VDD pfet_03v3 ad=0 pd=0 as=0 ps=0 w=1.56u l=0.28u
X4615 VREFP A44_DCTRL_STRIP_W_R2_0/CTRL_OUT[7] A44_CDAC_CAP_BANK_ASSEMBLY_R8_M6_0/A44_CAP_CORE128_M6_R1_0/CAP_BOTTOM_074 VDD pfet_03v3 ad=0 pd=0 as=0 ps=0 w=1.56u l=0.28u
X4616 VREFP A44_DCTRL_STRIP_W_R2_0/CTRL_OUT[7] A44_CDAC_CAP_BANK_ASSEMBLY_R8_M6_0/A44_CAP_CORE128_M6_R1_0/CAP_BOTTOM_074 VDD pfet_03v3 ad=0 pd=0 as=0 ps=0 w=1.56u l=0.28u
X4617 VREFP A44_DCTRL_STRIP_W_R2_0/CTRL_OUT[7] A44_CDAC_CAP_BANK_ASSEMBLY_R8_M6_0/A44_CAP_CORE128_M6_R1_0/CAP_BOTTOM_074 VDD pfet_03v3 ad=0 pd=0 as=0 ps=0 w=1.56u l=0.28u
X4618 VREFP A44_DCTRL_STRIP_W_R2_0/CTRL_OUT[7] A44_CDAC_CAP_BANK_ASSEMBLY_R8_M6_0/A44_CAP_CORE128_M6_R1_0/CAP_BOTTOM_074 VDD pfet_03v3 ad=0 pd=0 as=0 ps=0 w=1.56u l=0.28u
X4619 VREFP A44_DCTRL_STRIP_W_R2_0/CTRL_OUT[7] A44_CDAC_CAP_BANK_ASSEMBLY_R8_M6_0/A44_CAP_CORE128_M6_R1_0/CAP_BOTTOM_074 VDD pfet_03v3 ad=0 pd=0 as=0 ps=0 w=1.56u l=0.28u
X4620 VREFP A44_DCTRL_STRIP_W_R2_0/CTRL_OUT[7] A44_CDAC_CAP_BANK_ASSEMBLY_R8_M6_0/A44_CAP_CORE128_M6_R1_0/CAP_BOTTOM_074 VDD pfet_03v3 ad=0 pd=0 as=0 ps=0 w=1.56u l=0.28u
X4621 VREFP A44_DCTRL_STRIP_W_R2_0/CTRL_OUT[7] A44_CDAC_CAP_BANK_ASSEMBLY_R8_M6_0/A44_CAP_CORE128_M6_R1_0/CAP_BOTTOM_074 VDD pfet_03v3 ad=0 pd=0 as=0 ps=0 w=1.56u l=0.28u
X4622 VREFP A44_DCTRL_STRIP_W_R2_0/CTRL_OUT[7] A44_CDAC_CAP_BANK_ASSEMBLY_R8_M6_0/A44_CAP_CORE128_M6_R1_0/CAP_BOTTOM_074 VDD pfet_03v3 ad=0 pd=0 as=0 ps=0 w=1.56u l=0.28u
X4623 VREFP A44_DCTRL_STRIP_W_R2_0/CTRL_OUT[7] A44_CDAC_CAP_BANK_ASSEMBLY_R8_M6_0/A44_CAP_CORE128_M6_R1_0/CAP_BOTTOM_074 VDD pfet_03v3 ad=0 pd=0 as=0 ps=0 w=1.56u l=0.28u
X4624 VREFP A44_DCTRL_STRIP_W_R2_0/CTRL_OUT[7] A44_CDAC_CAP_BANK_ASSEMBLY_R8_M6_0/A44_CAP_CORE128_M6_R1_0/CAP_BOTTOM_074 VDD pfet_03v3 ad=0 pd=0 as=0 ps=0 w=1.56u l=0.28u
X4625 VREFP A44_DCTRL_STRIP_W_R2_0/CTRL_OUT[7] A44_CDAC_CAP_BANK_ASSEMBLY_R8_M6_0/A44_CAP_CORE128_M6_R1_0/CAP_BOTTOM_074 VDD pfet_03v3 ad=0 pd=0 as=0 ps=0 w=1.56u l=0.28u
X4626 VREFP A44_DCTRL_STRIP_W_R2_0/CTRL_OUT[7] A44_CDAC_CAP_BANK_ASSEMBLY_R8_M6_0/A44_CAP_CORE128_M6_R1_0/CAP_BOTTOM_074 VDD pfet_03v3 ad=0 pd=0 as=0 ps=0 w=1.56u l=0.28u
X4627 VREFP A44_DCTRL_STRIP_W_R2_0/CTRL_OUT[7] A44_CDAC_CAP_BANK_ASSEMBLY_R8_M6_0/A44_CAP_CORE128_M6_R1_0/CAP_BOTTOM_074 VDD pfet_03v3 ad=0 pd=0 as=0 ps=0 w=1.56u l=0.28u
X4628 VREFN A44_DCTRL_STRIP_W_R2_0/CTRL_OUT[7] A44_CDAC_CAP_BANK_ASSEMBLY_R8_M6_0/A44_CAP_CORE128_M6_R1_0/CAP_BOTTOM_074 GND nfet_03v3 ad=0 pd=0 as=16.6842p ps=77.76u w=1.56u l=0.28u
X4629 VREFN A44_DCTRL_STRIP_W_R2_0/CTRL_OUT[7] A44_CDAC_CAP_BANK_ASSEMBLY_R8_M6_0/A44_CAP_CORE128_M6_R1_0/CAP_BOTTOM_074 GND nfet_03v3 ad=0 pd=0 as=0 ps=0 w=1.56u l=0.28u
X4630 VREFN A44_DCTRL_STRIP_W_R2_0/CTRL_OUT[7] A44_CDAC_CAP_BANK_ASSEMBLY_R8_M6_0/A44_CAP_CORE128_M6_R1_0/CAP_BOTTOM_074 GND nfet_03v3 ad=0 pd=0 as=0 ps=0 w=1.56u l=0.28u
X4631 VREFN A44_DCTRL_STRIP_W_R2_0/CTRL_OUT[7] A44_CDAC_CAP_BANK_ASSEMBLY_R8_M6_0/A44_CAP_CORE128_M6_R1_0/CAP_BOTTOM_074 GND nfet_03v3 ad=0 pd=0 as=0 ps=0 w=1.56u l=0.28u
X4632 VREFN A44_DCTRL_STRIP_W_R2_0/CTRL_OUT[7] A44_CDAC_CAP_BANK_ASSEMBLY_R8_M6_0/A44_CAP_CORE128_M6_R1_0/CAP_BOTTOM_074 GND nfet_03v3 ad=0 pd=0 as=0 ps=0 w=1.56u l=0.28u
X4633 VREFN A44_DCTRL_STRIP_W_R2_0/CTRL_OUT[7] A44_CDAC_CAP_BANK_ASSEMBLY_R8_M6_0/A44_CAP_CORE128_M6_R1_0/CAP_BOTTOM_074 GND nfet_03v3 ad=0 pd=0 as=0 ps=0 w=1.56u l=0.28u
X4634 VREFN A44_DCTRL_STRIP_W_R2_0/CTRL_OUT[7] A44_CDAC_CAP_BANK_ASSEMBLY_R8_M6_0/A44_CAP_CORE128_M6_R1_0/CAP_BOTTOM_074 GND nfet_03v3 ad=0 pd=0 as=0 ps=0 w=1.56u l=0.28u
X4635 VREFN A44_DCTRL_STRIP_W_R2_0/CTRL_OUT[7] A44_CDAC_CAP_BANK_ASSEMBLY_R8_M6_0/A44_CAP_CORE128_M6_R1_0/CAP_BOTTOM_074 GND nfet_03v3 ad=0 pd=0 as=0 ps=0 w=1.56u l=0.28u
X4636 VREFN A44_DCTRL_STRIP_W_R2_0/CTRL_OUT[7] A44_CDAC_CAP_BANK_ASSEMBLY_R8_M6_0/A44_CAP_CORE128_M6_R1_0/CAP_BOTTOM_074 GND nfet_03v3 ad=0 pd=0 as=0 ps=0 w=1.56u l=0.28u
X4637 VREFN A44_DCTRL_STRIP_W_R2_0/CTRL_OUT[7] A44_CDAC_CAP_BANK_ASSEMBLY_R8_M6_0/A44_CAP_CORE128_M6_R1_0/CAP_BOTTOM_074 GND nfet_03v3 ad=0 pd=0 as=0 ps=0 w=1.56u l=0.28u
X4638 VREFN A44_DCTRL_STRIP_W_R2_0/CTRL_OUT[7] A44_CDAC_CAP_BANK_ASSEMBLY_R8_M6_0/A44_CAP_CORE128_M6_R1_0/CAP_BOTTOM_074 GND nfet_03v3 ad=0 pd=0 as=0 ps=0 w=1.56u l=0.28u
X4639 VREFN A44_DCTRL_STRIP_W_R2_0/CTRL_OUT[7] A44_CDAC_CAP_BANK_ASSEMBLY_R8_M6_0/A44_CAP_CORE128_M6_R1_0/CAP_BOTTOM_074 GND nfet_03v3 ad=0 pd=0 as=0 ps=0 w=1.56u l=0.28u
X4640 VREFN A44_DCTRL_STRIP_W_R2_0/CTRL_OUT[7] A44_CDAC_CAP_BANK_ASSEMBLY_R8_M6_0/A44_CAP_CORE128_M6_R1_0/CAP_BOTTOM_074 GND nfet_03v3 ad=0 pd=0 as=0 ps=0 w=1.56u l=0.28u
X4641 VREFN A44_DCTRL_STRIP_W_R2_0/CTRL_OUT[7] A44_CDAC_CAP_BANK_ASSEMBLY_R8_M6_0/A44_CAP_CORE128_M6_R1_0/CAP_BOTTOM_074 GND nfet_03v3 ad=0 pd=0 as=0 ps=0 w=1.56u l=0.28u
X4642 VREFN A44_DCTRL_STRIP_W_R2_0/CTRL_OUT[7] A44_CDAC_CAP_BANK_ASSEMBLY_R8_M6_0/A44_CAP_CORE128_M6_R1_0/CAP_BOTTOM_074 GND nfet_03v3 ad=0 pd=0 as=0 ps=0 w=1.56u l=0.28u
X4643 VREFN A44_DCTRL_STRIP_W_R2_0/CTRL_OUT[7] A44_CDAC_CAP_BANK_ASSEMBLY_R8_M6_0/A44_CAP_CORE128_M6_R1_0/CAP_BOTTOM_074 GND nfet_03v3 ad=0 pd=0 as=0 ps=0 w=1.56u l=0.28u
X4644 VREFN A44_DCTRL_STRIP_W_R2_0/CTRL_OUT[7] A44_CDAC_CAP_BANK_ASSEMBLY_R8_M6_0/A44_CAP_CORE128_M6_R1_0/CAP_BOTTOM_074 GND nfet_03v3 ad=0 pd=0 as=0 ps=0 w=1.56u l=0.28u
X4645 VREFN A44_DCTRL_STRIP_W_R2_0/CTRL_OUT[7] A44_CDAC_CAP_BANK_ASSEMBLY_R8_M6_0/A44_CAP_CORE128_M6_R1_0/CAP_BOTTOM_074 GND nfet_03v3 ad=0 pd=0 as=0 ps=0 w=1.56u l=0.28u
X4646 VTOP A44_CDAC_CAP_BANK_ASSEMBLY_R8_M6_0/A44_CAP_CORE128_M6_R1_0/CAP_BOTTOM_093 cap_mim_2f0_m4m5_noshield c_width=6.855u c_length=6.855u
X4647 VTOP A44_CDAC_CAP_BANK_ASSEMBLY_R8_M6_0/A44_CAP_CORE128_M6_R1_0/CAP_BOTTOM_093 cap_mim_2f0_m4m5_noshield c_width=6.855u c_length=6.855u
X4648 VTOP A44_CDAC_CAP_BANK_ASSEMBLY_R8_M6_0/A44_CAP_CORE128_M6_R1_0/CAP_BOTTOM_093 cap_mim_2f0_m4m5_noshield c_width=6.855u c_length=6.855u
X4649 VTOP A44_CDAC_CAP_BANK_ASSEMBLY_R8_M6_0/A44_CAP_CORE128_M6_R1_0/CAP_BOTTOM_093 cap_mim_2f0_m4m5_noshield c_width=6.855u c_length=6.855u
X4650 VTOP A44_CDAC_CAP_BANK_ASSEMBLY_R8_M6_0/A44_CAP_CORE128_M6_R1_0/CAP_BOTTOM_093 cap_mim_2f0_m4m5_noshield c_width=6.855u c_length=6.855u
X4651 VTOP A44_CDAC_CAP_BANK_ASSEMBLY_R8_M6_0/A44_CAP_CORE128_M6_R1_0/CAP_BOTTOM_093 cap_mim_2f0_m4m5_noshield c_width=6.855u c_length=6.855u
X4652 VTOP A44_CDAC_CAP_BANK_ASSEMBLY_R8_M6_0/A44_CAP_CORE128_M6_R1_0/CAP_BOTTOM_112 cap_mim_2f0_m4m5_noshield c_width=6.855u c_length=6.855u
X4653 VTOP A44_CDAC_CAP_BANK_ASSEMBLY_R8_M6_0/A44_CAP_CORE128_M6_R1_0/CAP_BOTTOM_112 cap_mim_2f0_m4m5_noshield c_width=6.855u c_length=6.855u
X4654 VTOP A44_CDAC_CAP_BANK_ASSEMBLY_R8_M6_0/A44_CAP_CORE128_M6_R1_0/CAP_BOTTOM_112 cap_mim_2f0_m4m5_noshield c_width=6.855u c_length=6.855u
X4655 VTOP A44_CDAC_CAP_BANK_ASSEMBLY_R8_M6_0/A44_CAP_CORE128_M6_R1_0/CAP_BOTTOM_112 cap_mim_2f0_m4m5_noshield c_width=6.855u c_length=6.855u
X4656 VTOP A44_CDAC_CAP_BANK_ASSEMBLY_R8_M6_0/A44_CAP_CORE128_M6_R1_0/CAP_BOTTOM_112 cap_mim_2f0_m4m5_noshield c_width=6.855u c_length=6.855u
X4657 VTOP A44_CDAC_CAP_BANK_ASSEMBLY_R8_M6_0/A44_CAP_CORE128_M6_R1_0/CAP_BOTTOM_112 cap_mim_2f0_m4m5_noshield c_width=6.855u c_length=6.855u
X4658 VTOP A44_CDAC_CAP_BANK_ASSEMBLY_R8_M6_0/A44_CAP_CORE128_M6_R1_0/CAP_BOTTOM_110 cap_mim_2f0_m4m5_noshield c_width=6.855u c_length=6.855u
X4659 VTOP A44_CDAC_CAP_BANK_ASSEMBLY_R8_M6_0/A44_CAP_CORE128_M6_R1_0/CAP_BOTTOM_110 cap_mim_2f0_m4m5_noshield c_width=6.855u c_length=6.855u
X4660 VTOP A44_CDAC_CAP_BANK_ASSEMBLY_R8_M6_0/A44_CAP_CORE128_M6_R1_0/CAP_BOTTOM_110 cap_mim_2f0_m4m5_noshield c_width=6.855u c_length=6.855u
X4661 VTOP A44_CDAC_CAP_BANK_ASSEMBLY_R8_M6_0/A44_CAP_CORE128_M6_R1_0/CAP_BOTTOM_110 cap_mim_2f0_m4m5_noshield c_width=6.855u c_length=6.855u
X4662 VTOP A44_CDAC_CAP_BANK_ASSEMBLY_R8_M6_0/A44_CAP_CORE128_M6_R1_0/CAP_BOTTOM_110 cap_mim_2f0_m4m5_noshield c_width=6.855u c_length=6.855u
X4663 VTOP A44_CDAC_CAP_BANK_ASSEMBLY_R8_M6_0/A44_CAP_CORE128_M6_R1_0/CAP_BOTTOM_110 cap_mim_2f0_m4m5_noshield c_width=6.855u c_length=6.855u
X4664 VTOP A44_CDAC_CAP_BANK_ASSEMBLY_R8_M6_0/A44_CAP_CORE128_M6_R1_0/CAP_BOTTOM_085 cap_mim_2f0_m4m5_noshield c_width=6.855u c_length=6.855u
X4665 VTOP A44_CDAC_CAP_BANK_ASSEMBLY_R8_M6_0/A44_CAP_CORE128_M6_R1_0/CAP_BOTTOM_085 cap_mim_2f0_m4m5_noshield c_width=6.855u c_length=6.855u
X4666 VTOP A44_CDAC_CAP_BANK_ASSEMBLY_R8_M6_0/A44_CAP_CORE128_M6_R1_0/CAP_BOTTOM_085 cap_mim_2f0_m4m5_noshield c_width=6.855u c_length=6.855u
X4667 VTOP A44_CDAC_CAP_BANK_ASSEMBLY_R8_M6_0/A44_CAP_CORE128_M6_R1_0/CAP_BOTTOM_085 cap_mim_2f0_m4m5_noshield c_width=6.855u c_length=6.855u
X4668 VTOP A44_CDAC_CAP_BANK_ASSEMBLY_R8_M6_0/A44_CAP_CORE128_M6_R1_0/CAP_BOTTOM_085 cap_mim_2f0_m4m5_noshield c_width=6.855u c_length=6.855u
X4669 VTOP A44_CDAC_CAP_BANK_ASSEMBLY_R8_M6_0/A44_CAP_CORE128_M6_R1_0/CAP_BOTTOM_085 cap_mim_2f0_m4m5_noshield c_width=6.855u c_length=6.855u
X4670 VTOP A44_CDAC_CAP_BANK_ASSEMBLY_R8_M6_0/A44_CAP_CORE128_M6_R1_0/CAP_BOTTOM_075 cap_mim_2f0_m4m5_noshield c_width=6.855u c_length=6.855u
X4671 VTOP A44_CDAC_CAP_BANK_ASSEMBLY_R8_M6_0/A44_CAP_CORE128_M6_R1_0/CAP_BOTTOM_075 cap_mim_2f0_m4m5_noshield c_width=6.855u c_length=6.855u
X4672 VTOP A44_CDAC_CAP_BANK_ASSEMBLY_R8_M6_0/A44_CAP_CORE128_M6_R1_0/CAP_BOTTOM_075 cap_mim_2f0_m4m5_noshield c_width=6.855u c_length=6.855u
X4673 VTOP A44_CDAC_CAP_BANK_ASSEMBLY_R8_M6_0/A44_CAP_CORE128_M6_R1_0/CAP_BOTTOM_075 cap_mim_2f0_m4m5_noshield c_width=6.855u c_length=6.855u
X4674 VTOP A44_CDAC_CAP_BANK_ASSEMBLY_R8_M6_0/A44_CAP_CORE128_M6_R1_0/CAP_BOTTOM_075 cap_mim_2f0_m4m5_noshield c_width=6.855u c_length=6.855u
X4675 VTOP A44_CDAC_CAP_BANK_ASSEMBLY_R8_M6_0/A44_CAP_CORE128_M6_R1_0/CAP_BOTTOM_075 cap_mim_2f0_m4m5_noshield c_width=6.855u c_length=6.855u
X4676 VTOP A44_CDAC_CAP_BANK_ASSEMBLY_R8_M6_0/A44_CAP_CORE128_M6_R1_0/CAP_BOTTOM_111 cap_mim_2f0_m4m5_noshield c_width=6.855u c_length=6.855u
X4677 VTOP A44_CDAC_CAP_BANK_ASSEMBLY_R8_M6_0/A44_CAP_CORE128_M6_R1_0/CAP_BOTTOM_111 cap_mim_2f0_m4m5_noshield c_width=6.855u c_length=6.855u
X4678 VTOP A44_CDAC_CAP_BANK_ASSEMBLY_R8_M6_0/A44_CAP_CORE128_M6_R1_0/CAP_BOTTOM_111 cap_mim_2f0_m4m5_noshield c_width=6.855u c_length=6.855u
X4679 VTOP A44_CDAC_CAP_BANK_ASSEMBLY_R8_M6_0/A44_CAP_CORE128_M6_R1_0/CAP_BOTTOM_111 cap_mim_2f0_m4m5_noshield c_width=6.855u c_length=6.855u
X4680 VTOP A44_CDAC_CAP_BANK_ASSEMBLY_R8_M6_0/A44_CAP_CORE128_M6_R1_0/CAP_BOTTOM_111 cap_mim_2f0_m4m5_noshield c_width=6.855u c_length=6.855u
X4681 VTOP A44_CDAC_CAP_BANK_ASSEMBLY_R8_M6_0/A44_CAP_CORE128_M6_R1_0/CAP_BOTTOM_111 cap_mim_2f0_m4m5_noshield c_width=6.855u c_length=6.855u
X4682 VTOP A44_CDAC_CAP_BANK_ASSEMBLY_R8_M6_0/A44_CAP_CORE128_M6_R1_0/CAP_BOTTOM_109 cap_mim_2f0_m4m5_noshield c_width=6.855u c_length=6.855u
X4683 VTOP A44_CDAC_CAP_BANK_ASSEMBLY_R8_M6_0/A44_CAP_CORE128_M6_R1_0/CAP_BOTTOM_109 cap_mim_2f0_m4m5_noshield c_width=6.855u c_length=6.855u
X4684 VTOP A44_CDAC_CAP_BANK_ASSEMBLY_R8_M6_0/A44_CAP_CORE128_M6_R1_0/CAP_BOTTOM_109 cap_mim_2f0_m4m5_noshield c_width=6.855u c_length=6.855u
X4685 VTOP A44_CDAC_CAP_BANK_ASSEMBLY_R8_M6_0/A44_CAP_CORE128_M6_R1_0/CAP_BOTTOM_109 cap_mim_2f0_m4m5_noshield c_width=6.855u c_length=6.855u
X4686 VTOP A44_CDAC_CAP_BANK_ASSEMBLY_R8_M6_0/A44_CAP_CORE128_M6_R1_0/CAP_BOTTOM_109 cap_mim_2f0_m4m5_noshield c_width=6.855u c_length=6.855u
X4687 VTOP A44_CDAC_CAP_BANK_ASSEMBLY_R8_M6_0/A44_CAP_CORE128_M6_R1_0/CAP_BOTTOM_109 cap_mim_2f0_m4m5_noshield c_width=6.855u c_length=6.855u
X4688 VTOP A44_CDAC_CAP_BANK_ASSEMBLY_R8_M6_0/A44_CAP_CORE128_M6_R1_0/CAP_BOTTOM_074 cap_mim_2f0_m4m5_noshield c_width=6.855u c_length=6.855u
X4689 VTOP A44_CDAC_CAP_BANK_ASSEMBLY_R8_M6_0/A44_CAP_CORE128_M6_R1_0/CAP_BOTTOM_074 cap_mim_2f0_m4m5_noshield c_width=6.855u c_length=6.855u
X4690 VTOP A44_CDAC_CAP_BANK_ASSEMBLY_R8_M6_0/A44_CAP_CORE128_M6_R1_0/CAP_BOTTOM_074 cap_mim_2f0_m4m5_noshield c_width=6.855u c_length=6.855u
X4691 VTOP A44_CDAC_CAP_BANK_ASSEMBLY_R8_M6_0/A44_CAP_CORE128_M6_R1_0/CAP_BOTTOM_074 cap_mim_2f0_m4m5_noshield c_width=6.855u c_length=6.855u
X4692 VTOP A44_CDAC_CAP_BANK_ASSEMBLY_R8_M6_0/A44_CAP_CORE128_M6_R1_0/CAP_BOTTOM_074 cap_mim_2f0_m4m5_noshield c_width=6.855u c_length=6.855u
X4693 VTOP A44_CDAC_CAP_BANK_ASSEMBLY_R8_M6_0/A44_CAP_CORE128_M6_R1_0/CAP_BOTTOM_074 cap_mim_2f0_m4m5_noshield c_width=6.855u c_length=6.855u
X4694 VTOP A44_CDAC_CAP_BANK_ASSEMBLY_R8_M6_0/A44_CAP_CORE128_M6_R1_0/CAP_BOTTOM_108 cap_mim_2f0_m4m5_noshield c_width=6.855u c_length=6.855u
X4695 VTOP A44_CDAC_CAP_BANK_ASSEMBLY_R8_M6_0/A44_CAP_CORE128_M6_R1_0/CAP_BOTTOM_108 cap_mim_2f0_m4m5_noshield c_width=6.855u c_length=6.855u
X4696 VTOP A44_CDAC_CAP_BANK_ASSEMBLY_R8_M6_0/A44_CAP_CORE128_M6_R1_0/CAP_BOTTOM_108 cap_mim_2f0_m4m5_noshield c_width=6.855u c_length=6.855u
X4697 VTOP A44_CDAC_CAP_BANK_ASSEMBLY_R8_M6_0/A44_CAP_CORE128_M6_R1_0/CAP_BOTTOM_108 cap_mim_2f0_m4m5_noshield c_width=6.855u c_length=6.855u
X4698 VTOP A44_CDAC_CAP_BANK_ASSEMBLY_R8_M6_0/A44_CAP_CORE128_M6_R1_0/CAP_BOTTOM_108 cap_mim_2f0_m4m5_noshield c_width=6.855u c_length=6.855u
X4699 VTOP A44_CDAC_CAP_BANK_ASSEMBLY_R8_M6_0/A44_CAP_CORE128_M6_R1_0/CAP_BOTTOM_108 cap_mim_2f0_m4m5_noshield c_width=6.855u c_length=6.855u
X4700 VTOP A44_CDAC_CAP_BANK_ASSEMBLY_R8_M6_0/A44_CAP_CORE128_M6_R1_0/CAP_BOTTOM_073 cap_mim_2f0_m4m5_noshield c_width=6.855u c_length=6.855u
X4701 VTOP A44_CDAC_CAP_BANK_ASSEMBLY_R8_M6_0/A44_CAP_CORE128_M6_R1_0/CAP_BOTTOM_073 cap_mim_2f0_m4m5_noshield c_width=6.855u c_length=6.855u
X4702 VTOP A44_CDAC_CAP_BANK_ASSEMBLY_R8_M6_0/A44_CAP_CORE128_M6_R1_0/CAP_BOTTOM_073 cap_mim_2f0_m4m5_noshield c_width=6.855u c_length=6.855u
X4703 VTOP A44_CDAC_CAP_BANK_ASSEMBLY_R8_M6_0/A44_CAP_CORE128_M6_R1_0/CAP_BOTTOM_073 cap_mim_2f0_m4m5_noshield c_width=6.855u c_length=6.855u
X4704 VTOP A44_CDAC_CAP_BANK_ASSEMBLY_R8_M6_0/A44_CAP_CORE128_M6_R1_0/CAP_BOTTOM_073 cap_mim_2f0_m4m5_noshield c_width=6.855u c_length=6.855u
X4705 VTOP A44_CDAC_CAP_BANK_ASSEMBLY_R8_M6_0/A44_CAP_CORE128_M6_R1_0/CAP_BOTTOM_073 cap_mim_2f0_m4m5_noshield c_width=6.855u c_length=6.855u
X4706 VTOP A44_CDAC_CAP_BANK_ASSEMBLY_R8_M6_0/A44_CAP_CORE128_M6_R1_0/CAP_BOTTOM_107 cap_mim_2f0_m4m5_noshield c_width=6.855u c_length=6.855u
X4707 VTOP A44_CDAC_CAP_BANK_ASSEMBLY_R8_M6_0/A44_CAP_CORE128_M6_R1_0/CAP_BOTTOM_107 cap_mim_2f0_m4m5_noshield c_width=6.855u c_length=6.855u
X4708 VTOP A44_CDAC_CAP_BANK_ASSEMBLY_R8_M6_0/A44_CAP_CORE128_M6_R1_0/CAP_BOTTOM_107 cap_mim_2f0_m4m5_noshield c_width=6.855u c_length=6.855u
X4709 VTOP A44_CDAC_CAP_BANK_ASSEMBLY_R8_M6_0/A44_CAP_CORE128_M6_R1_0/CAP_BOTTOM_107 cap_mim_2f0_m4m5_noshield c_width=6.855u c_length=6.855u
X4710 VTOP A44_CDAC_CAP_BANK_ASSEMBLY_R8_M6_0/A44_CAP_CORE128_M6_R1_0/CAP_BOTTOM_107 cap_mim_2f0_m4m5_noshield c_width=6.855u c_length=6.855u
X4711 VTOP A44_CDAC_CAP_BANK_ASSEMBLY_R8_M6_0/A44_CAP_CORE128_M6_R1_0/CAP_BOTTOM_107 cap_mim_2f0_m4m5_noshield c_width=6.855u c_length=6.855u
X4712 VTOP A44_CDAC_CAP_BANK_ASSEMBLY_R8_M6_0/A44_CAP_CORE128_M6_R1_0/CAP_BOTTOM_015 cap_mim_2f0_m4m5_noshield c_width=6.855u c_length=6.855u
X4713 VTOP A44_CDAC_CAP_BANK_ASSEMBLY_R8_M6_0/A44_CAP_CORE128_M6_R1_0/CAP_BOTTOM_015 cap_mim_2f0_m4m5_noshield c_width=6.855u c_length=6.855u
X4714 VTOP A44_CDAC_CAP_BANK_ASSEMBLY_R8_M6_0/A44_CAP_CORE128_M6_R1_0/CAP_BOTTOM_015 cap_mim_2f0_m4m5_noshield c_width=6.855u c_length=6.855u
X4715 VTOP A44_CDAC_CAP_BANK_ASSEMBLY_R8_M6_0/A44_CAP_CORE128_M6_R1_0/CAP_BOTTOM_015 cap_mim_2f0_m4m5_noshield c_width=6.855u c_length=6.855u
X4716 VTOP A44_CDAC_CAP_BANK_ASSEMBLY_R8_M6_0/A44_CAP_CORE128_M6_R1_0/CAP_BOTTOM_015 cap_mim_2f0_m4m5_noshield c_width=6.855u c_length=6.855u
X4717 VTOP A44_CDAC_CAP_BANK_ASSEMBLY_R8_M6_0/A44_CAP_CORE128_M6_R1_0/CAP_BOTTOM_015 cap_mim_2f0_m4m5_noshield c_width=6.855u c_length=6.855u
X4718 VTOP A44_CDAC_CAP_BANK_ASSEMBLY_R8_M6_0/A44_CAP_CORE128_M6_R1_0/CAP_BOTTOM_014 cap_mim_2f0_m4m5_noshield c_width=6.855u c_length=6.855u
X4719 VTOP A44_CDAC_CAP_BANK_ASSEMBLY_R8_M6_0/A44_CAP_CORE128_M6_R1_0/CAP_BOTTOM_014 cap_mim_2f0_m4m5_noshield c_width=6.855u c_length=6.855u
X4720 VTOP A44_CDAC_CAP_BANK_ASSEMBLY_R8_M6_0/A44_CAP_CORE128_M6_R1_0/CAP_BOTTOM_014 cap_mim_2f0_m4m5_noshield c_width=6.855u c_length=6.855u
X4721 VTOP A44_CDAC_CAP_BANK_ASSEMBLY_R8_M6_0/A44_CAP_CORE128_M6_R1_0/CAP_BOTTOM_014 cap_mim_2f0_m4m5_noshield c_width=6.855u c_length=6.855u
X4722 VTOP A44_CDAC_CAP_BANK_ASSEMBLY_R8_M6_0/A44_CAP_CORE128_M6_R1_0/CAP_BOTTOM_014 cap_mim_2f0_m4m5_noshield c_width=6.855u c_length=6.855u
X4723 VTOP A44_CDAC_CAP_BANK_ASSEMBLY_R8_M6_0/A44_CAP_CORE128_M6_R1_0/CAP_BOTTOM_014 cap_mim_2f0_m4m5_noshield c_width=6.855u c_length=6.855u
X4724 VTOP A44_CDAC_CAP_BANK_ASSEMBLY_R8_M6_0/A44_CAP_CORE128_M6_R1_0/CAP_BOTTOM_041 cap_mim_2f0_m4m5_noshield c_width=6.855u c_length=6.855u
X4725 VTOP A44_CDAC_CAP_BANK_ASSEMBLY_R8_M6_0/A44_CAP_CORE128_M6_R1_0/CAP_BOTTOM_041 cap_mim_2f0_m4m5_noshield c_width=6.855u c_length=6.855u
X4726 VTOP A44_CDAC_CAP_BANK_ASSEMBLY_R8_M6_0/A44_CAP_CORE128_M6_R1_0/CAP_BOTTOM_041 cap_mim_2f0_m4m5_noshield c_width=6.855u c_length=6.855u
X4727 VTOP A44_CDAC_CAP_BANK_ASSEMBLY_R8_M6_0/A44_CAP_CORE128_M6_R1_0/CAP_BOTTOM_041 cap_mim_2f0_m4m5_noshield c_width=6.855u c_length=6.855u
X4728 VTOP A44_CDAC_CAP_BANK_ASSEMBLY_R8_M6_0/A44_CAP_CORE128_M6_R1_0/CAP_BOTTOM_041 cap_mim_2f0_m4m5_noshield c_width=6.855u c_length=6.855u
X4729 VTOP A44_CDAC_CAP_BANK_ASSEMBLY_R8_M6_0/A44_CAP_CORE128_M6_R1_0/CAP_BOTTOM_041 cap_mim_2f0_m4m5_noshield c_width=6.855u c_length=6.855u
X4730 VTOP A44_CDAC_CAP_BANK_ASSEMBLY_R8_M6_0/A44_CAP_CORE128_M6_R1_0/CAP_BOTTOM_013 cap_mim_2f0_m4m5_noshield c_width=6.855u c_length=6.855u
X4731 VTOP A44_CDAC_CAP_BANK_ASSEMBLY_R8_M6_0/A44_CAP_CORE128_M6_R1_0/CAP_BOTTOM_013 cap_mim_2f0_m4m5_noshield c_width=6.855u c_length=6.855u
X4732 VTOP A44_CDAC_CAP_BANK_ASSEMBLY_R8_M6_0/A44_CAP_CORE128_M6_R1_0/CAP_BOTTOM_013 cap_mim_2f0_m4m5_noshield c_width=6.855u c_length=6.855u
X4733 VTOP A44_CDAC_CAP_BANK_ASSEMBLY_R8_M6_0/A44_CAP_CORE128_M6_R1_0/CAP_BOTTOM_013 cap_mim_2f0_m4m5_noshield c_width=6.855u c_length=6.855u
X4734 VTOP A44_CDAC_CAP_BANK_ASSEMBLY_R8_M6_0/A44_CAP_CORE128_M6_R1_0/CAP_BOTTOM_013 cap_mim_2f0_m4m5_noshield c_width=6.855u c_length=6.855u
X4735 VTOP A44_CDAC_CAP_BANK_ASSEMBLY_R8_M6_0/A44_CAP_CORE128_M6_R1_0/CAP_BOTTOM_013 cap_mim_2f0_m4m5_noshield c_width=6.855u c_length=6.855u
X4736 VTOP A44_CDAC_CAP_BANK_ASSEMBLY_R8_M6_0/A44_CAP_CORE128_M6_R1_0/CAP_BOTTOM_059 cap_mim_2f0_m4m5_noshield c_width=6.855u c_length=6.855u
X4737 VTOP A44_CDAC_CAP_BANK_ASSEMBLY_R8_M6_0/A44_CAP_CORE128_M6_R1_0/CAP_BOTTOM_059 cap_mim_2f0_m4m5_noshield c_width=6.855u c_length=6.855u
X4738 VTOP A44_CDAC_CAP_BANK_ASSEMBLY_R8_M6_0/A44_CAP_CORE128_M6_R1_0/CAP_BOTTOM_059 cap_mim_2f0_m4m5_noshield c_width=6.855u c_length=6.855u
X4739 VTOP A44_CDAC_CAP_BANK_ASSEMBLY_R8_M6_0/A44_CAP_CORE128_M6_R1_0/CAP_BOTTOM_059 cap_mim_2f0_m4m5_noshield c_width=6.855u c_length=6.855u
X4740 VTOP A44_CDAC_CAP_BANK_ASSEMBLY_R8_M6_0/A44_CAP_CORE128_M6_R1_0/CAP_BOTTOM_059 cap_mim_2f0_m4m5_noshield c_width=6.855u c_length=6.855u
X4741 VTOP A44_CDAC_CAP_BANK_ASSEMBLY_R8_M6_0/A44_CAP_CORE128_M6_R1_0/CAP_BOTTOM_059 cap_mim_2f0_m4m5_noshield c_width=6.855u c_length=6.855u
X4742 VTOP A44_CDAC_CAP_BANK_ASSEMBLY_R8_M6_0/A44_CAP_CORE128_M6_R1_0/CAP_BOTTOM_037 cap_mim_2f0_m4m5_noshield c_width=6.855u c_length=6.855u
X4743 VTOP A44_CDAC_CAP_BANK_ASSEMBLY_R8_M6_0/A44_CAP_CORE128_M6_R1_0/CAP_BOTTOM_037 cap_mim_2f0_m4m5_noshield c_width=6.855u c_length=6.855u
X4744 VTOP A44_CDAC_CAP_BANK_ASSEMBLY_R8_M6_0/A44_CAP_CORE128_M6_R1_0/CAP_BOTTOM_037 cap_mim_2f0_m4m5_noshield c_width=6.855u c_length=6.855u
X4745 VTOP A44_CDAC_CAP_BANK_ASSEMBLY_R8_M6_0/A44_CAP_CORE128_M6_R1_0/CAP_BOTTOM_037 cap_mim_2f0_m4m5_noshield c_width=6.855u c_length=6.855u
X4746 VTOP A44_CDAC_CAP_BANK_ASSEMBLY_R8_M6_0/A44_CAP_CORE128_M6_R1_0/CAP_BOTTOM_037 cap_mim_2f0_m4m5_noshield c_width=6.855u c_length=6.855u
X4747 VTOP A44_CDAC_CAP_BANK_ASSEMBLY_R8_M6_0/A44_CAP_CORE128_M6_R1_0/CAP_BOTTOM_037 cap_mim_2f0_m4m5_noshield c_width=6.855u c_length=6.855u
X4748 VTOP A44_CDAC_CAP_BANK_ASSEMBLY_R8_M6_0/A44_CAP_CORE128_M6_R1_0/CAP_BOTTOM_040 cap_mim_2f0_m4m5_noshield c_width=6.855u c_length=6.855u
X4749 VTOP A44_CDAC_CAP_BANK_ASSEMBLY_R8_M6_0/A44_CAP_CORE128_M6_R1_0/CAP_BOTTOM_040 cap_mim_2f0_m4m5_noshield c_width=6.855u c_length=6.855u
X4750 VTOP A44_CDAC_CAP_BANK_ASSEMBLY_R8_M6_0/A44_CAP_CORE128_M6_R1_0/CAP_BOTTOM_040 cap_mim_2f0_m4m5_noshield c_width=6.855u c_length=6.855u
X4751 VTOP A44_CDAC_CAP_BANK_ASSEMBLY_R8_M6_0/A44_CAP_CORE128_M6_R1_0/CAP_BOTTOM_040 cap_mim_2f0_m4m5_noshield c_width=6.855u c_length=6.855u
X4752 VTOP A44_CDAC_CAP_BANK_ASSEMBLY_R8_M6_0/A44_CAP_CORE128_M6_R1_0/CAP_BOTTOM_040 cap_mim_2f0_m4m5_noshield c_width=6.855u c_length=6.855u
X4753 VTOP A44_CDAC_CAP_BANK_ASSEMBLY_R8_M6_0/A44_CAP_CORE128_M6_R1_0/CAP_BOTTOM_040 cap_mim_2f0_m4m5_noshield c_width=6.855u c_length=6.855u
X4754 VTOP A44_CDAC_CAP_BANK_ASSEMBLY_R8_M6_0/A44_CAP_CORE128_M6_R1_0/CAP_BOTTOM_012 cap_mim_2f0_m4m5_noshield c_width=6.855u c_length=6.855u
X4755 VTOP A44_CDAC_CAP_BANK_ASSEMBLY_R8_M6_0/A44_CAP_CORE128_M6_R1_0/CAP_BOTTOM_012 cap_mim_2f0_m4m5_noshield c_width=6.855u c_length=6.855u
X4756 VTOP A44_CDAC_CAP_BANK_ASSEMBLY_R8_M6_0/A44_CAP_CORE128_M6_R1_0/CAP_BOTTOM_012 cap_mim_2f0_m4m5_noshield c_width=6.855u c_length=6.855u
X4757 VTOP A44_CDAC_CAP_BANK_ASSEMBLY_R8_M6_0/A44_CAP_CORE128_M6_R1_0/CAP_BOTTOM_012 cap_mim_2f0_m4m5_noshield c_width=6.855u c_length=6.855u
X4758 VTOP A44_CDAC_CAP_BANK_ASSEMBLY_R8_M6_0/A44_CAP_CORE128_M6_R1_0/CAP_BOTTOM_012 cap_mim_2f0_m4m5_noshield c_width=6.855u c_length=6.855u
X4759 VTOP A44_CDAC_CAP_BANK_ASSEMBLY_R8_M6_0/A44_CAP_CORE128_M6_R1_0/CAP_BOTTOM_012 cap_mim_2f0_m4m5_noshield c_width=6.855u c_length=6.855u
X4760 VTOP A44_CDAC_CAP_BANK_ASSEMBLY_R8_M6_0/A44_CAP_CORE128_M6_R1_0/CAP_BOTTOM_031 cap_mim_2f0_m4m5_noshield c_width=6.855u c_length=6.855u
X4761 VTOP A44_CDAC_CAP_BANK_ASSEMBLY_R8_M6_0/A44_CAP_CORE128_M6_R1_0/CAP_BOTTOM_031 cap_mim_2f0_m4m5_noshield c_width=6.855u c_length=6.855u
X4762 VTOP A44_CDAC_CAP_BANK_ASSEMBLY_R8_M6_0/A44_CAP_CORE128_M6_R1_0/CAP_BOTTOM_031 cap_mim_2f0_m4m5_noshield c_width=6.855u c_length=6.855u
X4763 VTOP A44_CDAC_CAP_BANK_ASSEMBLY_R8_M6_0/A44_CAP_CORE128_M6_R1_0/CAP_BOTTOM_031 cap_mim_2f0_m4m5_noshield c_width=6.855u c_length=6.855u
X4764 VTOP A44_CDAC_CAP_BANK_ASSEMBLY_R8_M6_0/A44_CAP_CORE128_M6_R1_0/CAP_BOTTOM_031 cap_mim_2f0_m4m5_noshield c_width=6.855u c_length=6.855u
X4765 VTOP A44_CDAC_CAP_BANK_ASSEMBLY_R8_M6_0/A44_CAP_CORE128_M6_R1_0/CAP_BOTTOM_031 cap_mim_2f0_m4m5_noshield c_width=6.855u c_length=6.855u
X4766 VTOP A44_CDAC_CAP_BANK_ASSEMBLY_R8_M6_0/A44_CAP_CORE128_M6_R1_0/CAP_BOTTOM_023 cap_mim_2f0_m4m5_noshield c_width=6.855u c_length=6.855u
X4767 VTOP A44_CDAC_CAP_BANK_ASSEMBLY_R8_M6_0/A44_CAP_CORE128_M6_R1_0/CAP_BOTTOM_023 cap_mim_2f0_m4m5_noshield c_width=6.855u c_length=6.855u
X4768 VTOP A44_CDAC_CAP_BANK_ASSEMBLY_R8_M6_0/A44_CAP_CORE128_M6_R1_0/CAP_BOTTOM_023 cap_mim_2f0_m4m5_noshield c_width=6.855u c_length=6.855u
X4769 VTOP A44_CDAC_CAP_BANK_ASSEMBLY_R8_M6_0/A44_CAP_CORE128_M6_R1_0/CAP_BOTTOM_023 cap_mim_2f0_m4m5_noshield c_width=6.855u c_length=6.855u
X4770 VTOP A44_CDAC_CAP_BANK_ASSEMBLY_R8_M6_0/A44_CAP_CORE128_M6_R1_0/CAP_BOTTOM_023 cap_mim_2f0_m4m5_noshield c_width=6.855u c_length=6.855u
X4771 VTOP A44_CDAC_CAP_BANK_ASSEMBLY_R8_M6_0/A44_CAP_CORE128_M6_R1_0/CAP_BOTTOM_023 cap_mim_2f0_m4m5_noshield c_width=6.855u c_length=6.855u
X4772 VTOP A44_CDAC_CAP_BANK_ASSEMBLY_R8_M6_0/A44_CAP_CORE128_M6_R1_0/CAP_BOTTOM_058 cap_mim_2f0_m4m5_noshield c_width=6.855u c_length=6.855u
X4773 VTOP A44_CDAC_CAP_BANK_ASSEMBLY_R8_M6_0/A44_CAP_CORE128_M6_R1_0/CAP_BOTTOM_058 cap_mim_2f0_m4m5_noshield c_width=6.855u c_length=6.855u
X4774 VTOP A44_CDAC_CAP_BANK_ASSEMBLY_R8_M6_0/A44_CAP_CORE128_M6_R1_0/CAP_BOTTOM_058 cap_mim_2f0_m4m5_noshield c_width=6.855u c_length=6.855u
X4775 VTOP A44_CDAC_CAP_BANK_ASSEMBLY_R8_M6_0/A44_CAP_CORE128_M6_R1_0/CAP_BOTTOM_058 cap_mim_2f0_m4m5_noshield c_width=6.855u c_length=6.855u
X4776 VTOP A44_CDAC_CAP_BANK_ASSEMBLY_R8_M6_0/A44_CAP_CORE128_M6_R1_0/CAP_BOTTOM_058 cap_mim_2f0_m4m5_noshield c_width=6.855u c_length=6.855u
X4777 VTOP A44_CDAC_CAP_BANK_ASSEMBLY_R8_M6_0/A44_CAP_CORE128_M6_R1_0/CAP_BOTTOM_058 cap_mim_2f0_m4m5_noshield c_width=6.855u c_length=6.855u
X4778 VTOP A44_CDAC_CAP_BANK_ASSEMBLY_R8_M6_0/A44_CAP_CORE128_M6_R1_0/CAP_BOTTOM_036 cap_mim_2f0_m4m5_noshield c_width=6.855u c_length=6.855u
X4779 VTOP A44_CDAC_CAP_BANK_ASSEMBLY_R8_M6_0/A44_CAP_CORE128_M6_R1_0/CAP_BOTTOM_036 cap_mim_2f0_m4m5_noshield c_width=6.855u c_length=6.855u
X4780 VTOP A44_CDAC_CAP_BANK_ASSEMBLY_R8_M6_0/A44_CAP_CORE128_M6_R1_0/CAP_BOTTOM_036 cap_mim_2f0_m4m5_noshield c_width=6.855u c_length=6.855u
X4781 VTOP A44_CDAC_CAP_BANK_ASSEMBLY_R8_M6_0/A44_CAP_CORE128_M6_R1_0/CAP_BOTTOM_036 cap_mim_2f0_m4m5_noshield c_width=6.855u c_length=6.855u
X4782 VTOP A44_CDAC_CAP_BANK_ASSEMBLY_R8_M6_0/A44_CAP_CORE128_M6_R1_0/CAP_BOTTOM_036 cap_mim_2f0_m4m5_noshield c_width=6.855u c_length=6.855u
X4783 VTOP A44_CDAC_CAP_BANK_ASSEMBLY_R8_M6_0/A44_CAP_CORE128_M6_R1_0/CAP_BOTTOM_036 cap_mim_2f0_m4m5_noshield c_width=6.855u c_length=6.855u
X4784 VTOP A44_CDAC_CAP_BANK_ASSEMBLY_R8_M6_0/A44_CAP_CORE128_M6_R1_0/CAP_BOTTOM_011 cap_mim_2f0_m4m5_noshield c_width=6.855u c_length=6.855u
X4785 VTOP A44_CDAC_CAP_BANK_ASSEMBLY_R8_M6_0/A44_CAP_CORE128_M6_R1_0/CAP_BOTTOM_011 cap_mim_2f0_m4m5_noshield c_width=6.855u c_length=6.855u
X4786 VTOP A44_CDAC_CAP_BANK_ASSEMBLY_R8_M6_0/A44_CAP_CORE128_M6_R1_0/CAP_BOTTOM_011 cap_mim_2f0_m4m5_noshield c_width=6.855u c_length=6.855u
X4787 VTOP A44_CDAC_CAP_BANK_ASSEMBLY_R8_M6_0/A44_CAP_CORE128_M6_R1_0/CAP_BOTTOM_011 cap_mim_2f0_m4m5_noshield c_width=6.855u c_length=6.855u
X4788 VTOP A44_CDAC_CAP_BANK_ASSEMBLY_R8_M6_0/A44_CAP_CORE128_M6_R1_0/CAP_BOTTOM_011 cap_mim_2f0_m4m5_noshield c_width=6.855u c_length=6.855u
X4789 VTOP A44_CDAC_CAP_BANK_ASSEMBLY_R8_M6_0/A44_CAP_CORE128_M6_R1_0/CAP_BOTTOM_011 cap_mim_2f0_m4m5_noshield c_width=6.855u c_length=6.855u
X4790 VTOP A44_CDAC_CAP_BANK_ASSEMBLY_R8_M6_0/A44_CAP_CORE128_M6_R1_0/CAP_BOTTOM_001 cap_mim_2f0_m4m5_noshield c_width=6.855u c_length=6.855u
X4791 VTOP A44_CDAC_CAP_BANK_ASSEMBLY_R8_M6_0/A44_CAP_CORE128_M6_R1_0/CAP_BOTTOM_001 cap_mim_2f0_m4m5_noshield c_width=6.855u c_length=6.855u
X4792 VTOP A44_CDAC_CAP_BANK_ASSEMBLY_R8_M6_0/A44_CAP_CORE128_M6_R1_0/CAP_BOTTOM_001 cap_mim_2f0_m4m5_noshield c_width=6.855u c_length=6.855u
X4793 VTOP A44_CDAC_CAP_BANK_ASSEMBLY_R8_M6_0/A44_CAP_CORE128_M6_R1_0/CAP_BOTTOM_001 cap_mim_2f0_m4m5_noshield c_width=6.855u c_length=6.855u
X4794 VTOP A44_CDAC_CAP_BANK_ASSEMBLY_R8_M6_0/A44_CAP_CORE128_M6_R1_0/CAP_BOTTOM_001 cap_mim_2f0_m4m5_noshield c_width=6.855u c_length=6.855u
X4795 VTOP A44_CDAC_CAP_BANK_ASSEMBLY_R8_M6_0/A44_CAP_CORE128_M6_R1_0/CAP_BOTTOM_001 cap_mim_2f0_m4m5_noshield c_width=6.855u c_length=6.855u
X4796 VTOP A44_CDAC_CAP_BANK_ASSEMBLY_R8_M6_0/A44_CAP_CORE128_M6_R1_0/CAP_BOTTOM_030 cap_mim_2f0_m4m5_noshield c_width=6.855u c_length=6.855u
X4797 VTOP A44_CDAC_CAP_BANK_ASSEMBLY_R8_M6_0/A44_CAP_CORE128_M6_R1_0/CAP_BOTTOM_030 cap_mim_2f0_m4m5_noshield c_width=6.855u c_length=6.855u
X4798 VTOP A44_CDAC_CAP_BANK_ASSEMBLY_R8_M6_0/A44_CAP_CORE128_M6_R1_0/CAP_BOTTOM_030 cap_mim_2f0_m4m5_noshield c_width=6.855u c_length=6.855u
X4799 VTOP A44_CDAC_CAP_BANK_ASSEMBLY_R8_M6_0/A44_CAP_CORE128_M6_R1_0/CAP_BOTTOM_030 cap_mim_2f0_m4m5_noshield c_width=6.855u c_length=6.855u
X4800 VTOP A44_CDAC_CAP_BANK_ASSEMBLY_R8_M6_0/A44_CAP_CORE128_M6_R1_0/CAP_BOTTOM_030 cap_mim_2f0_m4m5_noshield c_width=6.855u c_length=6.855u
X4801 VTOP A44_CDAC_CAP_BANK_ASSEMBLY_R8_M6_0/A44_CAP_CORE128_M6_R1_0/CAP_BOTTOM_030 cap_mim_2f0_m4m5_noshield c_width=6.855u c_length=6.855u
X4802 VTOP A44_CDAC_CAP_BANK_ASSEMBLY_R8_M6_0/A44_CAP_CORE128_M6_R1_0/CAP_BOTTOM_022 cap_mim_2f0_m4m5_noshield c_width=6.855u c_length=6.855u
X4803 VTOP A44_CDAC_CAP_BANK_ASSEMBLY_R8_M6_0/A44_CAP_CORE128_M6_R1_0/CAP_BOTTOM_022 cap_mim_2f0_m4m5_noshield c_width=6.855u c_length=6.855u
X4804 VTOP A44_CDAC_CAP_BANK_ASSEMBLY_R8_M6_0/A44_CAP_CORE128_M6_R1_0/CAP_BOTTOM_022 cap_mim_2f0_m4m5_noshield c_width=6.855u c_length=6.855u
X4805 VTOP A44_CDAC_CAP_BANK_ASSEMBLY_R8_M6_0/A44_CAP_CORE128_M6_R1_0/CAP_BOTTOM_022 cap_mim_2f0_m4m5_noshield c_width=6.855u c_length=6.855u
X4806 VTOP A44_CDAC_CAP_BANK_ASSEMBLY_R8_M6_0/A44_CAP_CORE128_M6_R1_0/CAP_BOTTOM_022 cap_mim_2f0_m4m5_noshield c_width=6.855u c_length=6.855u
X4807 VTOP A44_CDAC_CAP_BANK_ASSEMBLY_R8_M6_0/A44_CAP_CORE128_M6_R1_0/CAP_BOTTOM_022 cap_mim_2f0_m4m5_noshield c_width=6.855u c_length=6.855u
X4808 VTOP A44_CDAC_CAP_BANK_ASSEMBLY_R8_M6_0/A44_CAP_CORE128_M6_R1_0/CAP_BOTTOM_057 cap_mim_2f0_m4m5_noshield c_width=6.855u c_length=6.855u
X4809 VTOP A44_CDAC_CAP_BANK_ASSEMBLY_R8_M6_0/A44_CAP_CORE128_M6_R1_0/CAP_BOTTOM_057 cap_mim_2f0_m4m5_noshield c_width=6.855u c_length=6.855u
X4810 VTOP A44_CDAC_CAP_BANK_ASSEMBLY_R8_M6_0/A44_CAP_CORE128_M6_R1_0/CAP_BOTTOM_057 cap_mim_2f0_m4m5_noshield c_width=6.855u c_length=6.855u
X4811 VTOP A44_CDAC_CAP_BANK_ASSEMBLY_R8_M6_0/A44_CAP_CORE128_M6_R1_0/CAP_BOTTOM_057 cap_mim_2f0_m4m5_noshield c_width=6.855u c_length=6.855u
X4812 VTOP A44_CDAC_CAP_BANK_ASSEMBLY_R8_M6_0/A44_CAP_CORE128_M6_R1_0/CAP_BOTTOM_057 cap_mim_2f0_m4m5_noshield c_width=6.855u c_length=6.855u
X4813 VTOP A44_CDAC_CAP_BANK_ASSEMBLY_R8_M6_0/A44_CAP_CORE128_M6_R1_0/CAP_BOTTOM_057 cap_mim_2f0_m4m5_noshield c_width=6.855u c_length=6.855u
X4814 VTOP A44_CDAC_CAP_BANK_ASSEMBLY_R8_M6_0/A44_CAP_CORE128_M6_R1_0/CAP_BOTTOM_035 cap_mim_2f0_m4m5_noshield c_width=6.855u c_length=6.855u
X4815 VTOP A44_CDAC_CAP_BANK_ASSEMBLY_R8_M6_0/A44_CAP_CORE128_M6_R1_0/CAP_BOTTOM_035 cap_mim_2f0_m4m5_noshield c_width=6.855u c_length=6.855u
X4816 VTOP A44_CDAC_CAP_BANK_ASSEMBLY_R8_M6_0/A44_CAP_CORE128_M6_R1_0/CAP_BOTTOM_035 cap_mim_2f0_m4m5_noshield c_width=6.855u c_length=6.855u
X4817 VTOP A44_CDAC_CAP_BANK_ASSEMBLY_R8_M6_0/A44_CAP_CORE128_M6_R1_0/CAP_BOTTOM_035 cap_mim_2f0_m4m5_noshield c_width=6.855u c_length=6.855u
X4818 VTOP A44_CDAC_CAP_BANK_ASSEMBLY_R8_M6_0/A44_CAP_CORE128_M6_R1_0/CAP_BOTTOM_035 cap_mim_2f0_m4m5_noshield c_width=6.855u c_length=6.855u
X4819 VTOP A44_CDAC_CAP_BANK_ASSEMBLY_R8_M6_0/A44_CAP_CORE128_M6_R1_0/CAP_BOTTOM_035 cap_mim_2f0_m4m5_noshield c_width=6.855u c_length=6.855u
X4820 VTOP A44_CDAC_CAP_BANK_ASSEMBLY_R8_M6_0/A44_CAP_CORE128_M6_R1_0/CAP_BOTTOM_010 cap_mim_2f0_m4m5_noshield c_width=6.855u c_length=6.855u
X4821 VTOP A44_CDAC_CAP_BANK_ASSEMBLY_R8_M6_0/A44_CAP_CORE128_M6_R1_0/CAP_BOTTOM_010 cap_mim_2f0_m4m5_noshield c_width=6.855u c_length=6.855u
X4822 VTOP A44_CDAC_CAP_BANK_ASSEMBLY_R8_M6_0/A44_CAP_CORE128_M6_R1_0/CAP_BOTTOM_010 cap_mim_2f0_m4m5_noshield c_width=6.855u c_length=6.855u
X4823 VTOP A44_CDAC_CAP_BANK_ASSEMBLY_R8_M6_0/A44_CAP_CORE128_M6_R1_0/CAP_BOTTOM_010 cap_mim_2f0_m4m5_noshield c_width=6.855u c_length=6.855u
X4824 VTOP A44_CDAC_CAP_BANK_ASSEMBLY_R8_M6_0/A44_CAP_CORE128_M6_R1_0/CAP_BOTTOM_010 cap_mim_2f0_m4m5_noshield c_width=6.855u c_length=6.855u
X4825 VTOP A44_CDAC_CAP_BANK_ASSEMBLY_R8_M6_0/A44_CAP_CORE128_M6_R1_0/CAP_BOTTOM_010 cap_mim_2f0_m4m5_noshield c_width=6.855u c_length=6.855u
X4826 VTOP A44_CDAC_CAP_BANK_ASSEMBLY_R8_M6_0/A44_CAP_CORE128_M6_R1_0/CAP_BOTTOM_000 cap_mim_2f0_m4m5_noshield c_width=6.855u c_length=6.855u
X4827 VTOP A44_CDAC_CAP_BANK_ASSEMBLY_R8_M6_0/A44_CAP_CORE128_M6_R1_0/CAP_BOTTOM_000 cap_mim_2f0_m4m5_noshield c_width=6.855u c_length=6.855u
X4828 VTOP A44_CDAC_CAP_BANK_ASSEMBLY_R8_M6_0/A44_CAP_CORE128_M6_R1_0/CAP_BOTTOM_000 cap_mim_2f0_m4m5_noshield c_width=6.855u c_length=6.855u
X4829 VTOP A44_CDAC_CAP_BANK_ASSEMBLY_R8_M6_0/A44_CAP_CORE128_M6_R1_0/CAP_BOTTOM_000 cap_mim_2f0_m4m5_noshield c_width=6.855u c_length=6.855u
X4830 VTOP A44_CDAC_CAP_BANK_ASSEMBLY_R8_M6_0/A44_CAP_CORE128_M6_R1_0/CAP_BOTTOM_000 cap_mim_2f0_m4m5_noshield c_width=6.855u c_length=6.855u
X4831 VTOP A44_CDAC_CAP_BANK_ASSEMBLY_R8_M6_0/A44_CAP_CORE128_M6_R1_0/CAP_BOTTOM_000 cap_mim_2f0_m4m5_noshield c_width=6.855u c_length=6.855u
X4832 VTOP A44_CDAC_CAP_BANK_ASSEMBLY_R8_M6_0/A44_CAP_CORE128_M6_R1_0/CAP_BOTTOM_029 cap_mim_2f0_m4m5_noshield c_width=6.855u c_length=6.855u
X4833 VTOP A44_CDAC_CAP_BANK_ASSEMBLY_R8_M6_0/A44_CAP_CORE128_M6_R1_0/CAP_BOTTOM_029 cap_mim_2f0_m4m5_noshield c_width=6.855u c_length=6.855u
X4834 VTOP A44_CDAC_CAP_BANK_ASSEMBLY_R8_M6_0/A44_CAP_CORE128_M6_R1_0/CAP_BOTTOM_029 cap_mim_2f0_m4m5_noshield c_width=6.855u c_length=6.855u
X4835 VTOP A44_CDAC_CAP_BANK_ASSEMBLY_R8_M6_0/A44_CAP_CORE128_M6_R1_0/CAP_BOTTOM_029 cap_mim_2f0_m4m5_noshield c_width=6.855u c_length=6.855u
X4836 VTOP A44_CDAC_CAP_BANK_ASSEMBLY_R8_M6_0/A44_CAP_CORE128_M6_R1_0/CAP_BOTTOM_029 cap_mim_2f0_m4m5_noshield c_width=6.855u c_length=6.855u
X4837 VTOP A44_CDAC_CAP_BANK_ASSEMBLY_R8_M6_0/A44_CAP_CORE128_M6_R1_0/CAP_BOTTOM_029 cap_mim_2f0_m4m5_noshield c_width=6.855u c_length=6.855u
X4838 VTOP A44_CDAC_CAP_BANK_ASSEMBLY_R8_M6_0/A44_CAP_CORE128_M6_R1_0/CAP_BOTTOM_021 cap_mim_2f0_m4m5_noshield c_width=6.855u c_length=6.855u
X4839 VTOP A44_CDAC_CAP_BANK_ASSEMBLY_R8_M6_0/A44_CAP_CORE128_M6_R1_0/CAP_BOTTOM_021 cap_mim_2f0_m4m5_noshield c_width=6.855u c_length=6.855u
X4840 VTOP A44_CDAC_CAP_BANK_ASSEMBLY_R8_M6_0/A44_CAP_CORE128_M6_R1_0/CAP_BOTTOM_021 cap_mim_2f0_m4m5_noshield c_width=6.855u c_length=6.855u
X4841 VTOP A44_CDAC_CAP_BANK_ASSEMBLY_R8_M6_0/A44_CAP_CORE128_M6_R1_0/CAP_BOTTOM_021 cap_mim_2f0_m4m5_noshield c_width=6.855u c_length=6.855u
X4842 VTOP A44_CDAC_CAP_BANK_ASSEMBLY_R8_M6_0/A44_CAP_CORE128_M6_R1_0/CAP_BOTTOM_021 cap_mim_2f0_m4m5_noshield c_width=6.855u c_length=6.855u
X4843 VTOP A44_CDAC_CAP_BANK_ASSEMBLY_R8_M6_0/A44_CAP_CORE128_M6_R1_0/CAP_BOTTOM_021 cap_mim_2f0_m4m5_noshield c_width=6.855u c_length=6.855u
X4844 VTOP A44_CDAC_CAP_BANK_ASSEMBLY_R8_M6_0/A44_CAP_CORE128_M6_R1_0/CAP_BOTTOM_067 cap_mim_2f0_m4m5_noshield c_width=6.855u c_length=6.855u
X4845 VTOP A44_CDAC_CAP_BANK_ASSEMBLY_R8_M6_0/A44_CAP_CORE128_M6_R1_0/CAP_BOTTOM_067 cap_mim_2f0_m4m5_noshield c_width=6.855u c_length=6.855u
X4846 VTOP A44_CDAC_CAP_BANK_ASSEMBLY_R8_M6_0/A44_CAP_CORE128_M6_R1_0/CAP_BOTTOM_067 cap_mim_2f0_m4m5_noshield c_width=6.855u c_length=6.855u
X4847 VTOP A44_CDAC_CAP_BANK_ASSEMBLY_R8_M6_0/A44_CAP_CORE128_M6_R1_0/CAP_BOTTOM_067 cap_mim_2f0_m4m5_noshield c_width=6.855u c_length=6.855u
X4848 VTOP A44_CDAC_CAP_BANK_ASSEMBLY_R8_M6_0/A44_CAP_CORE128_M6_R1_0/CAP_BOTTOM_067 cap_mim_2f0_m4m5_noshield c_width=6.855u c_length=6.855u
X4849 VTOP A44_CDAC_CAP_BANK_ASSEMBLY_R8_M6_0/A44_CAP_CORE128_M6_R1_0/CAP_BOTTOM_067 cap_mim_2f0_m4m5_noshield c_width=6.855u c_length=6.855u
X4850 VTOP A44_CDAC_CAP_BANK_ASSEMBLY_R8_M6_0/A44_CAP_CORE128_M6_R1_0/CAP_BOTTOM_056 cap_mim_2f0_m4m5_noshield c_width=6.855u c_length=6.855u
X4851 VTOP A44_CDAC_CAP_BANK_ASSEMBLY_R8_M6_0/A44_CAP_CORE128_M6_R1_0/CAP_BOTTOM_056 cap_mim_2f0_m4m5_noshield c_width=6.855u c_length=6.855u
X4852 VTOP A44_CDAC_CAP_BANK_ASSEMBLY_R8_M6_0/A44_CAP_CORE128_M6_R1_0/CAP_BOTTOM_056 cap_mim_2f0_m4m5_noshield c_width=6.855u c_length=6.855u
X4853 VTOP A44_CDAC_CAP_BANK_ASSEMBLY_R8_M6_0/A44_CAP_CORE128_M6_R1_0/CAP_BOTTOM_056 cap_mim_2f0_m4m5_noshield c_width=6.855u c_length=6.855u
X4854 VTOP A44_CDAC_CAP_BANK_ASSEMBLY_R8_M6_0/A44_CAP_CORE128_M6_R1_0/CAP_BOTTOM_056 cap_mim_2f0_m4m5_noshield c_width=6.855u c_length=6.855u
X4855 VTOP A44_CDAC_CAP_BANK_ASSEMBLY_R8_M6_0/A44_CAP_CORE128_M6_R1_0/CAP_BOTTOM_056 cap_mim_2f0_m4m5_noshield c_width=6.855u c_length=6.855u
X4856 VTOP A44_CDAC_CAP_BANK_ASSEMBLY_R8_M6_0/A44_CAP_CORE128_M6_R1_0/CAP_BOTTOM_034 cap_mim_2f0_m4m5_noshield c_width=6.855u c_length=6.855u
X4857 VTOP A44_CDAC_CAP_BANK_ASSEMBLY_R8_M6_0/A44_CAP_CORE128_M6_R1_0/CAP_BOTTOM_034 cap_mim_2f0_m4m5_noshield c_width=6.855u c_length=6.855u
X4858 VTOP A44_CDAC_CAP_BANK_ASSEMBLY_R8_M6_0/A44_CAP_CORE128_M6_R1_0/CAP_BOTTOM_034 cap_mim_2f0_m4m5_noshield c_width=6.855u c_length=6.855u
X4859 VTOP A44_CDAC_CAP_BANK_ASSEMBLY_R8_M6_0/A44_CAP_CORE128_M6_R1_0/CAP_BOTTOM_034 cap_mim_2f0_m4m5_noshield c_width=6.855u c_length=6.855u
X4860 VTOP A44_CDAC_CAP_BANK_ASSEMBLY_R8_M6_0/A44_CAP_CORE128_M6_R1_0/CAP_BOTTOM_034 cap_mim_2f0_m4m5_noshield c_width=6.855u c_length=6.855u
X4861 VTOP A44_CDAC_CAP_BANK_ASSEMBLY_R8_M6_0/A44_CAP_CORE128_M6_R1_0/CAP_BOTTOM_034 cap_mim_2f0_m4m5_noshield c_width=6.855u c_length=6.855u
X4862 VTOP A44_CDAC_CAP_BANK_ASSEMBLY_R8_M6_0/A44_CAP_CORE128_M6_R1_0/CAP_BOTTOM_009 cap_mim_2f0_m4m5_noshield c_width=6.855u c_length=6.855u
X4863 VTOP A44_CDAC_CAP_BANK_ASSEMBLY_R8_M6_0/A44_CAP_CORE128_M6_R1_0/CAP_BOTTOM_009 cap_mim_2f0_m4m5_noshield c_width=6.855u c_length=6.855u
X4864 VTOP A44_CDAC_CAP_BANK_ASSEMBLY_R8_M6_0/A44_CAP_CORE128_M6_R1_0/CAP_BOTTOM_009 cap_mim_2f0_m4m5_noshield c_width=6.855u c_length=6.855u
X4865 VTOP A44_CDAC_CAP_BANK_ASSEMBLY_R8_M6_0/A44_CAP_CORE128_M6_R1_0/CAP_BOTTOM_009 cap_mim_2f0_m4m5_noshield c_width=6.855u c_length=6.855u
X4866 VTOP A44_CDAC_CAP_BANK_ASSEMBLY_R8_M6_0/A44_CAP_CORE128_M6_R1_0/CAP_BOTTOM_009 cap_mim_2f0_m4m5_noshield c_width=6.855u c_length=6.855u
X4867 VTOP A44_CDAC_CAP_BANK_ASSEMBLY_R8_M6_0/A44_CAP_CORE128_M6_R1_0/CAP_BOTTOM_009 cap_mim_2f0_m4m5_noshield c_width=6.855u c_length=6.855u
X4868 VTOP A44_CDAC_CAP_BANK_ASSEMBLY_R8_M6_0/A44_CAP_CORE128_M6_R1_0/CAP_BOTTOM_028 cap_mim_2f0_m4m5_noshield c_width=6.855u c_length=6.855u
X4869 VTOP A44_CDAC_CAP_BANK_ASSEMBLY_R8_M6_0/A44_CAP_CORE128_M6_R1_0/CAP_BOTTOM_028 cap_mim_2f0_m4m5_noshield c_width=6.855u c_length=6.855u
X4870 VTOP A44_CDAC_CAP_BANK_ASSEMBLY_R8_M6_0/A44_CAP_CORE128_M6_R1_0/CAP_BOTTOM_028 cap_mim_2f0_m4m5_noshield c_width=6.855u c_length=6.855u
X4871 VTOP A44_CDAC_CAP_BANK_ASSEMBLY_R8_M6_0/A44_CAP_CORE128_M6_R1_0/CAP_BOTTOM_028 cap_mim_2f0_m4m5_noshield c_width=6.855u c_length=6.855u
X4872 VTOP A44_CDAC_CAP_BANK_ASSEMBLY_R8_M6_0/A44_CAP_CORE128_M6_R1_0/CAP_BOTTOM_028 cap_mim_2f0_m4m5_noshield c_width=6.855u c_length=6.855u
X4873 VTOP A44_CDAC_CAP_BANK_ASSEMBLY_R8_M6_0/A44_CAP_CORE128_M6_R1_0/CAP_BOTTOM_028 cap_mim_2f0_m4m5_noshield c_width=6.855u c_length=6.855u
X4874 VTOP A44_CDAC_CAP_BANK_ASSEMBLY_R8_M6_0/A44_CAP_CORE128_M6_R1_0/CAP_BOTTOM_020 cap_mim_2f0_m4m5_noshield c_width=6.855u c_length=6.855u
X4875 VTOP A44_CDAC_CAP_BANK_ASSEMBLY_R8_M6_0/A44_CAP_CORE128_M6_R1_0/CAP_BOTTOM_020 cap_mim_2f0_m4m5_noshield c_width=6.855u c_length=6.855u
X4876 VTOP A44_CDAC_CAP_BANK_ASSEMBLY_R8_M6_0/A44_CAP_CORE128_M6_R1_0/CAP_BOTTOM_020 cap_mim_2f0_m4m5_noshield c_width=6.855u c_length=6.855u
X4877 VTOP A44_CDAC_CAP_BANK_ASSEMBLY_R8_M6_0/A44_CAP_CORE128_M6_R1_0/CAP_BOTTOM_020 cap_mim_2f0_m4m5_noshield c_width=6.855u c_length=6.855u
X4878 VTOP A44_CDAC_CAP_BANK_ASSEMBLY_R8_M6_0/A44_CAP_CORE128_M6_R1_0/CAP_BOTTOM_020 cap_mim_2f0_m4m5_noshield c_width=6.855u c_length=6.855u
X4879 VTOP A44_CDAC_CAP_BANK_ASSEMBLY_R8_M6_0/A44_CAP_CORE128_M6_R1_0/CAP_BOTTOM_020 cap_mim_2f0_m4m5_noshield c_width=6.855u c_length=6.855u
X4880 VTOP A44_CDAC_CAP_BANK_ASSEMBLY_R8_M6_0/A44_CAP_CORE128_M6_R1_0/CAP_BOTTOM_084 cap_mim_2f0_m4m5_noshield c_width=6.855u c_length=6.855u
X4881 VTOP A44_CDAC_CAP_BANK_ASSEMBLY_R8_M6_0/A44_CAP_CORE128_M6_R1_0/CAP_BOTTOM_084 cap_mim_2f0_m4m5_noshield c_width=6.855u c_length=6.855u
X4882 VTOP A44_CDAC_CAP_BANK_ASSEMBLY_R8_M6_0/A44_CAP_CORE128_M6_R1_0/CAP_BOTTOM_084 cap_mim_2f0_m4m5_noshield c_width=6.855u c_length=6.855u
X4883 VTOP A44_CDAC_CAP_BANK_ASSEMBLY_R8_M6_0/A44_CAP_CORE128_M6_R1_0/CAP_BOTTOM_084 cap_mim_2f0_m4m5_noshield c_width=6.855u c_length=6.855u
X4884 VTOP A44_CDAC_CAP_BANK_ASSEMBLY_R8_M6_0/A44_CAP_CORE128_M6_R1_0/CAP_BOTTOM_084 cap_mim_2f0_m4m5_noshield c_width=6.855u c_length=6.855u
X4885 VTOP A44_CDAC_CAP_BANK_ASSEMBLY_R8_M6_0/A44_CAP_CORE128_M6_R1_0/CAP_BOTTOM_084 cap_mim_2f0_m4m5_noshield c_width=6.855u c_length=6.855u
X4886 VTOP A44_CDAC_CAP_BANK_ASSEMBLY_R8_M6_0/A44_CAP_CORE128_M6_R1_0/CAP_BOTTOM_066 cap_mim_2f0_m4m5_noshield c_width=6.855u c_length=6.855u
X4887 VTOP A44_CDAC_CAP_BANK_ASSEMBLY_R8_M6_0/A44_CAP_CORE128_M6_R1_0/CAP_BOTTOM_066 cap_mim_2f0_m4m5_noshield c_width=6.855u c_length=6.855u
X4888 VTOP A44_CDAC_CAP_BANK_ASSEMBLY_R8_M6_0/A44_CAP_CORE128_M6_R1_0/CAP_BOTTOM_066 cap_mim_2f0_m4m5_noshield c_width=6.855u c_length=6.855u
X4889 VTOP A44_CDAC_CAP_BANK_ASSEMBLY_R8_M6_0/A44_CAP_CORE128_M6_R1_0/CAP_BOTTOM_066 cap_mim_2f0_m4m5_noshield c_width=6.855u c_length=6.855u
X4890 VTOP A44_CDAC_CAP_BANK_ASSEMBLY_R8_M6_0/A44_CAP_CORE128_M6_R1_0/CAP_BOTTOM_066 cap_mim_2f0_m4m5_noshield c_width=6.855u c_length=6.855u
X4891 VTOP A44_CDAC_CAP_BANK_ASSEMBLY_R8_M6_0/A44_CAP_CORE128_M6_R1_0/CAP_BOTTOM_066 cap_mim_2f0_m4m5_noshield c_width=6.855u c_length=6.855u
X4892 VTOP A44_CDAC_CAP_BANK_ASSEMBLY_R8_M6_0/A44_CAP_CORE128_M6_R1_0/CAP_BOTTOM_055 cap_mim_2f0_m4m5_noshield c_width=6.855u c_length=6.855u
X4893 VTOP A44_CDAC_CAP_BANK_ASSEMBLY_R8_M6_0/A44_CAP_CORE128_M6_R1_0/CAP_BOTTOM_055 cap_mim_2f0_m4m5_noshield c_width=6.855u c_length=6.855u
X4894 VTOP A44_CDAC_CAP_BANK_ASSEMBLY_R8_M6_0/A44_CAP_CORE128_M6_R1_0/CAP_BOTTOM_055 cap_mim_2f0_m4m5_noshield c_width=6.855u c_length=6.855u
X4895 VTOP A44_CDAC_CAP_BANK_ASSEMBLY_R8_M6_0/A44_CAP_CORE128_M6_R1_0/CAP_BOTTOM_055 cap_mim_2f0_m4m5_noshield c_width=6.855u c_length=6.855u
X4896 VTOP A44_CDAC_CAP_BANK_ASSEMBLY_R8_M6_0/A44_CAP_CORE128_M6_R1_0/CAP_BOTTOM_055 cap_mim_2f0_m4m5_noshield c_width=6.855u c_length=6.855u
X4897 VTOP A44_CDAC_CAP_BANK_ASSEMBLY_R8_M6_0/A44_CAP_CORE128_M6_R1_0/CAP_BOTTOM_055 cap_mim_2f0_m4m5_noshield c_width=6.855u c_length=6.855u
X4898 VTOP A44_CDAC_CAP_BANK_ASSEMBLY_R8_M6_0/A44_CAP_CORE128_M6_R1_0/CAP_BOTTOM_033 cap_mim_2f0_m4m5_noshield c_width=6.855u c_length=6.855u
X4899 VTOP A44_CDAC_CAP_BANK_ASSEMBLY_R8_M6_0/A44_CAP_CORE128_M6_R1_0/CAP_BOTTOM_033 cap_mim_2f0_m4m5_noshield c_width=6.855u c_length=6.855u
X4900 VTOP A44_CDAC_CAP_BANK_ASSEMBLY_R8_M6_0/A44_CAP_CORE128_M6_R1_0/CAP_BOTTOM_033 cap_mim_2f0_m4m5_noshield c_width=6.855u c_length=6.855u
X4901 VTOP A44_CDAC_CAP_BANK_ASSEMBLY_R8_M6_0/A44_CAP_CORE128_M6_R1_0/CAP_BOTTOM_033 cap_mim_2f0_m4m5_noshield c_width=6.855u c_length=6.855u
X4902 VTOP A44_CDAC_CAP_BANK_ASSEMBLY_R8_M6_0/A44_CAP_CORE128_M6_R1_0/CAP_BOTTOM_033 cap_mim_2f0_m4m5_noshield c_width=6.855u c_length=6.855u
X4903 VTOP A44_CDAC_CAP_BANK_ASSEMBLY_R8_M6_0/A44_CAP_CORE128_M6_R1_0/CAP_BOTTOM_033 cap_mim_2f0_m4m5_noshield c_width=6.855u c_length=6.855u
X4904 VTOP A44_CDAC_CAP_BANK_ASSEMBLY_R8_M6_0/A44_CAP_CORE128_M6_R1_0/CAP_BOTTOM_047 cap_mim_2f0_m4m5_noshield c_width=6.855u c_length=6.855u
X4905 VTOP A44_CDAC_CAP_BANK_ASSEMBLY_R8_M6_0/A44_CAP_CORE128_M6_R1_0/CAP_BOTTOM_047 cap_mim_2f0_m4m5_noshield c_width=6.855u c_length=6.855u
X4906 VTOP A44_CDAC_CAP_BANK_ASSEMBLY_R8_M6_0/A44_CAP_CORE128_M6_R1_0/CAP_BOTTOM_047 cap_mim_2f0_m4m5_noshield c_width=6.855u c_length=6.855u
X4907 VTOP A44_CDAC_CAP_BANK_ASSEMBLY_R8_M6_0/A44_CAP_CORE128_M6_R1_0/CAP_BOTTOM_047 cap_mim_2f0_m4m5_noshield c_width=6.855u c_length=6.855u
X4908 VTOP A44_CDAC_CAP_BANK_ASSEMBLY_R8_M6_0/A44_CAP_CORE128_M6_R1_0/CAP_BOTTOM_047 cap_mim_2f0_m4m5_noshield c_width=6.855u c_length=6.855u
X4909 VTOP A44_CDAC_CAP_BANK_ASSEMBLY_R8_M6_0/A44_CAP_CORE128_M6_R1_0/CAP_BOTTOM_047 cap_mim_2f0_m4m5_noshield c_width=6.855u c_length=6.855u
X4910 VTOP A44_CDAC_CAP_BANK_ASSEMBLY_R8_M6_0/A44_CAP_CORE128_M6_R1_0/CAP_BOTTOM_126 cap_mim_2f0_m4m5_noshield c_width=6.855u c_length=6.855u
X4911 VTOP A44_CDAC_CAP_BANK_ASSEMBLY_R8_M6_0/A44_CAP_CORE128_M6_R1_0/CAP_BOTTOM_126 cap_mim_2f0_m4m5_noshield c_width=6.855u c_length=6.855u
X4912 VTOP A44_CDAC_CAP_BANK_ASSEMBLY_R8_M6_0/A44_CAP_CORE128_M6_R1_0/CAP_BOTTOM_126 cap_mim_2f0_m4m5_noshield c_width=6.855u c_length=6.855u
X4913 VTOP A44_CDAC_CAP_BANK_ASSEMBLY_R8_M6_0/A44_CAP_CORE128_M6_R1_0/CAP_BOTTOM_126 cap_mim_2f0_m4m5_noshield c_width=6.855u c_length=6.855u
X4914 VTOP A44_CDAC_CAP_BANK_ASSEMBLY_R8_M6_0/A44_CAP_CORE128_M6_R1_0/CAP_BOTTOM_126 cap_mim_2f0_m4m5_noshield c_width=6.855u c_length=6.855u
X4915 VTOP A44_CDAC_CAP_BANK_ASSEMBLY_R8_M6_0/A44_CAP_CORE128_M6_R1_0/CAP_BOTTOM_126 cap_mim_2f0_m4m5_noshield c_width=6.855u c_length=6.855u
X4916 VTOP A44_CDAC_CAP_BANK_ASSEMBLY_R8_M6_0/A44_CAP_CORE128_M6_R1_0/CAP_BOTTOM_008 cap_mim_2f0_m4m5_noshield c_width=6.855u c_length=6.855u
X4917 VTOP A44_CDAC_CAP_BANK_ASSEMBLY_R8_M6_0/A44_CAP_CORE128_M6_R1_0/CAP_BOTTOM_008 cap_mim_2f0_m4m5_noshield c_width=6.855u c_length=6.855u
X4918 VTOP A44_CDAC_CAP_BANK_ASSEMBLY_R8_M6_0/A44_CAP_CORE128_M6_R1_0/CAP_BOTTOM_008 cap_mim_2f0_m4m5_noshield c_width=6.855u c_length=6.855u
X4919 VTOP A44_CDAC_CAP_BANK_ASSEMBLY_R8_M6_0/A44_CAP_CORE128_M6_R1_0/CAP_BOTTOM_008 cap_mim_2f0_m4m5_noshield c_width=6.855u c_length=6.855u
X4920 VTOP A44_CDAC_CAP_BANK_ASSEMBLY_R8_M6_0/A44_CAP_CORE128_M6_R1_0/CAP_BOTTOM_008 cap_mim_2f0_m4m5_noshield c_width=6.855u c_length=6.855u
X4921 VTOP A44_CDAC_CAP_BANK_ASSEMBLY_R8_M6_0/A44_CAP_CORE128_M6_R1_0/CAP_BOTTOM_008 cap_mim_2f0_m4m5_noshield c_width=6.855u c_length=6.855u
X4922 VTOP A44_CDAC_CAP_BANK_ASSEMBLY_R8_M6_0/A44_CAP_CORE128_M6_R1_0/CAP_BOTTOM_027 cap_mim_2f0_m4m5_noshield c_width=6.855u c_length=6.855u
X4923 VTOP A44_CDAC_CAP_BANK_ASSEMBLY_R8_M6_0/A44_CAP_CORE128_M6_R1_0/CAP_BOTTOM_027 cap_mim_2f0_m4m5_noshield c_width=6.855u c_length=6.855u
X4924 VTOP A44_CDAC_CAP_BANK_ASSEMBLY_R8_M6_0/A44_CAP_CORE128_M6_R1_0/CAP_BOTTOM_027 cap_mim_2f0_m4m5_noshield c_width=6.855u c_length=6.855u
X4925 VTOP A44_CDAC_CAP_BANK_ASSEMBLY_R8_M6_0/A44_CAP_CORE128_M6_R1_0/CAP_BOTTOM_027 cap_mim_2f0_m4m5_noshield c_width=6.855u c_length=6.855u
X4926 VTOP A44_CDAC_CAP_BANK_ASSEMBLY_R8_M6_0/A44_CAP_CORE128_M6_R1_0/CAP_BOTTOM_027 cap_mim_2f0_m4m5_noshield c_width=6.855u c_length=6.855u
X4927 VTOP A44_CDAC_CAP_BANK_ASSEMBLY_R8_M6_0/A44_CAP_CORE128_M6_R1_0/CAP_BOTTOM_027 cap_mim_2f0_m4m5_noshield c_width=6.855u c_length=6.855u
X4928 VTOP A44_CDAC_CAP_BANK_ASSEMBLY_R8_M6_0/A44_CAP_CORE128_M6_R1_0/CAP_BOTTOM_019 cap_mim_2f0_m4m5_noshield c_width=6.855u c_length=6.855u
X4929 VTOP A44_CDAC_CAP_BANK_ASSEMBLY_R8_M6_0/A44_CAP_CORE128_M6_R1_0/CAP_BOTTOM_019 cap_mim_2f0_m4m5_noshield c_width=6.855u c_length=6.855u
X4930 VTOP A44_CDAC_CAP_BANK_ASSEMBLY_R8_M6_0/A44_CAP_CORE128_M6_R1_0/CAP_BOTTOM_019 cap_mim_2f0_m4m5_noshield c_width=6.855u c_length=6.855u
X4931 VTOP A44_CDAC_CAP_BANK_ASSEMBLY_R8_M6_0/A44_CAP_CORE128_M6_R1_0/CAP_BOTTOM_019 cap_mim_2f0_m4m5_noshield c_width=6.855u c_length=6.855u
X4932 VTOP A44_CDAC_CAP_BANK_ASSEMBLY_R8_M6_0/A44_CAP_CORE128_M6_R1_0/CAP_BOTTOM_019 cap_mim_2f0_m4m5_noshield c_width=6.855u c_length=6.855u
X4933 VTOP A44_CDAC_CAP_BANK_ASSEMBLY_R8_M6_0/A44_CAP_CORE128_M6_R1_0/CAP_BOTTOM_019 cap_mim_2f0_m4m5_noshield c_width=6.855u c_length=6.855u
X4934 VTOP A44_CDAC_CAP_BANK_ASSEMBLY_R8_M6_0/A44_CAP_CORE128_M6_R1_0/CAP_BOTTOM_102 cap_mim_2f0_m4m5_noshield c_width=6.855u c_length=6.855u
X4935 VTOP A44_CDAC_CAP_BANK_ASSEMBLY_R8_M6_0/A44_CAP_CORE128_M6_R1_0/CAP_BOTTOM_102 cap_mim_2f0_m4m5_noshield c_width=6.855u c_length=6.855u
X4936 VTOP A44_CDAC_CAP_BANK_ASSEMBLY_R8_M6_0/A44_CAP_CORE128_M6_R1_0/CAP_BOTTOM_102 cap_mim_2f0_m4m5_noshield c_width=6.855u c_length=6.855u
X4937 VTOP A44_CDAC_CAP_BANK_ASSEMBLY_R8_M6_0/A44_CAP_CORE128_M6_R1_0/CAP_BOTTOM_102 cap_mim_2f0_m4m5_noshield c_width=6.855u c_length=6.855u
X4938 VTOP A44_CDAC_CAP_BANK_ASSEMBLY_R8_M6_0/A44_CAP_CORE128_M6_R1_0/CAP_BOTTOM_102 cap_mim_2f0_m4m5_noshield c_width=6.855u c_length=6.855u
X4939 VTOP A44_CDAC_CAP_BANK_ASSEMBLY_R8_M6_0/A44_CAP_CORE128_M6_R1_0/CAP_BOTTOM_102 cap_mim_2f0_m4m5_noshield c_width=6.855u c_length=6.855u
X4940 VTOP A44_CDAC_CAP_BANK_ASSEMBLY_R8_M6_0/A44_CAP_CORE128_M6_R1_0/CAP_BOTTOM_083 cap_mim_2f0_m4m5_noshield c_width=6.855u c_length=6.855u
X4941 VTOP A44_CDAC_CAP_BANK_ASSEMBLY_R8_M6_0/A44_CAP_CORE128_M6_R1_0/CAP_BOTTOM_083 cap_mim_2f0_m4m5_noshield c_width=6.855u c_length=6.855u
X4942 VTOP A44_CDAC_CAP_BANK_ASSEMBLY_R8_M6_0/A44_CAP_CORE128_M6_R1_0/CAP_BOTTOM_083 cap_mim_2f0_m4m5_noshield c_width=6.855u c_length=6.855u
X4943 VTOP A44_CDAC_CAP_BANK_ASSEMBLY_R8_M6_0/A44_CAP_CORE128_M6_R1_0/CAP_BOTTOM_083 cap_mim_2f0_m4m5_noshield c_width=6.855u c_length=6.855u
X4944 VTOP A44_CDAC_CAP_BANK_ASSEMBLY_R8_M6_0/A44_CAP_CORE128_M6_R1_0/CAP_BOTTOM_083 cap_mim_2f0_m4m5_noshield c_width=6.855u c_length=6.855u
X4945 VTOP A44_CDAC_CAP_BANK_ASSEMBLY_R8_M6_0/A44_CAP_CORE128_M6_R1_0/CAP_BOTTOM_083 cap_mim_2f0_m4m5_noshield c_width=6.855u c_length=6.855u
X4946 VTOP A44_CDAC_CAP_BANK_ASSEMBLY_R8_M6_0/A44_CAP_CORE128_M6_R1_0/CAP_BOTTOM_065 cap_mim_2f0_m4m5_noshield c_width=6.855u c_length=6.855u
X4947 VTOP A44_CDAC_CAP_BANK_ASSEMBLY_R8_M6_0/A44_CAP_CORE128_M6_R1_0/CAP_BOTTOM_065 cap_mim_2f0_m4m5_noshield c_width=6.855u c_length=6.855u
X4948 VTOP A44_CDAC_CAP_BANK_ASSEMBLY_R8_M6_0/A44_CAP_CORE128_M6_R1_0/CAP_BOTTOM_065 cap_mim_2f0_m4m5_noshield c_width=6.855u c_length=6.855u
X4949 VTOP A44_CDAC_CAP_BANK_ASSEMBLY_R8_M6_0/A44_CAP_CORE128_M6_R1_0/CAP_BOTTOM_065 cap_mim_2f0_m4m5_noshield c_width=6.855u c_length=6.855u
X4950 VTOP A44_CDAC_CAP_BANK_ASSEMBLY_R8_M6_0/A44_CAP_CORE128_M6_R1_0/CAP_BOTTOM_065 cap_mim_2f0_m4m5_noshield c_width=6.855u c_length=6.855u
X4951 VTOP A44_CDAC_CAP_BANK_ASSEMBLY_R8_M6_0/A44_CAP_CORE128_M6_R1_0/CAP_BOTTOM_065 cap_mim_2f0_m4m5_noshield c_width=6.855u c_length=6.855u
X4952 VTOP A44_CDAC_CAP_BANK_ASSEMBLY_R8_M6_0/A44_CAP_CORE128_M6_R1_0/CAP_BOTTOM_054 cap_mim_2f0_m4m5_noshield c_width=6.855u c_length=6.855u
X4953 VTOP A44_CDAC_CAP_BANK_ASSEMBLY_R8_M6_0/A44_CAP_CORE128_M6_R1_0/CAP_BOTTOM_054 cap_mim_2f0_m4m5_noshield c_width=6.855u c_length=6.855u
X4954 VTOP A44_CDAC_CAP_BANK_ASSEMBLY_R8_M6_0/A44_CAP_CORE128_M6_R1_0/CAP_BOTTOM_054 cap_mim_2f0_m4m5_noshield c_width=6.855u c_length=6.855u
X4955 VTOP A44_CDAC_CAP_BANK_ASSEMBLY_R8_M6_0/A44_CAP_CORE128_M6_R1_0/CAP_BOTTOM_054 cap_mim_2f0_m4m5_noshield c_width=6.855u c_length=6.855u
X4956 VTOP A44_CDAC_CAP_BANK_ASSEMBLY_R8_M6_0/A44_CAP_CORE128_M6_R1_0/CAP_BOTTOM_054 cap_mim_2f0_m4m5_noshield c_width=6.855u c_length=6.855u
X4957 VTOP A44_CDAC_CAP_BANK_ASSEMBLY_R8_M6_0/A44_CAP_CORE128_M6_R1_0/CAP_BOTTOM_054 cap_mim_2f0_m4m5_noshield c_width=6.855u c_length=6.855u
X4958 VTOP A44_CDAC_CAP_BANK_ASSEMBLY_R8_M6_0/A44_CAP_CORE128_M6_R1_0/CAP_BOTTOM_032 cap_mim_2f0_m4m5_noshield c_width=6.855u c_length=6.855u
X4959 VTOP A44_CDAC_CAP_BANK_ASSEMBLY_R8_M6_0/A44_CAP_CORE128_M6_R1_0/CAP_BOTTOM_032 cap_mim_2f0_m4m5_noshield c_width=6.855u c_length=6.855u
X4960 VTOP A44_CDAC_CAP_BANK_ASSEMBLY_R8_M6_0/A44_CAP_CORE128_M6_R1_0/CAP_BOTTOM_032 cap_mim_2f0_m4m5_noshield c_width=6.855u c_length=6.855u
X4961 VTOP A44_CDAC_CAP_BANK_ASSEMBLY_R8_M6_0/A44_CAP_CORE128_M6_R1_0/CAP_BOTTOM_032 cap_mim_2f0_m4m5_noshield c_width=6.855u c_length=6.855u
X4962 VTOP A44_CDAC_CAP_BANK_ASSEMBLY_R8_M6_0/A44_CAP_CORE128_M6_R1_0/CAP_BOTTOM_032 cap_mim_2f0_m4m5_noshield c_width=6.855u c_length=6.855u
X4963 VTOP A44_CDAC_CAP_BANK_ASSEMBLY_R8_M6_0/A44_CAP_CORE128_M6_R1_0/CAP_BOTTOM_032 cap_mim_2f0_m4m5_noshield c_width=6.855u c_length=6.855u
X4964 VTOP A44_CDAC_CAP_BANK_ASSEMBLY_R8_M6_0/A44_CAP_CORE128_M6_R1_0/CAP_BOTTOM_046 cap_mim_2f0_m4m5_noshield c_width=6.855u c_length=6.855u
X4965 VTOP A44_CDAC_CAP_BANK_ASSEMBLY_R8_M6_0/A44_CAP_CORE128_M6_R1_0/CAP_BOTTOM_046 cap_mim_2f0_m4m5_noshield c_width=6.855u c_length=6.855u
X4966 VTOP A44_CDAC_CAP_BANK_ASSEMBLY_R8_M6_0/A44_CAP_CORE128_M6_R1_0/CAP_BOTTOM_046 cap_mim_2f0_m4m5_noshield c_width=6.855u c_length=6.855u
X4967 VTOP A44_CDAC_CAP_BANK_ASSEMBLY_R8_M6_0/A44_CAP_CORE128_M6_R1_0/CAP_BOTTOM_046 cap_mim_2f0_m4m5_noshield c_width=6.855u c_length=6.855u
X4968 VTOP A44_CDAC_CAP_BANK_ASSEMBLY_R8_M6_0/A44_CAP_CORE128_M6_R1_0/CAP_BOTTOM_046 cap_mim_2f0_m4m5_noshield c_width=6.855u c_length=6.855u
X4969 VTOP A44_CDAC_CAP_BANK_ASSEMBLY_R8_M6_0/A44_CAP_CORE128_M6_R1_0/CAP_BOTTOM_046 cap_mim_2f0_m4m5_noshield c_width=6.855u c_length=6.855u
X4970 VTOP A44_CDAC_CAP_BANK_ASSEMBLY_R8_M6_0/A44_CAP_CORE128_M6_R1_0/CAP_BOTTOM_125 cap_mim_2f0_m4m5_noshield c_width=6.855u c_length=6.855u
X4971 VTOP A44_CDAC_CAP_BANK_ASSEMBLY_R8_M6_0/A44_CAP_CORE128_M6_R1_0/CAP_BOTTOM_125 cap_mim_2f0_m4m5_noshield c_width=6.855u c_length=6.855u
X4972 VTOP A44_CDAC_CAP_BANK_ASSEMBLY_R8_M6_0/A44_CAP_CORE128_M6_R1_0/CAP_BOTTOM_125 cap_mim_2f0_m4m5_noshield c_width=6.855u c_length=6.855u
X4973 VTOP A44_CDAC_CAP_BANK_ASSEMBLY_R8_M6_0/A44_CAP_CORE128_M6_R1_0/CAP_BOTTOM_125 cap_mim_2f0_m4m5_noshield c_width=6.855u c_length=6.855u
X4974 VTOP A44_CDAC_CAP_BANK_ASSEMBLY_R8_M6_0/A44_CAP_CORE128_M6_R1_0/CAP_BOTTOM_125 cap_mim_2f0_m4m5_noshield c_width=6.855u c_length=6.855u
X4975 VTOP A44_CDAC_CAP_BANK_ASSEMBLY_R8_M6_0/A44_CAP_CORE128_M6_R1_0/CAP_BOTTOM_125 cap_mim_2f0_m4m5_noshield c_width=6.855u c_length=6.855u
X4976 VTOP A44_CDAC_CAP_BANK_ASSEMBLY_R8_M6_0/A44_CAP_CORE128_M6_R1_0/CAP_BOTTOM_026 cap_mim_2f0_m4m5_noshield c_width=6.855u c_length=6.855u
X4977 VTOP A44_CDAC_CAP_BANK_ASSEMBLY_R8_M6_0/A44_CAP_CORE128_M6_R1_0/CAP_BOTTOM_026 cap_mim_2f0_m4m5_noshield c_width=6.855u c_length=6.855u
X4978 VTOP A44_CDAC_CAP_BANK_ASSEMBLY_R8_M6_0/A44_CAP_CORE128_M6_R1_0/CAP_BOTTOM_026 cap_mim_2f0_m4m5_noshield c_width=6.855u c_length=6.855u
X4979 VTOP A44_CDAC_CAP_BANK_ASSEMBLY_R8_M6_0/A44_CAP_CORE128_M6_R1_0/CAP_BOTTOM_026 cap_mim_2f0_m4m5_noshield c_width=6.855u c_length=6.855u
X4980 VTOP A44_CDAC_CAP_BANK_ASSEMBLY_R8_M6_0/A44_CAP_CORE128_M6_R1_0/CAP_BOTTOM_026 cap_mim_2f0_m4m5_noshield c_width=6.855u c_length=6.855u
X4981 VTOP A44_CDAC_CAP_BANK_ASSEMBLY_R8_M6_0/A44_CAP_CORE128_M6_R1_0/CAP_BOTTOM_026 cap_mim_2f0_m4m5_noshield c_width=6.855u c_length=6.855u
X4982 VTOP A44_CDAC_CAP_BANK_ASSEMBLY_R8_M6_0/A44_CAP_CORE128_M6_R1_0/CAP_BOTTOM_018 cap_mim_2f0_m4m5_noshield c_width=6.855u c_length=6.855u
X4983 VTOP A44_CDAC_CAP_BANK_ASSEMBLY_R8_M6_0/A44_CAP_CORE128_M6_R1_0/CAP_BOTTOM_018 cap_mim_2f0_m4m5_noshield c_width=6.855u c_length=6.855u
X4984 VTOP A44_CDAC_CAP_BANK_ASSEMBLY_R8_M6_0/A44_CAP_CORE128_M6_R1_0/CAP_BOTTOM_018 cap_mim_2f0_m4m5_noshield c_width=6.855u c_length=6.855u
X4985 VTOP A44_CDAC_CAP_BANK_ASSEMBLY_R8_M6_0/A44_CAP_CORE128_M6_R1_0/CAP_BOTTOM_018 cap_mim_2f0_m4m5_noshield c_width=6.855u c_length=6.855u
X4986 VTOP A44_CDAC_CAP_BANK_ASSEMBLY_R8_M6_0/A44_CAP_CORE128_M6_R1_0/CAP_BOTTOM_018 cap_mim_2f0_m4m5_noshield c_width=6.855u c_length=6.855u
X4987 VTOP A44_CDAC_CAP_BANK_ASSEMBLY_R8_M6_0/A44_CAP_CORE128_M6_R1_0/CAP_BOTTOM_018 cap_mim_2f0_m4m5_noshield c_width=6.855u c_length=6.855u
X4988 VTOP A44_CDAC_CAP_BANK_ASSEMBLY_R8_M6_0/A44_CAP_CORE128_M6_R1_0/CAP_BOTTOM_101 cap_mim_2f0_m4m5_noshield c_width=6.855u c_length=6.855u
X4989 VTOP A44_CDAC_CAP_BANK_ASSEMBLY_R8_M6_0/A44_CAP_CORE128_M6_R1_0/CAP_BOTTOM_101 cap_mim_2f0_m4m5_noshield c_width=6.855u c_length=6.855u
X4990 VTOP A44_CDAC_CAP_BANK_ASSEMBLY_R8_M6_0/A44_CAP_CORE128_M6_R1_0/CAP_BOTTOM_101 cap_mim_2f0_m4m5_noshield c_width=6.855u c_length=6.855u
X4991 VTOP A44_CDAC_CAP_BANK_ASSEMBLY_R8_M6_0/A44_CAP_CORE128_M6_R1_0/CAP_BOTTOM_101 cap_mim_2f0_m4m5_noshield c_width=6.855u c_length=6.855u
X4992 VTOP A44_CDAC_CAP_BANK_ASSEMBLY_R8_M6_0/A44_CAP_CORE128_M6_R1_0/CAP_BOTTOM_101 cap_mim_2f0_m4m5_noshield c_width=6.855u c_length=6.855u
X4993 VTOP A44_CDAC_CAP_BANK_ASSEMBLY_R8_M6_0/A44_CAP_CORE128_M6_R1_0/CAP_BOTTOM_101 cap_mim_2f0_m4m5_noshield c_width=6.855u c_length=6.855u
X4994 VTOP A44_CDAC_CAP_BANK_ASSEMBLY_R8_M6_0/A44_CAP_CORE128_M6_R1_0/CAP_BOTTOM_082 cap_mim_2f0_m4m5_noshield c_width=6.855u c_length=6.855u
X4995 VTOP A44_CDAC_CAP_BANK_ASSEMBLY_R8_M6_0/A44_CAP_CORE128_M6_R1_0/CAP_BOTTOM_082 cap_mim_2f0_m4m5_noshield c_width=6.855u c_length=6.855u
X4996 VTOP A44_CDAC_CAP_BANK_ASSEMBLY_R8_M6_0/A44_CAP_CORE128_M6_R1_0/CAP_BOTTOM_082 cap_mim_2f0_m4m5_noshield c_width=6.855u c_length=6.855u
X4997 VTOP A44_CDAC_CAP_BANK_ASSEMBLY_R8_M6_0/A44_CAP_CORE128_M6_R1_0/CAP_BOTTOM_082 cap_mim_2f0_m4m5_noshield c_width=6.855u c_length=6.855u
X4998 VTOP A44_CDAC_CAP_BANK_ASSEMBLY_R8_M6_0/A44_CAP_CORE128_M6_R1_0/CAP_BOTTOM_082 cap_mim_2f0_m4m5_noshield c_width=6.855u c_length=6.855u
X4999 VTOP A44_CDAC_CAP_BANK_ASSEMBLY_R8_M6_0/A44_CAP_CORE128_M6_R1_0/CAP_BOTTOM_082 cap_mim_2f0_m4m5_noshield c_width=6.855u c_length=6.855u
X5000 VTOP A44_CDAC_CAP_BANK_ASSEMBLY_R8_M6_0/A44_CAP_CORE128_M6_R1_0/CAP_BOTTOM_064 cap_mim_2f0_m4m5_noshield c_width=6.855u c_length=6.855u
X5001 VTOP A44_CDAC_CAP_BANK_ASSEMBLY_R8_M6_0/A44_CAP_CORE128_M6_R1_0/CAP_BOTTOM_064 cap_mim_2f0_m4m5_noshield c_width=6.855u c_length=6.855u
X5002 VTOP A44_CDAC_CAP_BANK_ASSEMBLY_R8_M6_0/A44_CAP_CORE128_M6_R1_0/CAP_BOTTOM_064 cap_mim_2f0_m4m5_noshield c_width=6.855u c_length=6.855u
X5003 VTOP A44_CDAC_CAP_BANK_ASSEMBLY_R8_M6_0/A44_CAP_CORE128_M6_R1_0/CAP_BOTTOM_064 cap_mim_2f0_m4m5_noshield c_width=6.855u c_length=6.855u
X5004 VTOP A44_CDAC_CAP_BANK_ASSEMBLY_R8_M6_0/A44_CAP_CORE128_M6_R1_0/CAP_BOTTOM_064 cap_mim_2f0_m4m5_noshield c_width=6.855u c_length=6.855u
X5005 VTOP A44_CDAC_CAP_BANK_ASSEMBLY_R8_M6_0/A44_CAP_CORE128_M6_R1_0/CAP_BOTTOM_064 cap_mim_2f0_m4m5_noshield c_width=6.855u c_length=6.855u
X5006 VTOP A44_CDAC_CAP_BANK_ASSEMBLY_R8_M6_0/A44_CAP_CORE128_M6_R1_0/CAP_BOTTOM_072 cap_mim_2f0_m4m5_noshield c_width=6.855u c_length=6.855u
X5007 VTOP A44_CDAC_CAP_BANK_ASSEMBLY_R8_M6_0/A44_CAP_CORE128_M6_R1_0/CAP_BOTTOM_072 cap_mim_2f0_m4m5_noshield c_width=6.855u c_length=6.855u
X5008 VTOP A44_CDAC_CAP_BANK_ASSEMBLY_R8_M6_0/A44_CAP_CORE128_M6_R1_0/CAP_BOTTOM_072 cap_mim_2f0_m4m5_noshield c_width=6.855u c_length=6.855u
X5009 VTOP A44_CDAC_CAP_BANK_ASSEMBLY_R8_M6_0/A44_CAP_CORE128_M6_R1_0/CAP_BOTTOM_072 cap_mim_2f0_m4m5_noshield c_width=6.855u c_length=6.855u
X5010 VTOP A44_CDAC_CAP_BANK_ASSEMBLY_R8_M6_0/A44_CAP_CORE128_M6_R1_0/CAP_BOTTOM_072 cap_mim_2f0_m4m5_noshield c_width=6.855u c_length=6.855u
X5011 VTOP A44_CDAC_CAP_BANK_ASSEMBLY_R8_M6_0/A44_CAP_CORE128_M6_R1_0/CAP_BOTTOM_072 cap_mim_2f0_m4m5_noshield c_width=6.855u c_length=6.855u
X5012 VTOP A44_CDAC_CAP_BANK_ASSEMBLY_R8_M6_0/A44_CAP_CORE128_M6_R1_0/CAP_BOTTOM_053 cap_mim_2f0_m4m5_noshield c_width=6.855u c_length=6.855u
X5013 VTOP A44_CDAC_CAP_BANK_ASSEMBLY_R8_M6_0/A44_CAP_CORE128_M6_R1_0/CAP_BOTTOM_053 cap_mim_2f0_m4m5_noshield c_width=6.855u c_length=6.855u
X5014 VTOP A44_CDAC_CAP_BANK_ASSEMBLY_R8_M6_0/A44_CAP_CORE128_M6_R1_0/CAP_BOTTOM_053 cap_mim_2f0_m4m5_noshield c_width=6.855u c_length=6.855u
X5015 VTOP A44_CDAC_CAP_BANK_ASSEMBLY_R8_M6_0/A44_CAP_CORE128_M6_R1_0/CAP_BOTTOM_053 cap_mim_2f0_m4m5_noshield c_width=6.855u c_length=6.855u
X5016 VTOP A44_CDAC_CAP_BANK_ASSEMBLY_R8_M6_0/A44_CAP_CORE128_M6_R1_0/CAP_BOTTOM_053 cap_mim_2f0_m4m5_noshield c_width=6.855u c_length=6.855u
X5017 VTOP A44_CDAC_CAP_BANK_ASSEMBLY_R8_M6_0/A44_CAP_CORE128_M6_R1_0/CAP_BOTTOM_053 cap_mim_2f0_m4m5_noshield c_width=6.855u c_length=6.855u
X5018 VTOP A44_CDAC_CAP_BANK_ASSEMBLY_R8_M6_0/A44_CAP_CORE128_M6_R1_0/CAP_BOTTOM_063 cap_mim_2f0_m4m5_noshield c_width=6.855u c_length=6.855u
X5019 VTOP A44_CDAC_CAP_BANK_ASSEMBLY_R8_M6_0/A44_CAP_CORE128_M6_R1_0/CAP_BOTTOM_063 cap_mim_2f0_m4m5_noshield c_width=6.855u c_length=6.855u
X5020 VTOP A44_CDAC_CAP_BANK_ASSEMBLY_R8_M6_0/A44_CAP_CORE128_M6_R1_0/CAP_BOTTOM_063 cap_mim_2f0_m4m5_noshield c_width=6.855u c_length=6.855u
X5021 VTOP A44_CDAC_CAP_BANK_ASSEMBLY_R8_M6_0/A44_CAP_CORE128_M6_R1_0/CAP_BOTTOM_063 cap_mim_2f0_m4m5_noshield c_width=6.855u c_length=6.855u
X5022 VTOP A44_CDAC_CAP_BANK_ASSEMBLY_R8_M6_0/A44_CAP_CORE128_M6_R1_0/CAP_BOTTOM_063 cap_mim_2f0_m4m5_noshield c_width=6.855u c_length=6.855u
X5023 VTOP A44_CDAC_CAP_BANK_ASSEMBLY_R8_M6_0/A44_CAP_CORE128_M6_R1_0/CAP_BOTTOM_063 cap_mim_2f0_m4m5_noshield c_width=6.855u c_length=6.855u
X5024 VTOP A44_CDAC_CAP_BANK_ASSEMBLY_R8_M6_0/A44_CAP_CORE128_M6_R1_0/CAP_BOTTOM_045 cap_mim_2f0_m4m5_noshield c_width=6.855u c_length=6.855u
X5025 VTOP A44_CDAC_CAP_BANK_ASSEMBLY_R8_M6_0/A44_CAP_CORE128_M6_R1_0/CAP_BOTTOM_045 cap_mim_2f0_m4m5_noshield c_width=6.855u c_length=6.855u
X5026 VTOP A44_CDAC_CAP_BANK_ASSEMBLY_R8_M6_0/A44_CAP_CORE128_M6_R1_0/CAP_BOTTOM_045 cap_mim_2f0_m4m5_noshield c_width=6.855u c_length=6.855u
X5027 VTOP A44_CDAC_CAP_BANK_ASSEMBLY_R8_M6_0/A44_CAP_CORE128_M6_R1_0/CAP_BOTTOM_045 cap_mim_2f0_m4m5_noshield c_width=6.855u c_length=6.855u
X5028 VTOP A44_CDAC_CAP_BANK_ASSEMBLY_R8_M6_0/A44_CAP_CORE128_M6_R1_0/CAP_BOTTOM_045 cap_mim_2f0_m4m5_noshield c_width=6.855u c_length=6.855u
X5029 VTOP A44_CDAC_CAP_BANK_ASSEMBLY_R8_M6_0/A44_CAP_CORE128_M6_R1_0/CAP_BOTTOM_045 cap_mim_2f0_m4m5_noshield c_width=6.855u c_length=6.855u
X5030 VTOP A44_CDAC_CAP_BANK_ASSEMBLY_R8_M6_0/A44_CAP_CORE128_M6_R1_0/CAP_BOTTOM_124 cap_mim_2f0_m4m5_noshield c_width=6.855u c_length=6.855u
X5031 VTOP A44_CDAC_CAP_BANK_ASSEMBLY_R8_M6_0/A44_CAP_CORE128_M6_R1_0/CAP_BOTTOM_124 cap_mim_2f0_m4m5_noshield c_width=6.855u c_length=6.855u
X5032 VTOP A44_CDAC_CAP_BANK_ASSEMBLY_R8_M6_0/A44_CAP_CORE128_M6_R1_0/CAP_BOTTOM_124 cap_mim_2f0_m4m5_noshield c_width=6.855u c_length=6.855u
X5033 VTOP A44_CDAC_CAP_BANK_ASSEMBLY_R8_M6_0/A44_CAP_CORE128_M6_R1_0/CAP_BOTTOM_124 cap_mim_2f0_m4m5_noshield c_width=6.855u c_length=6.855u
X5034 VTOP A44_CDAC_CAP_BANK_ASSEMBLY_R8_M6_0/A44_CAP_CORE128_M6_R1_0/CAP_BOTTOM_124 cap_mim_2f0_m4m5_noshield c_width=6.855u c_length=6.855u
X5035 VTOP A44_CDAC_CAP_BANK_ASSEMBLY_R8_M6_0/A44_CAP_CORE128_M6_R1_0/CAP_BOTTOM_124 cap_mim_2f0_m4m5_noshield c_width=6.855u c_length=6.855u
X5036 VTOP A44_CDAC_CAP_BANK_ASSEMBLY_R8_M6_0/A44_CAP_CORE128_M6_R1_0/CAP_BOTTOM_007 cap_mim_2f0_m4m5_noshield c_width=6.855u c_length=6.855u
X5037 VTOP A44_CDAC_CAP_BANK_ASSEMBLY_R8_M6_0/A44_CAP_CORE128_M6_R1_0/CAP_BOTTOM_007 cap_mim_2f0_m4m5_noshield c_width=6.855u c_length=6.855u
X5038 VTOP A44_CDAC_CAP_BANK_ASSEMBLY_R8_M6_0/A44_CAP_CORE128_M6_R1_0/CAP_BOTTOM_007 cap_mim_2f0_m4m5_noshield c_width=6.855u c_length=6.855u
X5039 VTOP A44_CDAC_CAP_BANK_ASSEMBLY_R8_M6_0/A44_CAP_CORE128_M6_R1_0/CAP_BOTTOM_007 cap_mim_2f0_m4m5_noshield c_width=6.855u c_length=6.855u
X5040 VTOP A44_CDAC_CAP_BANK_ASSEMBLY_R8_M6_0/A44_CAP_CORE128_M6_R1_0/CAP_BOTTOM_007 cap_mim_2f0_m4m5_noshield c_width=6.855u c_length=6.855u
X5041 VTOP A44_CDAC_CAP_BANK_ASSEMBLY_R8_M6_0/A44_CAP_CORE128_M6_R1_0/CAP_BOTTOM_007 cap_mim_2f0_m4m5_noshield c_width=6.855u c_length=6.855u
X5042 VTOP A44_CDAC_CAP_BANK_ASSEMBLY_R8_M6_0/A44_CAP_CORE128_M6_R1_0/CAP_BOTTOM_025 cap_mim_2f0_m4m5_noshield c_width=6.855u c_length=6.855u
X5043 VTOP A44_CDAC_CAP_BANK_ASSEMBLY_R8_M6_0/A44_CAP_CORE128_M6_R1_0/CAP_BOTTOM_025 cap_mim_2f0_m4m5_noshield c_width=6.855u c_length=6.855u
X5044 VTOP A44_CDAC_CAP_BANK_ASSEMBLY_R8_M6_0/A44_CAP_CORE128_M6_R1_0/CAP_BOTTOM_025 cap_mim_2f0_m4m5_noshield c_width=6.855u c_length=6.855u
X5045 VTOP A44_CDAC_CAP_BANK_ASSEMBLY_R8_M6_0/A44_CAP_CORE128_M6_R1_0/CAP_BOTTOM_025 cap_mim_2f0_m4m5_noshield c_width=6.855u c_length=6.855u
X5046 VTOP A44_CDAC_CAP_BANK_ASSEMBLY_R8_M6_0/A44_CAP_CORE128_M6_R1_0/CAP_BOTTOM_025 cap_mim_2f0_m4m5_noshield c_width=6.855u c_length=6.855u
X5047 VTOP A44_CDAC_CAP_BANK_ASSEMBLY_R8_M6_0/A44_CAP_CORE128_M6_R1_0/CAP_BOTTOM_025 cap_mim_2f0_m4m5_noshield c_width=6.855u c_length=6.855u
X5048 VTOP A44_CDAC_CAP_BANK_ASSEMBLY_R8_M6_0/A44_CAP_CORE128_M6_R1_0/CAP_BOTTOM_017 cap_mim_2f0_m4m5_noshield c_width=6.855u c_length=6.855u
X5049 VTOP A44_CDAC_CAP_BANK_ASSEMBLY_R8_M6_0/A44_CAP_CORE128_M6_R1_0/CAP_BOTTOM_017 cap_mim_2f0_m4m5_noshield c_width=6.855u c_length=6.855u
X5050 VTOP A44_CDAC_CAP_BANK_ASSEMBLY_R8_M6_0/A44_CAP_CORE128_M6_R1_0/CAP_BOTTOM_017 cap_mim_2f0_m4m5_noshield c_width=6.855u c_length=6.855u
X5051 VTOP A44_CDAC_CAP_BANK_ASSEMBLY_R8_M6_0/A44_CAP_CORE128_M6_R1_0/CAP_BOTTOM_017 cap_mim_2f0_m4m5_noshield c_width=6.855u c_length=6.855u
X5052 VTOP A44_CDAC_CAP_BANK_ASSEMBLY_R8_M6_0/A44_CAP_CORE128_M6_R1_0/CAP_BOTTOM_017 cap_mim_2f0_m4m5_noshield c_width=6.855u c_length=6.855u
X5053 VTOP A44_CDAC_CAP_BANK_ASSEMBLY_R8_M6_0/A44_CAP_CORE128_M6_R1_0/CAP_BOTTOM_017 cap_mim_2f0_m4m5_noshield c_width=6.855u c_length=6.855u
X5054 VTOP A44_CDAC_CAP_BANK_ASSEMBLY_R8_M6_0/A44_CAP_CORE128_M6_R1_0/CAP_BOTTOM_100 cap_mim_2f0_m4m5_noshield c_width=6.855u c_length=6.855u
X5055 VTOP A44_CDAC_CAP_BANK_ASSEMBLY_R8_M6_0/A44_CAP_CORE128_M6_R1_0/CAP_BOTTOM_100 cap_mim_2f0_m4m5_noshield c_width=6.855u c_length=6.855u
X5056 VTOP A44_CDAC_CAP_BANK_ASSEMBLY_R8_M6_0/A44_CAP_CORE128_M6_R1_0/CAP_BOTTOM_100 cap_mim_2f0_m4m5_noshield c_width=6.855u c_length=6.855u
X5057 VTOP A44_CDAC_CAP_BANK_ASSEMBLY_R8_M6_0/A44_CAP_CORE128_M6_R1_0/CAP_BOTTOM_100 cap_mim_2f0_m4m5_noshield c_width=6.855u c_length=6.855u
X5058 VTOP A44_CDAC_CAP_BANK_ASSEMBLY_R8_M6_0/A44_CAP_CORE128_M6_R1_0/CAP_BOTTOM_100 cap_mim_2f0_m4m5_noshield c_width=6.855u c_length=6.855u
X5059 VTOP A44_CDAC_CAP_BANK_ASSEMBLY_R8_M6_0/A44_CAP_CORE128_M6_R1_0/CAP_BOTTOM_100 cap_mim_2f0_m4m5_noshield c_width=6.855u c_length=6.855u
X5060 VTOP A44_CDAC_CAP_BANK_ASSEMBLY_R8_M6_0/A44_CAP_CORE128_M6_R1_0/CAP_BOTTOM_106 cap_mim_2f0_m4m5_noshield c_width=6.855u c_length=6.855u
X5061 VTOP A44_CDAC_CAP_BANK_ASSEMBLY_R8_M6_0/A44_CAP_CORE128_M6_R1_0/CAP_BOTTOM_106 cap_mim_2f0_m4m5_noshield c_width=6.855u c_length=6.855u
X5062 VTOP A44_CDAC_CAP_BANK_ASSEMBLY_R8_M6_0/A44_CAP_CORE128_M6_R1_0/CAP_BOTTOM_106 cap_mim_2f0_m4m5_noshield c_width=6.855u c_length=6.855u
X5063 VTOP A44_CDAC_CAP_BANK_ASSEMBLY_R8_M6_0/A44_CAP_CORE128_M6_R1_0/CAP_BOTTOM_106 cap_mim_2f0_m4m5_noshield c_width=6.855u c_length=6.855u
X5064 VTOP A44_CDAC_CAP_BANK_ASSEMBLY_R8_M6_0/A44_CAP_CORE128_M6_R1_0/CAP_BOTTOM_106 cap_mim_2f0_m4m5_noshield c_width=6.855u c_length=6.855u
X5065 VTOP A44_CDAC_CAP_BANK_ASSEMBLY_R8_M6_0/A44_CAP_CORE128_M6_R1_0/CAP_BOTTOM_106 cap_mim_2f0_m4m5_noshield c_width=6.855u c_length=6.855u
X5066 VTOP A44_CDAC_CAP_BANK_ASSEMBLY_R8_M6_0/A44_CAP_CORE128_M6_R1_0/CAP_BOTTOM_081 cap_mim_2f0_m4m5_noshield c_width=6.855u c_length=6.855u
X5067 VTOP A44_CDAC_CAP_BANK_ASSEMBLY_R8_M6_0/A44_CAP_CORE128_M6_R1_0/CAP_BOTTOM_081 cap_mim_2f0_m4m5_noshield c_width=6.855u c_length=6.855u
X5068 VTOP A44_CDAC_CAP_BANK_ASSEMBLY_R8_M6_0/A44_CAP_CORE128_M6_R1_0/CAP_BOTTOM_081 cap_mim_2f0_m4m5_noshield c_width=6.855u c_length=6.855u
X5069 VTOP A44_CDAC_CAP_BANK_ASSEMBLY_R8_M6_0/A44_CAP_CORE128_M6_R1_0/CAP_BOTTOM_081 cap_mim_2f0_m4m5_noshield c_width=6.855u c_length=6.855u
X5070 VTOP A44_CDAC_CAP_BANK_ASSEMBLY_R8_M6_0/A44_CAP_CORE128_M6_R1_0/CAP_BOTTOM_081 cap_mim_2f0_m4m5_noshield c_width=6.855u c_length=6.855u
X5071 VTOP A44_CDAC_CAP_BANK_ASSEMBLY_R8_M6_0/A44_CAP_CORE128_M6_R1_0/CAP_BOTTOM_081 cap_mim_2f0_m4m5_noshield c_width=6.855u c_length=6.855u
X5072 VTOP GND cap_mim_2f0_m4m5_noshield c_width=6.855u c_length=6.855u
X5073 VTOP GND cap_mim_2f0_m4m5_noshield c_width=6.855u c_length=6.855u
X5074 VTOP GND cap_mim_2f0_m4m5_noshield c_width=6.855u c_length=6.855u
X5075 VTOP GND cap_mim_2f0_m4m5_noshield c_width=6.855u c_length=6.855u
X5076 VTOP GND cap_mim_2f0_m4m5_noshield c_width=6.855u c_length=6.855u
X5077 VTOP GND cap_mim_2f0_m4m5_noshield c_width=6.855u c_length=6.855u
X5078 VTOP A44_CDAC_CAP_BANK_ASSEMBLY_R8_M6_0/A44_CAP_CORE128_M6_R1_0/CAP_BOTTOM_052 cap_mim_2f0_m4m5_noshield c_width=6.855u c_length=6.855u
X5079 VTOP A44_CDAC_CAP_BANK_ASSEMBLY_R8_M6_0/A44_CAP_CORE128_M6_R1_0/CAP_BOTTOM_052 cap_mim_2f0_m4m5_noshield c_width=6.855u c_length=6.855u
X5080 VTOP A44_CDAC_CAP_BANK_ASSEMBLY_R8_M6_0/A44_CAP_CORE128_M6_R1_0/CAP_BOTTOM_052 cap_mim_2f0_m4m5_noshield c_width=6.855u c_length=6.855u
X5081 VTOP A44_CDAC_CAP_BANK_ASSEMBLY_R8_M6_0/A44_CAP_CORE128_M6_R1_0/CAP_BOTTOM_052 cap_mim_2f0_m4m5_noshield c_width=6.855u c_length=6.855u
X5082 VTOP A44_CDAC_CAP_BANK_ASSEMBLY_R8_M6_0/A44_CAP_CORE128_M6_R1_0/CAP_BOTTOM_052 cap_mim_2f0_m4m5_noshield c_width=6.855u c_length=6.855u
X5083 VTOP A44_CDAC_CAP_BANK_ASSEMBLY_R8_M6_0/A44_CAP_CORE128_M6_R1_0/CAP_BOTTOM_052 cap_mim_2f0_m4m5_noshield c_width=6.855u c_length=6.855u
X5084 VTOP A44_CDAC_CAP_BANK_ASSEMBLY_R8_M6_0/A44_CAP_CORE128_M6_R1_0/CAP_BOTTOM_062 cap_mim_2f0_m4m5_noshield c_width=6.855u c_length=6.855u
X5085 VTOP A44_CDAC_CAP_BANK_ASSEMBLY_R8_M6_0/A44_CAP_CORE128_M6_R1_0/CAP_BOTTOM_062 cap_mim_2f0_m4m5_noshield c_width=6.855u c_length=6.855u
X5086 VTOP A44_CDAC_CAP_BANK_ASSEMBLY_R8_M6_0/A44_CAP_CORE128_M6_R1_0/CAP_BOTTOM_062 cap_mim_2f0_m4m5_noshield c_width=6.855u c_length=6.855u
X5087 VTOP A44_CDAC_CAP_BANK_ASSEMBLY_R8_M6_0/A44_CAP_CORE128_M6_R1_0/CAP_BOTTOM_062 cap_mim_2f0_m4m5_noshield c_width=6.855u c_length=6.855u
X5088 VTOP A44_CDAC_CAP_BANK_ASSEMBLY_R8_M6_0/A44_CAP_CORE128_M6_R1_0/CAP_BOTTOM_062 cap_mim_2f0_m4m5_noshield c_width=6.855u c_length=6.855u
X5089 VTOP A44_CDAC_CAP_BANK_ASSEMBLY_R8_M6_0/A44_CAP_CORE128_M6_R1_0/CAP_BOTTOM_062 cap_mim_2f0_m4m5_noshield c_width=6.855u c_length=6.855u
X5090 VTOP A44_CDAC_CAP_BANK_ASSEMBLY_R8_M6_0/A44_CAP_CORE128_M6_R1_0/CAP_BOTTOM_044 cap_mim_2f0_m4m5_noshield c_width=6.855u c_length=6.855u
X5091 VTOP A44_CDAC_CAP_BANK_ASSEMBLY_R8_M6_0/A44_CAP_CORE128_M6_R1_0/CAP_BOTTOM_044 cap_mim_2f0_m4m5_noshield c_width=6.855u c_length=6.855u
X5092 VTOP A44_CDAC_CAP_BANK_ASSEMBLY_R8_M6_0/A44_CAP_CORE128_M6_R1_0/CAP_BOTTOM_044 cap_mim_2f0_m4m5_noshield c_width=6.855u c_length=6.855u
X5093 VTOP A44_CDAC_CAP_BANK_ASSEMBLY_R8_M6_0/A44_CAP_CORE128_M6_R1_0/CAP_BOTTOM_044 cap_mim_2f0_m4m5_noshield c_width=6.855u c_length=6.855u
X5094 VTOP A44_CDAC_CAP_BANK_ASSEMBLY_R8_M6_0/A44_CAP_CORE128_M6_R1_0/CAP_BOTTOM_044 cap_mim_2f0_m4m5_noshield c_width=6.855u c_length=6.855u
X5095 VTOP A44_CDAC_CAP_BANK_ASSEMBLY_R8_M6_0/A44_CAP_CORE128_M6_R1_0/CAP_BOTTOM_044 cap_mim_2f0_m4m5_noshield c_width=6.855u c_length=6.855u
X5096 VTOP A44_CDAC_CAP_BANK_ASSEMBLY_R8_M6_0/A44_CAP_CORE128_M6_R1_0/CAP_BOTTOM_123 cap_mim_2f0_m4m5_noshield c_width=6.855u c_length=6.855u
X5097 VTOP A44_CDAC_CAP_BANK_ASSEMBLY_R8_M6_0/A44_CAP_CORE128_M6_R1_0/CAP_BOTTOM_123 cap_mim_2f0_m4m5_noshield c_width=6.855u c_length=6.855u
X5098 VTOP A44_CDAC_CAP_BANK_ASSEMBLY_R8_M6_0/A44_CAP_CORE128_M6_R1_0/CAP_BOTTOM_123 cap_mim_2f0_m4m5_noshield c_width=6.855u c_length=6.855u
X5099 VTOP A44_CDAC_CAP_BANK_ASSEMBLY_R8_M6_0/A44_CAP_CORE128_M6_R1_0/CAP_BOTTOM_123 cap_mim_2f0_m4m5_noshield c_width=6.855u c_length=6.855u
X5100 VTOP A44_CDAC_CAP_BANK_ASSEMBLY_R8_M6_0/A44_CAP_CORE128_M6_R1_0/CAP_BOTTOM_123 cap_mim_2f0_m4m5_noshield c_width=6.855u c_length=6.855u
X5101 VTOP A44_CDAC_CAP_BANK_ASSEMBLY_R8_M6_0/A44_CAP_CORE128_M6_R1_0/CAP_BOTTOM_123 cap_mim_2f0_m4m5_noshield c_width=6.855u c_length=6.855u
X5102 VTOP A44_CDAC_CAP_BANK_ASSEMBLY_R8_M6_0/A44_CAP_CORE128_M6_R1_0/CAP_BOTTOM_006 cap_mim_2f0_m4m5_noshield c_width=6.855u c_length=6.855u
X5103 VTOP A44_CDAC_CAP_BANK_ASSEMBLY_R8_M6_0/A44_CAP_CORE128_M6_R1_0/CAP_BOTTOM_006 cap_mim_2f0_m4m5_noshield c_width=6.855u c_length=6.855u
X5104 VTOP A44_CDAC_CAP_BANK_ASSEMBLY_R8_M6_0/A44_CAP_CORE128_M6_R1_0/CAP_BOTTOM_006 cap_mim_2f0_m4m5_noshield c_width=6.855u c_length=6.855u
X5105 VTOP A44_CDAC_CAP_BANK_ASSEMBLY_R8_M6_0/A44_CAP_CORE128_M6_R1_0/CAP_BOTTOM_006 cap_mim_2f0_m4m5_noshield c_width=6.855u c_length=6.855u
X5106 VTOP A44_CDAC_CAP_BANK_ASSEMBLY_R8_M6_0/A44_CAP_CORE128_M6_R1_0/CAP_BOTTOM_006 cap_mim_2f0_m4m5_noshield c_width=6.855u c_length=6.855u
X5107 VTOP A44_CDAC_CAP_BANK_ASSEMBLY_R8_M6_0/A44_CAP_CORE128_M6_R1_0/CAP_BOTTOM_006 cap_mim_2f0_m4m5_noshield c_width=6.855u c_length=6.855u
X5108 VTOP A44_CDAC_CAP_BANK_ASSEMBLY_R8_M6_0/A44_CAP_CORE128_M6_R1_0/CAP_BOTTOM_016 cap_mim_2f0_m4m5_noshield c_width=6.855u c_length=6.855u
X5109 VTOP A44_CDAC_CAP_BANK_ASSEMBLY_R8_M6_0/A44_CAP_CORE128_M6_R1_0/CAP_BOTTOM_016 cap_mim_2f0_m4m5_noshield c_width=6.855u c_length=6.855u
X5110 VTOP A44_CDAC_CAP_BANK_ASSEMBLY_R8_M6_0/A44_CAP_CORE128_M6_R1_0/CAP_BOTTOM_016 cap_mim_2f0_m4m5_noshield c_width=6.855u c_length=6.855u
X5111 VTOP A44_CDAC_CAP_BANK_ASSEMBLY_R8_M6_0/A44_CAP_CORE128_M6_R1_0/CAP_BOTTOM_016 cap_mim_2f0_m4m5_noshield c_width=6.855u c_length=6.855u
X5112 VTOP A44_CDAC_CAP_BANK_ASSEMBLY_R8_M6_0/A44_CAP_CORE128_M6_R1_0/CAP_BOTTOM_016 cap_mim_2f0_m4m5_noshield c_width=6.855u c_length=6.855u
X5113 VTOP A44_CDAC_CAP_BANK_ASSEMBLY_R8_M6_0/A44_CAP_CORE128_M6_R1_0/CAP_BOTTOM_016 cap_mim_2f0_m4m5_noshield c_width=6.855u c_length=6.855u
X5114 VTOP A44_CDAC_CAP_BANK_ASSEMBLY_R8_M6_0/A44_CAP_CORE128_M6_R1_0/CAP_BOTTOM_099 cap_mim_2f0_m4m5_noshield c_width=6.855u c_length=6.855u
X5115 VTOP A44_CDAC_CAP_BANK_ASSEMBLY_R8_M6_0/A44_CAP_CORE128_M6_R1_0/CAP_BOTTOM_099 cap_mim_2f0_m4m5_noshield c_width=6.855u c_length=6.855u
X5116 VTOP A44_CDAC_CAP_BANK_ASSEMBLY_R8_M6_0/A44_CAP_CORE128_M6_R1_0/CAP_BOTTOM_099 cap_mim_2f0_m4m5_noshield c_width=6.855u c_length=6.855u
X5117 VTOP A44_CDAC_CAP_BANK_ASSEMBLY_R8_M6_0/A44_CAP_CORE128_M6_R1_0/CAP_BOTTOM_099 cap_mim_2f0_m4m5_noshield c_width=6.855u c_length=6.855u
X5118 VTOP A44_CDAC_CAP_BANK_ASSEMBLY_R8_M6_0/A44_CAP_CORE128_M6_R1_0/CAP_BOTTOM_099 cap_mim_2f0_m4m5_noshield c_width=6.855u c_length=6.855u
X5119 VTOP A44_CDAC_CAP_BANK_ASSEMBLY_R8_M6_0/A44_CAP_CORE128_M6_R1_0/CAP_BOTTOM_099 cap_mim_2f0_m4m5_noshield c_width=6.855u c_length=6.855u
X5120 VTOP A44_CDAC_CAP_BANK_ASSEMBLY_R8_M6_0/A44_CAP_CORE128_M6_R1_0/CAP_BOTTOM_118 cap_mim_2f0_m4m5_noshield c_width=6.855u c_length=6.855u
X5121 VTOP A44_CDAC_CAP_BANK_ASSEMBLY_R8_M6_0/A44_CAP_CORE128_M6_R1_0/CAP_BOTTOM_118 cap_mim_2f0_m4m5_noshield c_width=6.855u c_length=6.855u
X5122 VTOP A44_CDAC_CAP_BANK_ASSEMBLY_R8_M6_0/A44_CAP_CORE128_M6_R1_0/CAP_BOTTOM_118 cap_mim_2f0_m4m5_noshield c_width=6.855u c_length=6.855u
X5123 VTOP A44_CDAC_CAP_BANK_ASSEMBLY_R8_M6_0/A44_CAP_CORE128_M6_R1_0/CAP_BOTTOM_118 cap_mim_2f0_m4m5_noshield c_width=6.855u c_length=6.855u
X5124 VTOP A44_CDAC_CAP_BANK_ASSEMBLY_R8_M6_0/A44_CAP_CORE128_M6_R1_0/CAP_BOTTOM_118 cap_mim_2f0_m4m5_noshield c_width=6.855u c_length=6.855u
X5125 VTOP A44_CDAC_CAP_BANK_ASSEMBLY_R8_M6_0/A44_CAP_CORE128_M6_R1_0/CAP_BOTTOM_118 cap_mim_2f0_m4m5_noshield c_width=6.855u c_length=6.855u
X5126 VTOP A44_CDAC_CAP_BANK_ASSEMBLY_R8_M6_0/A44_CAP_CORE128_M6_R1_0/CAP_BOTTOM_105 cap_mim_2f0_m4m5_noshield c_width=6.855u c_length=6.855u
X5127 VTOP A44_CDAC_CAP_BANK_ASSEMBLY_R8_M6_0/A44_CAP_CORE128_M6_R1_0/CAP_BOTTOM_105 cap_mim_2f0_m4m5_noshield c_width=6.855u c_length=6.855u
X5128 VTOP A44_CDAC_CAP_BANK_ASSEMBLY_R8_M6_0/A44_CAP_CORE128_M6_R1_0/CAP_BOTTOM_105 cap_mim_2f0_m4m5_noshield c_width=6.855u c_length=6.855u
X5129 VTOP A44_CDAC_CAP_BANK_ASSEMBLY_R8_M6_0/A44_CAP_CORE128_M6_R1_0/CAP_BOTTOM_105 cap_mim_2f0_m4m5_noshield c_width=6.855u c_length=6.855u
X5130 VTOP A44_CDAC_CAP_BANK_ASSEMBLY_R8_M6_0/A44_CAP_CORE128_M6_R1_0/CAP_BOTTOM_105 cap_mim_2f0_m4m5_noshield c_width=6.855u c_length=6.855u
X5131 VTOP A44_CDAC_CAP_BANK_ASSEMBLY_R8_M6_0/A44_CAP_CORE128_M6_R1_0/CAP_BOTTOM_105 cap_mim_2f0_m4m5_noshield c_width=6.855u c_length=6.855u
X5132 VTOP A44_CDAC_CAP_BANK_ASSEMBLY_R8_M6_0/A44_CAP_CORE128_M6_R1_0/CAP_BOTTOM_080 cap_mim_2f0_m4m5_noshield c_width=6.855u c_length=6.855u
X5133 VTOP A44_CDAC_CAP_BANK_ASSEMBLY_R8_M6_0/A44_CAP_CORE128_M6_R1_0/CAP_BOTTOM_080 cap_mim_2f0_m4m5_noshield c_width=6.855u c_length=6.855u
X5134 VTOP A44_CDAC_CAP_BANK_ASSEMBLY_R8_M6_0/A44_CAP_CORE128_M6_R1_0/CAP_BOTTOM_080 cap_mim_2f0_m4m5_noshield c_width=6.855u c_length=6.855u
X5135 VTOP A44_CDAC_CAP_BANK_ASSEMBLY_R8_M6_0/A44_CAP_CORE128_M6_R1_0/CAP_BOTTOM_080 cap_mim_2f0_m4m5_noshield c_width=6.855u c_length=6.855u
X5136 VTOP A44_CDAC_CAP_BANK_ASSEMBLY_R8_M6_0/A44_CAP_CORE128_M6_R1_0/CAP_BOTTOM_080 cap_mim_2f0_m4m5_noshield c_width=6.855u c_length=6.855u
X5137 VTOP A44_CDAC_CAP_BANK_ASSEMBLY_R8_M6_0/A44_CAP_CORE128_M6_R1_0/CAP_BOTTOM_080 cap_mim_2f0_m4m5_noshield c_width=6.855u c_length=6.855u
X5138 VTOP A44_CDAC_CAP_BANK_ASSEMBLY_R8_M6_0/A44_CAP_CORE128_M6_R1_0/CAP_BOTTOM_092 cap_mim_2f0_m4m5_noshield c_width=6.855u c_length=6.855u
X5139 VTOP A44_CDAC_CAP_BANK_ASSEMBLY_R8_M6_0/A44_CAP_CORE128_M6_R1_0/CAP_BOTTOM_092 cap_mim_2f0_m4m5_noshield c_width=6.855u c_length=6.855u
X5140 VTOP A44_CDAC_CAP_BANK_ASSEMBLY_R8_M6_0/A44_CAP_CORE128_M6_R1_0/CAP_BOTTOM_092 cap_mim_2f0_m4m5_noshield c_width=6.855u c_length=6.855u
X5141 VTOP A44_CDAC_CAP_BANK_ASSEMBLY_R8_M6_0/A44_CAP_CORE128_M6_R1_0/CAP_BOTTOM_092 cap_mim_2f0_m4m5_noshield c_width=6.855u c_length=6.855u
X5142 VTOP A44_CDAC_CAP_BANK_ASSEMBLY_R8_M6_0/A44_CAP_CORE128_M6_R1_0/CAP_BOTTOM_092 cap_mim_2f0_m4m5_noshield c_width=6.855u c_length=6.855u
X5143 VTOP A44_CDAC_CAP_BANK_ASSEMBLY_R8_M6_0/A44_CAP_CORE128_M6_R1_0/CAP_BOTTOM_092 cap_mim_2f0_m4m5_noshield c_width=6.855u c_length=6.855u
X5144 VTOP A44_CDAC_CAP_BANK_ASSEMBLY_R8_M6_0/A44_CAP_CORE128_M6_R1_0/CAP_BOTTOM_051 cap_mim_2f0_m4m5_noshield c_width=6.855u c_length=6.855u
X5145 VTOP A44_CDAC_CAP_BANK_ASSEMBLY_R8_M6_0/A44_CAP_CORE128_M6_R1_0/CAP_BOTTOM_051 cap_mim_2f0_m4m5_noshield c_width=6.855u c_length=6.855u
X5146 VTOP A44_CDAC_CAP_BANK_ASSEMBLY_R8_M6_0/A44_CAP_CORE128_M6_R1_0/CAP_BOTTOM_051 cap_mim_2f0_m4m5_noshield c_width=6.855u c_length=6.855u
X5147 VTOP A44_CDAC_CAP_BANK_ASSEMBLY_R8_M6_0/A44_CAP_CORE128_M6_R1_0/CAP_BOTTOM_051 cap_mim_2f0_m4m5_noshield c_width=6.855u c_length=6.855u
X5148 VTOP A44_CDAC_CAP_BANK_ASSEMBLY_R8_M6_0/A44_CAP_CORE128_M6_R1_0/CAP_BOTTOM_051 cap_mim_2f0_m4m5_noshield c_width=6.855u c_length=6.855u
X5149 VTOP A44_CDAC_CAP_BANK_ASSEMBLY_R8_M6_0/A44_CAP_CORE128_M6_R1_0/CAP_BOTTOM_051 cap_mim_2f0_m4m5_noshield c_width=6.855u c_length=6.855u
X5150 VTOP A44_CDAC_CAP_BANK_ASSEMBLY_R8_M6_0/A44_CAP_CORE128_M6_R1_0/CAP_BOTTOM_061 cap_mim_2f0_m4m5_noshield c_width=6.855u c_length=6.855u
X5151 VTOP A44_CDAC_CAP_BANK_ASSEMBLY_R8_M6_0/A44_CAP_CORE128_M6_R1_0/CAP_BOTTOM_061 cap_mim_2f0_m4m5_noshield c_width=6.855u c_length=6.855u
X5152 VTOP A44_CDAC_CAP_BANK_ASSEMBLY_R8_M6_0/A44_CAP_CORE128_M6_R1_0/CAP_BOTTOM_061 cap_mim_2f0_m4m5_noshield c_width=6.855u c_length=6.855u
X5153 VTOP A44_CDAC_CAP_BANK_ASSEMBLY_R8_M6_0/A44_CAP_CORE128_M6_R1_0/CAP_BOTTOM_061 cap_mim_2f0_m4m5_noshield c_width=6.855u c_length=6.855u
X5154 VTOP A44_CDAC_CAP_BANK_ASSEMBLY_R8_M6_0/A44_CAP_CORE128_M6_R1_0/CAP_BOTTOM_061 cap_mim_2f0_m4m5_noshield c_width=6.855u c_length=6.855u
X5155 VTOP A44_CDAC_CAP_BANK_ASSEMBLY_R8_M6_0/A44_CAP_CORE128_M6_R1_0/CAP_BOTTOM_061 cap_mim_2f0_m4m5_noshield c_width=6.855u c_length=6.855u
X5156 VTOP A44_CDAC_CAP_BANK_ASSEMBLY_R8_M6_0/A44_CAP_CORE128_M6_R1_0/CAP_BOTTOM_024 cap_mim_2f0_m4m5_noshield c_width=6.855u c_length=6.855u
X5157 VTOP A44_CDAC_CAP_BANK_ASSEMBLY_R8_M6_0/A44_CAP_CORE128_M6_R1_0/CAP_BOTTOM_024 cap_mim_2f0_m4m5_noshield c_width=6.855u c_length=6.855u
X5158 VTOP A44_CDAC_CAP_BANK_ASSEMBLY_R8_M6_0/A44_CAP_CORE128_M6_R1_0/CAP_BOTTOM_024 cap_mim_2f0_m4m5_noshield c_width=6.855u c_length=6.855u
X5159 VTOP A44_CDAC_CAP_BANK_ASSEMBLY_R8_M6_0/A44_CAP_CORE128_M6_R1_0/CAP_BOTTOM_024 cap_mim_2f0_m4m5_noshield c_width=6.855u c_length=6.855u
X5160 VTOP A44_CDAC_CAP_BANK_ASSEMBLY_R8_M6_0/A44_CAP_CORE128_M6_R1_0/CAP_BOTTOM_024 cap_mim_2f0_m4m5_noshield c_width=6.855u c_length=6.855u
X5161 VTOP A44_CDAC_CAP_BANK_ASSEMBLY_R8_M6_0/A44_CAP_CORE128_M6_R1_0/CAP_BOTTOM_024 cap_mim_2f0_m4m5_noshield c_width=6.855u c_length=6.855u
X5162 VTOP A44_CDAC_CAP_BANK_ASSEMBLY_R8_M6_0/A44_CAP_CORE128_M6_R1_0/CAP_BOTTOM_043 cap_mim_2f0_m4m5_noshield c_width=6.855u c_length=6.855u
X5163 VTOP A44_CDAC_CAP_BANK_ASSEMBLY_R8_M6_0/A44_CAP_CORE128_M6_R1_0/CAP_BOTTOM_043 cap_mim_2f0_m4m5_noshield c_width=6.855u c_length=6.855u
X5164 VTOP A44_CDAC_CAP_BANK_ASSEMBLY_R8_M6_0/A44_CAP_CORE128_M6_R1_0/CAP_BOTTOM_043 cap_mim_2f0_m4m5_noshield c_width=6.855u c_length=6.855u
X5165 VTOP A44_CDAC_CAP_BANK_ASSEMBLY_R8_M6_0/A44_CAP_CORE128_M6_R1_0/CAP_BOTTOM_043 cap_mim_2f0_m4m5_noshield c_width=6.855u c_length=6.855u
X5166 VTOP A44_CDAC_CAP_BANK_ASSEMBLY_R8_M6_0/A44_CAP_CORE128_M6_R1_0/CAP_BOTTOM_043 cap_mim_2f0_m4m5_noshield c_width=6.855u c_length=6.855u
X5167 VTOP A44_CDAC_CAP_BANK_ASSEMBLY_R8_M6_0/A44_CAP_CORE128_M6_R1_0/CAP_BOTTOM_043 cap_mim_2f0_m4m5_noshield c_width=6.855u c_length=6.855u
X5168 VTOP A44_CDAC_CAP_BANK_ASSEMBLY_R8_M6_0/A44_CAP_CORE128_M6_R1_0/CAP_BOTTOM_122 cap_mim_2f0_m4m5_noshield c_width=6.855u c_length=6.855u
X5169 VTOP A44_CDAC_CAP_BANK_ASSEMBLY_R8_M6_0/A44_CAP_CORE128_M6_R1_0/CAP_BOTTOM_122 cap_mim_2f0_m4m5_noshield c_width=6.855u c_length=6.855u
X5170 VTOP A44_CDAC_CAP_BANK_ASSEMBLY_R8_M6_0/A44_CAP_CORE128_M6_R1_0/CAP_BOTTOM_122 cap_mim_2f0_m4m5_noshield c_width=6.855u c_length=6.855u
X5171 VTOP A44_CDAC_CAP_BANK_ASSEMBLY_R8_M6_0/A44_CAP_CORE128_M6_R1_0/CAP_BOTTOM_122 cap_mim_2f0_m4m5_noshield c_width=6.855u c_length=6.855u
X5172 VTOP A44_CDAC_CAP_BANK_ASSEMBLY_R8_M6_0/A44_CAP_CORE128_M6_R1_0/CAP_BOTTOM_122 cap_mim_2f0_m4m5_noshield c_width=6.855u c_length=6.855u
X5173 VTOP A44_CDAC_CAP_BANK_ASSEMBLY_R8_M6_0/A44_CAP_CORE128_M6_R1_0/CAP_BOTTOM_122 cap_mim_2f0_m4m5_noshield c_width=6.855u c_length=6.855u
X5174 VTOP A44_CDAC_CAP_BANK_ASSEMBLY_R8_M6_0/A44_CAP_CORE128_M6_R1_0/CAP_BOTTOM_005 cap_mim_2f0_m4m5_noshield c_width=6.855u c_length=6.855u
X5175 VTOP A44_CDAC_CAP_BANK_ASSEMBLY_R8_M6_0/A44_CAP_CORE128_M6_R1_0/CAP_BOTTOM_005 cap_mim_2f0_m4m5_noshield c_width=6.855u c_length=6.855u
X5176 VTOP A44_CDAC_CAP_BANK_ASSEMBLY_R8_M6_0/A44_CAP_CORE128_M6_R1_0/CAP_BOTTOM_005 cap_mim_2f0_m4m5_noshield c_width=6.855u c_length=6.855u
X5177 VTOP A44_CDAC_CAP_BANK_ASSEMBLY_R8_M6_0/A44_CAP_CORE128_M6_R1_0/CAP_BOTTOM_005 cap_mim_2f0_m4m5_noshield c_width=6.855u c_length=6.855u
X5178 VTOP A44_CDAC_CAP_BANK_ASSEMBLY_R8_M6_0/A44_CAP_CORE128_M6_R1_0/CAP_BOTTOM_005 cap_mim_2f0_m4m5_noshield c_width=6.855u c_length=6.855u
X5179 VTOP A44_CDAC_CAP_BANK_ASSEMBLY_R8_M6_0/A44_CAP_CORE128_M6_R1_0/CAP_BOTTOM_005 cap_mim_2f0_m4m5_noshield c_width=6.855u c_length=6.855u
X5180 VTOP A44_CDAC_CAP_BANK_ASSEMBLY_R8_M6_0/A44_CAP_CORE128_M6_R1_0/CAP_BOTTOM_098 cap_mim_2f0_m4m5_noshield c_width=6.855u c_length=6.855u
X5181 VTOP A44_CDAC_CAP_BANK_ASSEMBLY_R8_M6_0/A44_CAP_CORE128_M6_R1_0/CAP_BOTTOM_098 cap_mim_2f0_m4m5_noshield c_width=6.855u c_length=6.855u
X5182 VTOP A44_CDAC_CAP_BANK_ASSEMBLY_R8_M6_0/A44_CAP_CORE128_M6_R1_0/CAP_BOTTOM_098 cap_mim_2f0_m4m5_noshield c_width=6.855u c_length=6.855u
X5183 VTOP A44_CDAC_CAP_BANK_ASSEMBLY_R8_M6_0/A44_CAP_CORE128_M6_R1_0/CAP_BOTTOM_098 cap_mim_2f0_m4m5_noshield c_width=6.855u c_length=6.855u
X5184 VTOP A44_CDAC_CAP_BANK_ASSEMBLY_R8_M6_0/A44_CAP_CORE128_M6_R1_0/CAP_BOTTOM_098 cap_mim_2f0_m4m5_noshield c_width=6.855u c_length=6.855u
X5185 VTOP A44_CDAC_CAP_BANK_ASSEMBLY_R8_M6_0/A44_CAP_CORE128_M6_R1_0/CAP_BOTTOM_098 cap_mim_2f0_m4m5_noshield c_width=6.855u c_length=6.855u
X5186 VTOP A44_CDAC_CAP_BANK_ASSEMBLY_R8_M6_0/A44_CAP_CORE128_M6_R1_0/CAP_BOTTOM_117 cap_mim_2f0_m4m5_noshield c_width=6.855u c_length=6.855u
X5187 VTOP A44_CDAC_CAP_BANK_ASSEMBLY_R8_M6_0/A44_CAP_CORE128_M6_R1_0/CAP_BOTTOM_117 cap_mim_2f0_m4m5_noshield c_width=6.855u c_length=6.855u
X5188 VTOP A44_CDAC_CAP_BANK_ASSEMBLY_R8_M6_0/A44_CAP_CORE128_M6_R1_0/CAP_BOTTOM_117 cap_mim_2f0_m4m5_noshield c_width=6.855u c_length=6.855u
X5189 VTOP A44_CDAC_CAP_BANK_ASSEMBLY_R8_M6_0/A44_CAP_CORE128_M6_R1_0/CAP_BOTTOM_117 cap_mim_2f0_m4m5_noshield c_width=6.855u c_length=6.855u
X5190 VTOP A44_CDAC_CAP_BANK_ASSEMBLY_R8_M6_0/A44_CAP_CORE128_M6_R1_0/CAP_BOTTOM_117 cap_mim_2f0_m4m5_noshield c_width=6.855u c_length=6.855u
X5191 VTOP A44_CDAC_CAP_BANK_ASSEMBLY_R8_M6_0/A44_CAP_CORE128_M6_R1_0/CAP_BOTTOM_117 cap_mim_2f0_m4m5_noshield c_width=6.855u c_length=6.855u
X5192 VTOP A44_CDAC_CAP_BANK_ASSEMBLY_R8_M6_0/A44_CAP_CORE128_M6_R1_0/CAP_BOTTOM_104 cap_mim_2f0_m4m5_noshield c_width=6.855u c_length=6.855u
X5193 VTOP A44_CDAC_CAP_BANK_ASSEMBLY_R8_M6_0/A44_CAP_CORE128_M6_R1_0/CAP_BOTTOM_104 cap_mim_2f0_m4m5_noshield c_width=6.855u c_length=6.855u
X5194 VTOP A44_CDAC_CAP_BANK_ASSEMBLY_R8_M6_0/A44_CAP_CORE128_M6_R1_0/CAP_BOTTOM_104 cap_mim_2f0_m4m5_noshield c_width=6.855u c_length=6.855u
X5195 VTOP A44_CDAC_CAP_BANK_ASSEMBLY_R8_M6_0/A44_CAP_CORE128_M6_R1_0/CAP_BOTTOM_104 cap_mim_2f0_m4m5_noshield c_width=6.855u c_length=6.855u
X5196 VTOP A44_CDAC_CAP_BANK_ASSEMBLY_R8_M6_0/A44_CAP_CORE128_M6_R1_0/CAP_BOTTOM_104 cap_mim_2f0_m4m5_noshield c_width=6.855u c_length=6.855u
X5197 VTOP A44_CDAC_CAP_BANK_ASSEMBLY_R8_M6_0/A44_CAP_CORE128_M6_R1_0/CAP_BOTTOM_104 cap_mim_2f0_m4m5_noshield c_width=6.855u c_length=6.855u
X5198 VTOP A44_CDAC_CAP_BANK_ASSEMBLY_R8_M6_0/A44_CAP_CORE128_M6_R1_0/CAP_BOTTOM_079 cap_mim_2f0_m4m5_noshield c_width=6.855u c_length=6.855u
X5199 VTOP A44_CDAC_CAP_BANK_ASSEMBLY_R8_M6_0/A44_CAP_CORE128_M6_R1_0/CAP_BOTTOM_079 cap_mim_2f0_m4m5_noshield c_width=6.855u c_length=6.855u
X5200 VTOP A44_CDAC_CAP_BANK_ASSEMBLY_R8_M6_0/A44_CAP_CORE128_M6_R1_0/CAP_BOTTOM_079 cap_mim_2f0_m4m5_noshield c_width=6.855u c_length=6.855u
X5201 VTOP A44_CDAC_CAP_BANK_ASSEMBLY_R8_M6_0/A44_CAP_CORE128_M6_R1_0/CAP_BOTTOM_079 cap_mim_2f0_m4m5_noshield c_width=6.855u c_length=6.855u
X5202 VTOP A44_CDAC_CAP_BANK_ASSEMBLY_R8_M6_0/A44_CAP_CORE128_M6_R1_0/CAP_BOTTOM_079 cap_mim_2f0_m4m5_noshield c_width=6.855u c_length=6.855u
X5203 VTOP A44_CDAC_CAP_BANK_ASSEMBLY_R8_M6_0/A44_CAP_CORE128_M6_R1_0/CAP_BOTTOM_079 cap_mim_2f0_m4m5_noshield c_width=6.855u c_length=6.855u
X5204 VTOP A44_CDAC_CAP_BANK_ASSEMBLY_R8_M6_0/A44_CAP_CORE128_M6_R1_0/CAP_BOTTOM_091 cap_mim_2f0_m4m5_noshield c_width=6.855u c_length=6.855u
X5205 VTOP A44_CDAC_CAP_BANK_ASSEMBLY_R8_M6_0/A44_CAP_CORE128_M6_R1_0/CAP_BOTTOM_091 cap_mim_2f0_m4m5_noshield c_width=6.855u c_length=6.855u
X5206 VTOP A44_CDAC_CAP_BANK_ASSEMBLY_R8_M6_0/A44_CAP_CORE128_M6_R1_0/CAP_BOTTOM_091 cap_mim_2f0_m4m5_noshield c_width=6.855u c_length=6.855u
X5207 VTOP A44_CDAC_CAP_BANK_ASSEMBLY_R8_M6_0/A44_CAP_CORE128_M6_R1_0/CAP_BOTTOM_091 cap_mim_2f0_m4m5_noshield c_width=6.855u c_length=6.855u
X5208 VTOP A44_CDAC_CAP_BANK_ASSEMBLY_R8_M6_0/A44_CAP_CORE128_M6_R1_0/CAP_BOTTOM_091 cap_mim_2f0_m4m5_noshield c_width=6.855u c_length=6.855u
X5209 VTOP A44_CDAC_CAP_BANK_ASSEMBLY_R8_M6_0/A44_CAP_CORE128_M6_R1_0/CAP_BOTTOM_091 cap_mim_2f0_m4m5_noshield c_width=6.855u c_length=6.855u
X5210 VTOP A44_CDAC_CAP_BANK_ASSEMBLY_R8_M6_0/A44_CAP_CORE128_M6_R1_0/CAP_BOTTOM_050 cap_mim_2f0_m4m5_noshield c_width=6.855u c_length=6.855u
X5211 VTOP A44_CDAC_CAP_BANK_ASSEMBLY_R8_M6_0/A44_CAP_CORE128_M6_R1_0/CAP_BOTTOM_050 cap_mim_2f0_m4m5_noshield c_width=6.855u c_length=6.855u
X5212 VTOP A44_CDAC_CAP_BANK_ASSEMBLY_R8_M6_0/A44_CAP_CORE128_M6_R1_0/CAP_BOTTOM_050 cap_mim_2f0_m4m5_noshield c_width=6.855u c_length=6.855u
X5213 VTOP A44_CDAC_CAP_BANK_ASSEMBLY_R8_M6_0/A44_CAP_CORE128_M6_R1_0/CAP_BOTTOM_050 cap_mim_2f0_m4m5_noshield c_width=6.855u c_length=6.855u
X5214 VTOP A44_CDAC_CAP_BANK_ASSEMBLY_R8_M6_0/A44_CAP_CORE128_M6_R1_0/CAP_BOTTOM_050 cap_mim_2f0_m4m5_noshield c_width=6.855u c_length=6.855u
X5215 VTOP A44_CDAC_CAP_BANK_ASSEMBLY_R8_M6_0/A44_CAP_CORE128_M6_R1_0/CAP_BOTTOM_050 cap_mim_2f0_m4m5_noshield c_width=6.855u c_length=6.855u
X5216 VTOP A44_CDAC_CAP_BANK_ASSEMBLY_R8_M6_0/A44_CAP_CORE128_M6_R1_0/CAP_BOTTOM_060 cap_mim_2f0_m4m5_noshield c_width=6.855u c_length=6.855u
X5217 VTOP A44_CDAC_CAP_BANK_ASSEMBLY_R8_M6_0/A44_CAP_CORE128_M6_R1_0/CAP_BOTTOM_060 cap_mim_2f0_m4m5_noshield c_width=6.855u c_length=6.855u
X5218 VTOP A44_CDAC_CAP_BANK_ASSEMBLY_R8_M6_0/A44_CAP_CORE128_M6_R1_0/CAP_BOTTOM_060 cap_mim_2f0_m4m5_noshield c_width=6.855u c_length=6.855u
X5219 VTOP A44_CDAC_CAP_BANK_ASSEMBLY_R8_M6_0/A44_CAP_CORE128_M6_R1_0/CAP_BOTTOM_060 cap_mim_2f0_m4m5_noshield c_width=6.855u c_length=6.855u
X5220 VTOP A44_CDAC_CAP_BANK_ASSEMBLY_R8_M6_0/A44_CAP_CORE128_M6_R1_0/CAP_BOTTOM_060 cap_mim_2f0_m4m5_noshield c_width=6.855u c_length=6.855u
X5221 VTOP A44_CDAC_CAP_BANK_ASSEMBLY_R8_M6_0/A44_CAP_CORE128_M6_R1_0/CAP_BOTTOM_060 cap_mim_2f0_m4m5_noshield c_width=6.855u c_length=6.855u
X5222 VTOP A44_CDAC_CAP_BANK_ASSEMBLY_R8_M6_0/A44_CAP_CORE128_M6_R1_0/CAP_BOTTOM_039 cap_mim_2f0_m4m5_noshield c_width=6.855u c_length=6.855u
X5223 VTOP A44_CDAC_CAP_BANK_ASSEMBLY_R8_M6_0/A44_CAP_CORE128_M6_R1_0/CAP_BOTTOM_039 cap_mim_2f0_m4m5_noshield c_width=6.855u c_length=6.855u
X5224 VTOP A44_CDAC_CAP_BANK_ASSEMBLY_R8_M6_0/A44_CAP_CORE128_M6_R1_0/CAP_BOTTOM_039 cap_mim_2f0_m4m5_noshield c_width=6.855u c_length=6.855u
X5225 VTOP A44_CDAC_CAP_BANK_ASSEMBLY_R8_M6_0/A44_CAP_CORE128_M6_R1_0/CAP_BOTTOM_039 cap_mim_2f0_m4m5_noshield c_width=6.855u c_length=6.855u
X5226 VTOP A44_CDAC_CAP_BANK_ASSEMBLY_R8_M6_0/A44_CAP_CORE128_M6_R1_0/CAP_BOTTOM_039 cap_mim_2f0_m4m5_noshield c_width=6.855u c_length=6.855u
X5227 VTOP A44_CDAC_CAP_BANK_ASSEMBLY_R8_M6_0/A44_CAP_CORE128_M6_R1_0/CAP_BOTTOM_039 cap_mim_2f0_m4m5_noshield c_width=6.855u c_length=6.855u
X5228 VTOP A44_CDAC_CAP_BANK_ASSEMBLY_R8_M6_0/A44_CAP_CORE128_M6_R1_0/CAP_BOTTOM_042 cap_mim_2f0_m4m5_noshield c_width=6.855u c_length=6.855u
X5229 VTOP A44_CDAC_CAP_BANK_ASSEMBLY_R8_M6_0/A44_CAP_CORE128_M6_R1_0/CAP_BOTTOM_042 cap_mim_2f0_m4m5_noshield c_width=6.855u c_length=6.855u
X5230 VTOP A44_CDAC_CAP_BANK_ASSEMBLY_R8_M6_0/A44_CAP_CORE128_M6_R1_0/CAP_BOTTOM_042 cap_mim_2f0_m4m5_noshield c_width=6.855u c_length=6.855u
X5231 VTOP A44_CDAC_CAP_BANK_ASSEMBLY_R8_M6_0/A44_CAP_CORE128_M6_R1_0/CAP_BOTTOM_042 cap_mim_2f0_m4m5_noshield c_width=6.855u c_length=6.855u
X5232 VTOP A44_CDAC_CAP_BANK_ASSEMBLY_R8_M6_0/A44_CAP_CORE128_M6_R1_0/CAP_BOTTOM_042 cap_mim_2f0_m4m5_noshield c_width=6.855u c_length=6.855u
X5233 VTOP A44_CDAC_CAP_BANK_ASSEMBLY_R8_M6_0/A44_CAP_CORE128_M6_R1_0/CAP_BOTTOM_042 cap_mim_2f0_m4m5_noshield c_width=6.855u c_length=6.855u
X5234 VTOP A44_CDAC_CAP_BANK_ASSEMBLY_R8_M6_0/A44_CAP_CORE128_M6_R1_0/CAP_BOTTOM_004 cap_mim_2f0_m4m5_noshield c_width=6.855u c_length=6.855u
X5235 VTOP A44_CDAC_CAP_BANK_ASSEMBLY_R8_M6_0/A44_CAP_CORE128_M6_R1_0/CAP_BOTTOM_004 cap_mim_2f0_m4m5_noshield c_width=6.855u c_length=6.855u
X5236 VTOP A44_CDAC_CAP_BANK_ASSEMBLY_R8_M6_0/A44_CAP_CORE128_M6_R1_0/CAP_BOTTOM_004 cap_mim_2f0_m4m5_noshield c_width=6.855u c_length=6.855u
X5237 VTOP A44_CDAC_CAP_BANK_ASSEMBLY_R8_M6_0/A44_CAP_CORE128_M6_R1_0/CAP_BOTTOM_004 cap_mim_2f0_m4m5_noshield c_width=6.855u c_length=6.855u
X5238 VTOP A44_CDAC_CAP_BANK_ASSEMBLY_R8_M6_0/A44_CAP_CORE128_M6_R1_0/CAP_BOTTOM_004 cap_mim_2f0_m4m5_noshield c_width=6.855u c_length=6.855u
X5239 VTOP A44_CDAC_CAP_BANK_ASSEMBLY_R8_M6_0/A44_CAP_CORE128_M6_R1_0/CAP_BOTTOM_004 cap_mim_2f0_m4m5_noshield c_width=6.855u c_length=6.855u
X5240 VTOP A44_CDAC_CAP_BANK_ASSEMBLY_R8_M6_0/A44_CAP_CORE128_M6_R1_0/CAP_BOTTOM_097 cap_mim_2f0_m4m5_noshield c_width=6.855u c_length=6.855u
X5241 VTOP A44_CDAC_CAP_BANK_ASSEMBLY_R8_M6_0/A44_CAP_CORE128_M6_R1_0/CAP_BOTTOM_097 cap_mim_2f0_m4m5_noshield c_width=6.855u c_length=6.855u
X5242 VTOP A44_CDAC_CAP_BANK_ASSEMBLY_R8_M6_0/A44_CAP_CORE128_M6_R1_0/CAP_BOTTOM_097 cap_mim_2f0_m4m5_noshield c_width=6.855u c_length=6.855u
X5243 VTOP A44_CDAC_CAP_BANK_ASSEMBLY_R8_M6_0/A44_CAP_CORE128_M6_R1_0/CAP_BOTTOM_097 cap_mim_2f0_m4m5_noshield c_width=6.855u c_length=6.855u
X5244 VTOP A44_CDAC_CAP_BANK_ASSEMBLY_R8_M6_0/A44_CAP_CORE128_M6_R1_0/CAP_BOTTOM_097 cap_mim_2f0_m4m5_noshield c_width=6.855u c_length=6.855u
X5245 VTOP A44_CDAC_CAP_BANK_ASSEMBLY_R8_M6_0/A44_CAP_CORE128_M6_R1_0/CAP_BOTTOM_097 cap_mim_2f0_m4m5_noshield c_width=6.855u c_length=6.855u
X5246 VTOP A44_CDAC_CAP_BANK_ASSEMBLY_R8_M6_0/A44_CAP_CORE128_M6_R1_0/CAP_BOTTOM_116 cap_mim_2f0_m4m5_noshield c_width=6.855u c_length=6.855u
X5247 VTOP A44_CDAC_CAP_BANK_ASSEMBLY_R8_M6_0/A44_CAP_CORE128_M6_R1_0/CAP_BOTTOM_116 cap_mim_2f0_m4m5_noshield c_width=6.855u c_length=6.855u
X5248 VTOP A44_CDAC_CAP_BANK_ASSEMBLY_R8_M6_0/A44_CAP_CORE128_M6_R1_0/CAP_BOTTOM_116 cap_mim_2f0_m4m5_noshield c_width=6.855u c_length=6.855u
X5249 VTOP A44_CDAC_CAP_BANK_ASSEMBLY_R8_M6_0/A44_CAP_CORE128_M6_R1_0/CAP_BOTTOM_116 cap_mim_2f0_m4m5_noshield c_width=6.855u c_length=6.855u
X5250 VTOP A44_CDAC_CAP_BANK_ASSEMBLY_R8_M6_0/A44_CAP_CORE128_M6_R1_0/CAP_BOTTOM_116 cap_mim_2f0_m4m5_noshield c_width=6.855u c_length=6.855u
X5251 VTOP A44_CDAC_CAP_BANK_ASSEMBLY_R8_M6_0/A44_CAP_CORE128_M6_R1_0/CAP_BOTTOM_116 cap_mim_2f0_m4m5_noshield c_width=6.855u c_length=6.855u
X5252 VTOP A44_CDAC_CAP_BANK_ASSEMBLY_R8_M6_0/A44_CAP_CORE128_M6_R1_0/CAP_BOTTOM_103 cap_mim_2f0_m4m5_noshield c_width=6.855u c_length=6.855u
X5253 VTOP A44_CDAC_CAP_BANK_ASSEMBLY_R8_M6_0/A44_CAP_CORE128_M6_R1_0/CAP_BOTTOM_103 cap_mim_2f0_m4m5_noshield c_width=6.855u c_length=6.855u
X5254 VTOP A44_CDAC_CAP_BANK_ASSEMBLY_R8_M6_0/A44_CAP_CORE128_M6_R1_0/CAP_BOTTOM_103 cap_mim_2f0_m4m5_noshield c_width=6.855u c_length=6.855u
X5255 VTOP A44_CDAC_CAP_BANK_ASSEMBLY_R8_M6_0/A44_CAP_CORE128_M6_R1_0/CAP_BOTTOM_103 cap_mim_2f0_m4m5_noshield c_width=6.855u c_length=6.855u
X5256 VTOP A44_CDAC_CAP_BANK_ASSEMBLY_R8_M6_0/A44_CAP_CORE128_M6_R1_0/CAP_BOTTOM_103 cap_mim_2f0_m4m5_noshield c_width=6.855u c_length=6.855u
X5257 VTOP A44_CDAC_CAP_BANK_ASSEMBLY_R8_M6_0/A44_CAP_CORE128_M6_R1_0/CAP_BOTTOM_103 cap_mim_2f0_m4m5_noshield c_width=6.855u c_length=6.855u
X5258 VTOP A44_CDAC_CAP_BANK_ASSEMBLY_R8_M6_0/A44_CAP_CORE128_M6_R1_0/CAP_BOTTOM_121 cap_mim_2f0_m4m5_noshield c_width=6.855u c_length=6.855u
X5259 VTOP A44_CDAC_CAP_BANK_ASSEMBLY_R8_M6_0/A44_CAP_CORE128_M6_R1_0/CAP_BOTTOM_121 cap_mim_2f0_m4m5_noshield c_width=6.855u c_length=6.855u
X5260 VTOP A44_CDAC_CAP_BANK_ASSEMBLY_R8_M6_0/A44_CAP_CORE128_M6_R1_0/CAP_BOTTOM_121 cap_mim_2f0_m4m5_noshield c_width=6.855u c_length=6.855u
X5261 VTOP A44_CDAC_CAP_BANK_ASSEMBLY_R8_M6_0/A44_CAP_CORE128_M6_R1_0/CAP_BOTTOM_121 cap_mim_2f0_m4m5_noshield c_width=6.855u c_length=6.855u
X5262 VTOP A44_CDAC_CAP_BANK_ASSEMBLY_R8_M6_0/A44_CAP_CORE128_M6_R1_0/CAP_BOTTOM_121 cap_mim_2f0_m4m5_noshield c_width=6.855u c_length=6.855u
X5263 VTOP A44_CDAC_CAP_BANK_ASSEMBLY_R8_M6_0/A44_CAP_CORE128_M6_R1_0/CAP_BOTTOM_121 cap_mim_2f0_m4m5_noshield c_width=6.855u c_length=6.855u
X5264 VTOP A44_CDAC_CAP_BANK_ASSEMBLY_R8_M6_0/A44_CAP_CORE128_M6_R1_0/CAP_BOTTOM_090 cap_mim_2f0_m4m5_noshield c_width=6.855u c_length=6.855u
X5265 VTOP A44_CDAC_CAP_BANK_ASSEMBLY_R8_M6_0/A44_CAP_CORE128_M6_R1_0/CAP_BOTTOM_090 cap_mim_2f0_m4m5_noshield c_width=6.855u c_length=6.855u
X5266 VTOP A44_CDAC_CAP_BANK_ASSEMBLY_R8_M6_0/A44_CAP_CORE128_M6_R1_0/CAP_BOTTOM_090 cap_mim_2f0_m4m5_noshield c_width=6.855u c_length=6.855u
X5267 VTOP A44_CDAC_CAP_BANK_ASSEMBLY_R8_M6_0/A44_CAP_CORE128_M6_R1_0/CAP_BOTTOM_090 cap_mim_2f0_m4m5_noshield c_width=6.855u c_length=6.855u
X5268 VTOP A44_CDAC_CAP_BANK_ASSEMBLY_R8_M6_0/A44_CAP_CORE128_M6_R1_0/CAP_BOTTOM_090 cap_mim_2f0_m4m5_noshield c_width=6.855u c_length=6.855u
X5269 VTOP A44_CDAC_CAP_BANK_ASSEMBLY_R8_M6_0/A44_CAP_CORE128_M6_R1_0/CAP_BOTTOM_090 cap_mim_2f0_m4m5_noshield c_width=6.855u c_length=6.855u
X5270 VTOP A44_CDAC_CAP_BANK_ASSEMBLY_R8_M6_0/A44_CAP_CORE128_M6_R1_0/CAP_BOTTOM_071 cap_mim_2f0_m4m5_noshield c_width=6.855u c_length=6.855u
X5271 VTOP A44_CDAC_CAP_BANK_ASSEMBLY_R8_M6_0/A44_CAP_CORE128_M6_R1_0/CAP_BOTTOM_071 cap_mim_2f0_m4m5_noshield c_width=6.855u c_length=6.855u
X5272 VTOP A44_CDAC_CAP_BANK_ASSEMBLY_R8_M6_0/A44_CAP_CORE128_M6_R1_0/CAP_BOTTOM_071 cap_mim_2f0_m4m5_noshield c_width=6.855u c_length=6.855u
X5273 VTOP A44_CDAC_CAP_BANK_ASSEMBLY_R8_M6_0/A44_CAP_CORE128_M6_R1_0/CAP_BOTTOM_071 cap_mim_2f0_m4m5_noshield c_width=6.855u c_length=6.855u
X5274 VTOP A44_CDAC_CAP_BANK_ASSEMBLY_R8_M6_0/A44_CAP_CORE128_M6_R1_0/CAP_BOTTOM_071 cap_mim_2f0_m4m5_noshield c_width=6.855u c_length=6.855u
X5275 VTOP A44_CDAC_CAP_BANK_ASSEMBLY_R8_M6_0/A44_CAP_CORE128_M6_R1_0/CAP_BOTTOM_071 cap_mim_2f0_m4m5_noshield c_width=6.855u c_length=6.855u
X5276 VTOP A44_CDAC_CAP_BANK_ASSEMBLY_R8_M6_0/A44_CAP_CORE128_M6_R1_0/CAP_BOTTOM_049 cap_mim_2f0_m4m5_noshield c_width=6.855u c_length=6.855u
X5277 VTOP A44_CDAC_CAP_BANK_ASSEMBLY_R8_M6_0/A44_CAP_CORE128_M6_R1_0/CAP_BOTTOM_049 cap_mim_2f0_m4m5_noshield c_width=6.855u c_length=6.855u
X5278 VTOP A44_CDAC_CAP_BANK_ASSEMBLY_R8_M6_0/A44_CAP_CORE128_M6_R1_0/CAP_BOTTOM_049 cap_mim_2f0_m4m5_noshield c_width=6.855u c_length=6.855u
X5279 VTOP A44_CDAC_CAP_BANK_ASSEMBLY_R8_M6_0/A44_CAP_CORE128_M6_R1_0/CAP_BOTTOM_049 cap_mim_2f0_m4m5_noshield c_width=6.855u c_length=6.855u
X5280 VTOP A44_CDAC_CAP_BANK_ASSEMBLY_R8_M6_0/A44_CAP_CORE128_M6_R1_0/CAP_BOTTOM_049 cap_mim_2f0_m4m5_noshield c_width=6.855u c_length=6.855u
X5281 VTOP A44_CDAC_CAP_BANK_ASSEMBLY_R8_M6_0/A44_CAP_CORE128_M6_R1_0/CAP_BOTTOM_049 cap_mim_2f0_m4m5_noshield c_width=6.855u c_length=6.855u
X5282 VTOP A44_CDAC_CAP_BANK_ASSEMBLY_R8_M6_0/A44_CAP_CORE128_M6_R1_0/CAP_BOTTOM_038 cap_mim_2f0_m4m5_noshield c_width=6.855u c_length=6.855u
X5283 VTOP A44_CDAC_CAP_BANK_ASSEMBLY_R8_M6_0/A44_CAP_CORE128_M6_R1_0/CAP_BOTTOM_038 cap_mim_2f0_m4m5_noshield c_width=6.855u c_length=6.855u
X5284 VTOP A44_CDAC_CAP_BANK_ASSEMBLY_R8_M6_0/A44_CAP_CORE128_M6_R1_0/CAP_BOTTOM_038 cap_mim_2f0_m4m5_noshield c_width=6.855u c_length=6.855u
X5285 VTOP A44_CDAC_CAP_BANK_ASSEMBLY_R8_M6_0/A44_CAP_CORE128_M6_R1_0/CAP_BOTTOM_038 cap_mim_2f0_m4m5_noshield c_width=6.855u c_length=6.855u
X5286 VTOP A44_CDAC_CAP_BANK_ASSEMBLY_R8_M6_0/A44_CAP_CORE128_M6_R1_0/CAP_BOTTOM_038 cap_mim_2f0_m4m5_noshield c_width=6.855u c_length=6.855u
X5287 VTOP A44_CDAC_CAP_BANK_ASSEMBLY_R8_M6_0/A44_CAP_CORE128_M6_R1_0/CAP_BOTTOM_038 cap_mim_2f0_m4m5_noshield c_width=6.855u c_length=6.855u
X5288 VTOP A44_CDAC_CAP_BANK_ASSEMBLY_R8_M6_0/A44_CAP_CORE128_M6_R1_0/CAP_BOTTOM_120 cap_mim_2f0_m4m5_noshield c_width=6.855u c_length=6.855u
X5289 VTOP A44_CDAC_CAP_BANK_ASSEMBLY_R8_M6_0/A44_CAP_CORE128_M6_R1_0/CAP_BOTTOM_120 cap_mim_2f0_m4m5_noshield c_width=6.855u c_length=6.855u
X5290 VTOP A44_CDAC_CAP_BANK_ASSEMBLY_R8_M6_0/A44_CAP_CORE128_M6_R1_0/CAP_BOTTOM_120 cap_mim_2f0_m4m5_noshield c_width=6.855u c_length=6.855u
X5291 VTOP A44_CDAC_CAP_BANK_ASSEMBLY_R8_M6_0/A44_CAP_CORE128_M6_R1_0/CAP_BOTTOM_120 cap_mim_2f0_m4m5_noshield c_width=6.855u c_length=6.855u
X5292 VTOP A44_CDAC_CAP_BANK_ASSEMBLY_R8_M6_0/A44_CAP_CORE128_M6_R1_0/CAP_BOTTOM_120 cap_mim_2f0_m4m5_noshield c_width=6.855u c_length=6.855u
X5293 VTOP A44_CDAC_CAP_BANK_ASSEMBLY_R8_M6_0/A44_CAP_CORE128_M6_R1_0/CAP_BOTTOM_120 cap_mim_2f0_m4m5_noshield c_width=6.855u c_length=6.855u
X5294 VTOP A44_CDAC_CAP_BANK_ASSEMBLY_R8_M6_0/A44_CAP_CORE128_M6_R1_0/CAP_BOTTOM_003 cap_mim_2f0_m4m5_noshield c_width=6.855u c_length=6.855u
X5295 VTOP A44_CDAC_CAP_BANK_ASSEMBLY_R8_M6_0/A44_CAP_CORE128_M6_R1_0/CAP_BOTTOM_003 cap_mim_2f0_m4m5_noshield c_width=6.855u c_length=6.855u
X5296 VTOP A44_CDAC_CAP_BANK_ASSEMBLY_R8_M6_0/A44_CAP_CORE128_M6_R1_0/CAP_BOTTOM_003 cap_mim_2f0_m4m5_noshield c_width=6.855u c_length=6.855u
X5297 VTOP A44_CDAC_CAP_BANK_ASSEMBLY_R8_M6_0/A44_CAP_CORE128_M6_R1_0/CAP_BOTTOM_003 cap_mim_2f0_m4m5_noshield c_width=6.855u c_length=6.855u
X5298 VTOP A44_CDAC_CAP_BANK_ASSEMBLY_R8_M6_0/A44_CAP_CORE128_M6_R1_0/CAP_BOTTOM_003 cap_mim_2f0_m4m5_noshield c_width=6.855u c_length=6.855u
X5299 VTOP A44_CDAC_CAP_BANK_ASSEMBLY_R8_M6_0/A44_CAP_CORE128_M6_R1_0/CAP_BOTTOM_003 cap_mim_2f0_m4m5_noshield c_width=6.855u c_length=6.855u
X5300 VTOP A44_CDAC_CAP_BANK_ASSEMBLY_R8_M6_0/A44_CAP_CORE128_M6_R1_0/CAP_BOTTOM_096 cap_mim_2f0_m4m5_noshield c_width=6.855u c_length=6.855u
X5301 VTOP A44_CDAC_CAP_BANK_ASSEMBLY_R8_M6_0/A44_CAP_CORE128_M6_R1_0/CAP_BOTTOM_096 cap_mim_2f0_m4m5_noshield c_width=6.855u c_length=6.855u
X5302 VTOP A44_CDAC_CAP_BANK_ASSEMBLY_R8_M6_0/A44_CAP_CORE128_M6_R1_0/CAP_BOTTOM_096 cap_mim_2f0_m4m5_noshield c_width=6.855u c_length=6.855u
X5303 VTOP A44_CDAC_CAP_BANK_ASSEMBLY_R8_M6_0/A44_CAP_CORE128_M6_R1_0/CAP_BOTTOM_096 cap_mim_2f0_m4m5_noshield c_width=6.855u c_length=6.855u
X5304 VTOP A44_CDAC_CAP_BANK_ASSEMBLY_R8_M6_0/A44_CAP_CORE128_M6_R1_0/CAP_BOTTOM_096 cap_mim_2f0_m4m5_noshield c_width=6.855u c_length=6.855u
X5305 VTOP A44_CDAC_CAP_BANK_ASSEMBLY_R8_M6_0/A44_CAP_CORE128_M6_R1_0/CAP_BOTTOM_096 cap_mim_2f0_m4m5_noshield c_width=6.855u c_length=6.855u
X5306 VTOP A44_CDAC_CAP_BANK_ASSEMBLY_R8_M6_0/A44_CAP_CORE128_M6_R1_0/CAP_BOTTOM_115 cap_mim_2f0_m4m5_noshield c_width=6.855u c_length=6.855u
X5307 VTOP A44_CDAC_CAP_BANK_ASSEMBLY_R8_M6_0/A44_CAP_CORE128_M6_R1_0/CAP_BOTTOM_115 cap_mim_2f0_m4m5_noshield c_width=6.855u c_length=6.855u
X5308 VTOP A44_CDAC_CAP_BANK_ASSEMBLY_R8_M6_0/A44_CAP_CORE128_M6_R1_0/CAP_BOTTOM_115 cap_mim_2f0_m4m5_noshield c_width=6.855u c_length=6.855u
X5309 VTOP A44_CDAC_CAP_BANK_ASSEMBLY_R8_M6_0/A44_CAP_CORE128_M6_R1_0/CAP_BOTTOM_115 cap_mim_2f0_m4m5_noshield c_width=6.855u c_length=6.855u
X5310 VTOP A44_CDAC_CAP_BANK_ASSEMBLY_R8_M6_0/A44_CAP_CORE128_M6_R1_0/CAP_BOTTOM_115 cap_mim_2f0_m4m5_noshield c_width=6.855u c_length=6.855u
X5311 VTOP A44_CDAC_CAP_BANK_ASSEMBLY_R8_M6_0/A44_CAP_CORE128_M6_R1_0/CAP_BOTTOM_115 cap_mim_2f0_m4m5_noshield c_width=6.855u c_length=6.855u
X5312 VTOP A44_CDAC_CAP_BANK_ASSEMBLY_R8_M6_0/A44_CAP_CORE128_M6_R1_0/CAP_BOTTOM_089 cap_mim_2f0_m4m5_noshield c_width=6.855u c_length=6.855u
X5313 VTOP A44_CDAC_CAP_BANK_ASSEMBLY_R8_M6_0/A44_CAP_CORE128_M6_R1_0/CAP_BOTTOM_089 cap_mim_2f0_m4m5_noshield c_width=6.855u c_length=6.855u
X5314 VTOP A44_CDAC_CAP_BANK_ASSEMBLY_R8_M6_0/A44_CAP_CORE128_M6_R1_0/CAP_BOTTOM_089 cap_mim_2f0_m4m5_noshield c_width=6.855u c_length=6.855u
X5315 VTOP A44_CDAC_CAP_BANK_ASSEMBLY_R8_M6_0/A44_CAP_CORE128_M6_R1_0/CAP_BOTTOM_089 cap_mim_2f0_m4m5_noshield c_width=6.855u c_length=6.855u
X5316 VTOP A44_CDAC_CAP_BANK_ASSEMBLY_R8_M6_0/A44_CAP_CORE128_M6_R1_0/CAP_BOTTOM_089 cap_mim_2f0_m4m5_noshield c_width=6.855u c_length=6.855u
X5317 VTOP A44_CDAC_CAP_BANK_ASSEMBLY_R8_M6_0/A44_CAP_CORE128_M6_R1_0/CAP_BOTTOM_089 cap_mim_2f0_m4m5_noshield c_width=6.855u c_length=6.855u
X5318 VTOP A44_CDAC_CAP_BANK_ASSEMBLY_R8_M6_0/A44_CAP_CORE128_M6_R1_0/CAP_BOTTOM_070 cap_mim_2f0_m4m5_noshield c_width=6.855u c_length=6.855u
X5319 VTOP A44_CDAC_CAP_BANK_ASSEMBLY_R8_M6_0/A44_CAP_CORE128_M6_R1_0/CAP_BOTTOM_070 cap_mim_2f0_m4m5_noshield c_width=6.855u c_length=6.855u
X5320 VTOP A44_CDAC_CAP_BANK_ASSEMBLY_R8_M6_0/A44_CAP_CORE128_M6_R1_0/CAP_BOTTOM_070 cap_mim_2f0_m4m5_noshield c_width=6.855u c_length=6.855u
X5321 VTOP A44_CDAC_CAP_BANK_ASSEMBLY_R8_M6_0/A44_CAP_CORE128_M6_R1_0/CAP_BOTTOM_070 cap_mim_2f0_m4m5_noshield c_width=6.855u c_length=6.855u
X5322 VTOP A44_CDAC_CAP_BANK_ASSEMBLY_R8_M6_0/A44_CAP_CORE128_M6_R1_0/CAP_BOTTOM_070 cap_mim_2f0_m4m5_noshield c_width=6.855u c_length=6.855u
X5323 VTOP A44_CDAC_CAP_BANK_ASSEMBLY_R8_M6_0/A44_CAP_CORE128_M6_R1_0/CAP_BOTTOM_070 cap_mim_2f0_m4m5_noshield c_width=6.855u c_length=6.855u
X5324 VTOP A44_CDAC_CAP_BANK_ASSEMBLY_R8_M6_0/A44_CAP_CORE128_M6_R1_0/CAP_BOTTOM_078 cap_mim_2f0_m4m5_noshield c_width=6.855u c_length=6.855u
X5325 VTOP A44_CDAC_CAP_BANK_ASSEMBLY_R8_M6_0/A44_CAP_CORE128_M6_R1_0/CAP_BOTTOM_078 cap_mim_2f0_m4m5_noshield c_width=6.855u c_length=6.855u
X5326 VTOP A44_CDAC_CAP_BANK_ASSEMBLY_R8_M6_0/A44_CAP_CORE128_M6_R1_0/CAP_BOTTOM_078 cap_mim_2f0_m4m5_noshield c_width=6.855u c_length=6.855u
X5327 VTOP A44_CDAC_CAP_BANK_ASSEMBLY_R8_M6_0/A44_CAP_CORE128_M6_R1_0/CAP_BOTTOM_078 cap_mim_2f0_m4m5_noshield c_width=6.855u c_length=6.855u
X5328 VTOP A44_CDAC_CAP_BANK_ASSEMBLY_R8_M6_0/A44_CAP_CORE128_M6_R1_0/CAP_BOTTOM_078 cap_mim_2f0_m4m5_noshield c_width=6.855u c_length=6.855u
X5329 VTOP A44_CDAC_CAP_BANK_ASSEMBLY_R8_M6_0/A44_CAP_CORE128_M6_R1_0/CAP_BOTTOM_078 cap_mim_2f0_m4m5_noshield c_width=6.855u c_length=6.855u
X5330 VTOP A44_CDAC_CAP_BANK_ASSEMBLY_R8_M6_0/A44_CAP_CORE128_M6_R1_0/CAP_BOTTOM_048 cap_mim_2f0_m4m5_noshield c_width=6.855u c_length=6.855u
X5331 VTOP A44_CDAC_CAP_BANK_ASSEMBLY_R8_M6_0/A44_CAP_CORE128_M6_R1_0/CAP_BOTTOM_048 cap_mim_2f0_m4m5_noshield c_width=6.855u c_length=6.855u
X5332 VTOP A44_CDAC_CAP_BANK_ASSEMBLY_R8_M6_0/A44_CAP_CORE128_M6_R1_0/CAP_BOTTOM_048 cap_mim_2f0_m4m5_noshield c_width=6.855u c_length=6.855u
X5333 VTOP A44_CDAC_CAP_BANK_ASSEMBLY_R8_M6_0/A44_CAP_CORE128_M6_R1_0/CAP_BOTTOM_048 cap_mim_2f0_m4m5_noshield c_width=6.855u c_length=6.855u
X5334 VTOP A44_CDAC_CAP_BANK_ASSEMBLY_R8_M6_0/A44_CAP_CORE128_M6_R1_0/CAP_BOTTOM_048 cap_mim_2f0_m4m5_noshield c_width=6.855u c_length=6.855u
X5335 VTOP A44_CDAC_CAP_BANK_ASSEMBLY_R8_M6_0/A44_CAP_CORE128_M6_R1_0/CAP_BOTTOM_048 cap_mim_2f0_m4m5_noshield c_width=6.855u c_length=6.855u
X5336 VTOP A44_CDAC_CAP_BANK_ASSEMBLY_R8_M6_0/A44_CAP_CORE128_M6_R1_0/CAP_BOTTOM_119 cap_mim_2f0_m4m5_noshield c_width=6.855u c_length=6.855u
X5337 VTOP A44_CDAC_CAP_BANK_ASSEMBLY_R8_M6_0/A44_CAP_CORE128_M6_R1_0/CAP_BOTTOM_119 cap_mim_2f0_m4m5_noshield c_width=6.855u c_length=6.855u
X5338 VTOP A44_CDAC_CAP_BANK_ASSEMBLY_R8_M6_0/A44_CAP_CORE128_M6_R1_0/CAP_BOTTOM_119 cap_mim_2f0_m4m5_noshield c_width=6.855u c_length=6.855u
X5339 VTOP A44_CDAC_CAP_BANK_ASSEMBLY_R8_M6_0/A44_CAP_CORE128_M6_R1_0/CAP_BOTTOM_119 cap_mim_2f0_m4m5_noshield c_width=6.855u c_length=6.855u
X5340 VTOP A44_CDAC_CAP_BANK_ASSEMBLY_R8_M6_0/A44_CAP_CORE128_M6_R1_0/CAP_BOTTOM_119 cap_mim_2f0_m4m5_noshield c_width=6.855u c_length=6.855u
X5341 VTOP A44_CDAC_CAP_BANK_ASSEMBLY_R8_M6_0/A44_CAP_CORE128_M6_R1_0/CAP_BOTTOM_119 cap_mim_2f0_m4m5_noshield c_width=6.855u c_length=6.855u
X5342 VTOP A44_CDAC_CAP_BANK_ASSEMBLY_R8_M6_0/A44_CAP_CORE128_M6_R1_0/CAP_BOTTOM_002 cap_mim_2f0_m4m5_noshield c_width=6.855u c_length=6.855u
X5343 VTOP A44_CDAC_CAP_BANK_ASSEMBLY_R8_M6_0/A44_CAP_CORE128_M6_R1_0/CAP_BOTTOM_002 cap_mim_2f0_m4m5_noshield c_width=6.855u c_length=6.855u
X5344 VTOP A44_CDAC_CAP_BANK_ASSEMBLY_R8_M6_0/A44_CAP_CORE128_M6_R1_0/CAP_BOTTOM_002 cap_mim_2f0_m4m5_noshield c_width=6.855u c_length=6.855u
X5345 VTOP A44_CDAC_CAP_BANK_ASSEMBLY_R8_M6_0/A44_CAP_CORE128_M6_R1_0/CAP_BOTTOM_002 cap_mim_2f0_m4m5_noshield c_width=6.855u c_length=6.855u
X5346 VTOP A44_CDAC_CAP_BANK_ASSEMBLY_R8_M6_0/A44_CAP_CORE128_M6_R1_0/CAP_BOTTOM_002 cap_mim_2f0_m4m5_noshield c_width=6.855u c_length=6.855u
X5347 VTOP A44_CDAC_CAP_BANK_ASSEMBLY_R8_M6_0/A44_CAP_CORE128_M6_R1_0/CAP_BOTTOM_002 cap_mim_2f0_m4m5_noshield c_width=6.855u c_length=6.855u
X5348 VTOP A44_CDAC_CAP_BANK_ASSEMBLY_R8_M6_0/A44_CAP_CORE128_M6_R1_0/CAP_BOTTOM_095 cap_mim_2f0_m4m5_noshield c_width=6.855u c_length=6.855u
X5349 VTOP A44_CDAC_CAP_BANK_ASSEMBLY_R8_M6_0/A44_CAP_CORE128_M6_R1_0/CAP_BOTTOM_095 cap_mim_2f0_m4m5_noshield c_width=6.855u c_length=6.855u
X5350 VTOP A44_CDAC_CAP_BANK_ASSEMBLY_R8_M6_0/A44_CAP_CORE128_M6_R1_0/CAP_BOTTOM_095 cap_mim_2f0_m4m5_noshield c_width=6.855u c_length=6.855u
X5351 VTOP A44_CDAC_CAP_BANK_ASSEMBLY_R8_M6_0/A44_CAP_CORE128_M6_R1_0/CAP_BOTTOM_095 cap_mim_2f0_m4m5_noshield c_width=6.855u c_length=6.855u
X5352 VTOP A44_CDAC_CAP_BANK_ASSEMBLY_R8_M6_0/A44_CAP_CORE128_M6_R1_0/CAP_BOTTOM_095 cap_mim_2f0_m4m5_noshield c_width=6.855u c_length=6.855u
X5353 VTOP A44_CDAC_CAP_BANK_ASSEMBLY_R8_M6_0/A44_CAP_CORE128_M6_R1_0/CAP_BOTTOM_095 cap_mim_2f0_m4m5_noshield c_width=6.855u c_length=6.855u
X5354 VTOP A44_CDAC_CAP_BANK_ASSEMBLY_R8_M6_0/A44_CAP_CORE128_M6_R1_0/CAP_BOTTOM_114 cap_mim_2f0_m4m5_noshield c_width=6.855u c_length=6.855u
X5355 VTOP A44_CDAC_CAP_BANK_ASSEMBLY_R8_M6_0/A44_CAP_CORE128_M6_R1_0/CAP_BOTTOM_114 cap_mim_2f0_m4m5_noshield c_width=6.855u c_length=6.855u
X5356 VTOP A44_CDAC_CAP_BANK_ASSEMBLY_R8_M6_0/A44_CAP_CORE128_M6_R1_0/CAP_BOTTOM_114 cap_mim_2f0_m4m5_noshield c_width=6.855u c_length=6.855u
X5357 VTOP A44_CDAC_CAP_BANK_ASSEMBLY_R8_M6_0/A44_CAP_CORE128_M6_R1_0/CAP_BOTTOM_114 cap_mim_2f0_m4m5_noshield c_width=6.855u c_length=6.855u
X5358 VTOP A44_CDAC_CAP_BANK_ASSEMBLY_R8_M6_0/A44_CAP_CORE128_M6_R1_0/CAP_BOTTOM_114 cap_mim_2f0_m4m5_noshield c_width=6.855u c_length=6.855u
X5359 VTOP A44_CDAC_CAP_BANK_ASSEMBLY_R8_M6_0/A44_CAP_CORE128_M6_R1_0/CAP_BOTTOM_114 cap_mim_2f0_m4m5_noshield c_width=6.855u c_length=6.855u
X5360 VTOP A44_CDAC_CAP_BANK_ASSEMBLY_R8_M6_0/A44_CAP_CORE128_M6_R1_0/CAP_BOTTOM_088 cap_mim_2f0_m4m5_noshield c_width=6.855u c_length=6.855u
X5361 VTOP A44_CDAC_CAP_BANK_ASSEMBLY_R8_M6_0/A44_CAP_CORE128_M6_R1_0/CAP_BOTTOM_088 cap_mim_2f0_m4m5_noshield c_width=6.855u c_length=6.855u
X5362 VTOP A44_CDAC_CAP_BANK_ASSEMBLY_R8_M6_0/A44_CAP_CORE128_M6_R1_0/CAP_BOTTOM_088 cap_mim_2f0_m4m5_noshield c_width=6.855u c_length=6.855u
X5363 VTOP A44_CDAC_CAP_BANK_ASSEMBLY_R8_M6_0/A44_CAP_CORE128_M6_R1_0/CAP_BOTTOM_088 cap_mim_2f0_m4m5_noshield c_width=6.855u c_length=6.855u
X5364 VTOP A44_CDAC_CAP_BANK_ASSEMBLY_R8_M6_0/A44_CAP_CORE128_M6_R1_0/CAP_BOTTOM_088 cap_mim_2f0_m4m5_noshield c_width=6.855u c_length=6.855u
X5365 VTOP A44_CDAC_CAP_BANK_ASSEMBLY_R8_M6_0/A44_CAP_CORE128_M6_R1_0/CAP_BOTTOM_088 cap_mim_2f0_m4m5_noshield c_width=6.855u c_length=6.855u
X5366 VTOP A44_CDAC_CAP_BANK_ASSEMBLY_R8_M6_0/A44_CAP_CORE128_M6_R1_0/CAP_BOTTOM_069 cap_mim_2f0_m4m5_noshield c_width=6.855u c_length=6.855u
X5367 VTOP A44_CDAC_CAP_BANK_ASSEMBLY_R8_M6_0/A44_CAP_CORE128_M6_R1_0/CAP_BOTTOM_069 cap_mim_2f0_m4m5_noshield c_width=6.855u c_length=6.855u
X5368 VTOP A44_CDAC_CAP_BANK_ASSEMBLY_R8_M6_0/A44_CAP_CORE128_M6_R1_0/CAP_BOTTOM_069 cap_mim_2f0_m4m5_noshield c_width=6.855u c_length=6.855u
X5369 VTOP A44_CDAC_CAP_BANK_ASSEMBLY_R8_M6_0/A44_CAP_CORE128_M6_R1_0/CAP_BOTTOM_069 cap_mim_2f0_m4m5_noshield c_width=6.855u c_length=6.855u
X5370 VTOP A44_CDAC_CAP_BANK_ASSEMBLY_R8_M6_0/A44_CAP_CORE128_M6_R1_0/CAP_BOTTOM_069 cap_mim_2f0_m4m5_noshield c_width=6.855u c_length=6.855u
X5371 VTOP A44_CDAC_CAP_BANK_ASSEMBLY_R8_M6_0/A44_CAP_CORE128_M6_R1_0/CAP_BOTTOM_069 cap_mim_2f0_m4m5_noshield c_width=6.855u c_length=6.855u
X5372 VTOP A44_CDAC_CAP_BANK_ASSEMBLY_R8_M6_0/A44_CAP_CORE128_M6_R1_0/CAP_BOTTOM_077 cap_mim_2f0_m4m5_noshield c_width=6.855u c_length=6.855u
X5373 VTOP A44_CDAC_CAP_BANK_ASSEMBLY_R8_M6_0/A44_CAP_CORE128_M6_R1_0/CAP_BOTTOM_077 cap_mim_2f0_m4m5_noshield c_width=6.855u c_length=6.855u
X5374 VTOP A44_CDAC_CAP_BANK_ASSEMBLY_R8_M6_0/A44_CAP_CORE128_M6_R1_0/CAP_BOTTOM_077 cap_mim_2f0_m4m5_noshield c_width=6.855u c_length=6.855u
X5375 VTOP A44_CDAC_CAP_BANK_ASSEMBLY_R8_M6_0/A44_CAP_CORE128_M6_R1_0/CAP_BOTTOM_077 cap_mim_2f0_m4m5_noshield c_width=6.855u c_length=6.855u
X5376 VTOP A44_CDAC_CAP_BANK_ASSEMBLY_R8_M6_0/A44_CAP_CORE128_M6_R1_0/CAP_BOTTOM_077 cap_mim_2f0_m4m5_noshield c_width=6.855u c_length=6.855u
X5377 VTOP A44_CDAC_CAP_BANK_ASSEMBLY_R8_M6_0/A44_CAP_CORE128_M6_R1_0/CAP_BOTTOM_077 cap_mim_2f0_m4m5_noshield c_width=6.855u c_length=6.855u
X5378 VTOP A44_CDAC_CAP_BANK_ASSEMBLY_R8_M6_0/A44_CAP_CORE128_M6_R1_0/CAP_BOTTOM_094 cap_mim_2f0_m4m5_noshield c_width=6.855u c_length=6.855u
X5379 VTOP A44_CDAC_CAP_BANK_ASSEMBLY_R8_M6_0/A44_CAP_CORE128_M6_R1_0/CAP_BOTTOM_094 cap_mim_2f0_m4m5_noshield c_width=6.855u c_length=6.855u
X5380 VTOP A44_CDAC_CAP_BANK_ASSEMBLY_R8_M6_0/A44_CAP_CORE128_M6_R1_0/CAP_BOTTOM_094 cap_mim_2f0_m4m5_noshield c_width=6.855u c_length=6.855u
X5381 VTOP A44_CDAC_CAP_BANK_ASSEMBLY_R8_M6_0/A44_CAP_CORE128_M6_R1_0/CAP_BOTTOM_094 cap_mim_2f0_m4m5_noshield c_width=6.855u c_length=6.855u
X5382 VTOP A44_CDAC_CAP_BANK_ASSEMBLY_R8_M6_0/A44_CAP_CORE128_M6_R1_0/CAP_BOTTOM_094 cap_mim_2f0_m4m5_noshield c_width=6.855u c_length=6.855u
X5383 VTOP A44_CDAC_CAP_BANK_ASSEMBLY_R8_M6_0/A44_CAP_CORE128_M6_R1_0/CAP_BOTTOM_094 cap_mim_2f0_m4m5_noshield c_width=6.855u c_length=6.855u
X5384 VTOP A44_CDAC_CAP_BANK_ASSEMBLY_R8_M6_0/A44_CAP_CORE128_M6_R1_0/CAP_BOTTOM_113 cap_mim_2f0_m4m5_noshield c_width=6.855u c_length=6.855u
X5385 VTOP A44_CDAC_CAP_BANK_ASSEMBLY_R8_M6_0/A44_CAP_CORE128_M6_R1_0/CAP_BOTTOM_113 cap_mim_2f0_m4m5_noshield c_width=6.855u c_length=6.855u
X5386 VTOP A44_CDAC_CAP_BANK_ASSEMBLY_R8_M6_0/A44_CAP_CORE128_M6_R1_0/CAP_BOTTOM_113 cap_mim_2f0_m4m5_noshield c_width=6.855u c_length=6.855u
X5387 VTOP A44_CDAC_CAP_BANK_ASSEMBLY_R8_M6_0/A44_CAP_CORE128_M6_R1_0/CAP_BOTTOM_113 cap_mim_2f0_m4m5_noshield c_width=6.855u c_length=6.855u
X5388 VTOP A44_CDAC_CAP_BANK_ASSEMBLY_R8_M6_0/A44_CAP_CORE128_M6_R1_0/CAP_BOTTOM_113 cap_mim_2f0_m4m5_noshield c_width=6.855u c_length=6.855u
X5389 VTOP A44_CDAC_CAP_BANK_ASSEMBLY_R8_M6_0/A44_CAP_CORE128_M6_R1_0/CAP_BOTTOM_113 cap_mim_2f0_m4m5_noshield c_width=6.855u c_length=6.855u
X5390 VTOP A44_CDAC_CAP_BANK_ASSEMBLY_R8_M6_0/A44_CAP_CORE128_M6_R1_0/CAP_BOTTOM_086 cap_mim_2f0_m4m5_noshield c_width=6.855u c_length=6.855u
X5391 VTOP A44_CDAC_CAP_BANK_ASSEMBLY_R8_M6_0/A44_CAP_CORE128_M6_R1_0/CAP_BOTTOM_086 cap_mim_2f0_m4m5_noshield c_width=6.855u c_length=6.855u
X5392 VTOP A44_CDAC_CAP_BANK_ASSEMBLY_R8_M6_0/A44_CAP_CORE128_M6_R1_0/CAP_BOTTOM_086 cap_mim_2f0_m4m5_noshield c_width=6.855u c_length=6.855u
X5393 VTOP A44_CDAC_CAP_BANK_ASSEMBLY_R8_M6_0/A44_CAP_CORE128_M6_R1_0/CAP_BOTTOM_086 cap_mim_2f0_m4m5_noshield c_width=6.855u c_length=6.855u
X5394 VTOP A44_CDAC_CAP_BANK_ASSEMBLY_R8_M6_0/A44_CAP_CORE128_M6_R1_0/CAP_BOTTOM_086 cap_mim_2f0_m4m5_noshield c_width=6.855u c_length=6.855u
X5395 VTOP A44_CDAC_CAP_BANK_ASSEMBLY_R8_M6_0/A44_CAP_CORE128_M6_R1_0/CAP_BOTTOM_086 cap_mim_2f0_m4m5_noshield c_width=6.855u c_length=6.855u
X5396 VTOP A44_CDAC_CAP_BANK_ASSEMBLY_R8_M6_0/A44_CAP_CORE128_M6_R1_0/CAP_BOTTOM_087 cap_mim_2f0_m4m5_noshield c_width=6.855u c_length=6.855u
X5397 VTOP A44_CDAC_CAP_BANK_ASSEMBLY_R8_M6_0/A44_CAP_CORE128_M6_R1_0/CAP_BOTTOM_087 cap_mim_2f0_m4m5_noshield c_width=6.855u c_length=6.855u
X5398 VTOP A44_CDAC_CAP_BANK_ASSEMBLY_R8_M6_0/A44_CAP_CORE128_M6_R1_0/CAP_BOTTOM_087 cap_mim_2f0_m4m5_noshield c_width=6.855u c_length=6.855u
X5399 VTOP A44_CDAC_CAP_BANK_ASSEMBLY_R8_M6_0/A44_CAP_CORE128_M6_R1_0/CAP_BOTTOM_087 cap_mim_2f0_m4m5_noshield c_width=6.855u c_length=6.855u
X5400 VTOP A44_CDAC_CAP_BANK_ASSEMBLY_R8_M6_0/A44_CAP_CORE128_M6_R1_0/CAP_BOTTOM_087 cap_mim_2f0_m4m5_noshield c_width=6.855u c_length=6.855u
X5401 VTOP A44_CDAC_CAP_BANK_ASSEMBLY_R8_M6_0/A44_CAP_CORE128_M6_R1_0/CAP_BOTTOM_087 cap_mim_2f0_m4m5_noshield c_width=6.855u c_length=6.855u
X5402 VTOP A44_CDAC_CAP_BANK_ASSEMBLY_R8_M6_0/A44_CAP_CORE128_M6_R1_0/CAP_BOTTOM_068 cap_mim_2f0_m4m5_noshield c_width=6.855u c_length=6.855u
X5403 VTOP A44_CDAC_CAP_BANK_ASSEMBLY_R8_M6_0/A44_CAP_CORE128_M6_R1_0/CAP_BOTTOM_068 cap_mim_2f0_m4m5_noshield c_width=6.855u c_length=6.855u
X5404 VTOP A44_CDAC_CAP_BANK_ASSEMBLY_R8_M6_0/A44_CAP_CORE128_M6_R1_0/CAP_BOTTOM_068 cap_mim_2f0_m4m5_noshield c_width=6.855u c_length=6.855u
X5405 VTOP A44_CDAC_CAP_BANK_ASSEMBLY_R8_M6_0/A44_CAP_CORE128_M6_R1_0/CAP_BOTTOM_068 cap_mim_2f0_m4m5_noshield c_width=6.855u c_length=6.855u
X5406 VTOP A44_CDAC_CAP_BANK_ASSEMBLY_R8_M6_0/A44_CAP_CORE128_M6_R1_0/CAP_BOTTOM_068 cap_mim_2f0_m4m5_noshield c_width=6.855u c_length=6.855u
X5407 VTOP A44_CDAC_CAP_BANK_ASSEMBLY_R8_M6_0/A44_CAP_CORE128_M6_R1_0/CAP_BOTTOM_068 cap_mim_2f0_m4m5_noshield c_width=6.855u c_length=6.855u
X5408 VTOP A44_CDAC_CAP_BANK_ASSEMBLY_R8_M6_0/A44_CAP_CORE128_M6_R1_0/CAP_BOTTOM_076 cap_mim_2f0_m4m5_noshield c_width=6.855u c_length=6.855u
X5409 VTOP A44_CDAC_CAP_BANK_ASSEMBLY_R8_M6_0/A44_CAP_CORE128_M6_R1_0/CAP_BOTTOM_076 cap_mim_2f0_m4m5_noshield c_width=6.855u c_length=6.855u
X5410 VTOP A44_CDAC_CAP_BANK_ASSEMBLY_R8_M6_0/A44_CAP_CORE128_M6_R1_0/CAP_BOTTOM_076 cap_mim_2f0_m4m5_noshield c_width=6.855u c_length=6.855u
X5411 VTOP A44_CDAC_CAP_BANK_ASSEMBLY_R8_M6_0/A44_CAP_CORE128_M6_R1_0/CAP_BOTTOM_076 cap_mim_2f0_m4m5_noshield c_width=6.855u c_length=6.855u
X5412 VTOP A44_CDAC_CAP_BANK_ASSEMBLY_R8_M6_0/A44_CAP_CORE128_M6_R1_0/CAP_BOTTOM_076 cap_mim_2f0_m4m5_noshield c_width=6.855u c_length=6.855u
X5413 VTOP A44_CDAC_CAP_BANK_ASSEMBLY_R8_M6_0/A44_CAP_CORE128_M6_R1_0/CAP_BOTTOM_076 cap_mim_2f0_m4m5_noshield c_width=6.855u c_length=6.855u
X5414 A44_DCTRL_STRIP_W_R2_0/CTRL_OUT[2] A44_DCTRL_STRIP_W_R2_0/XDCTRL_CH2_R0/MID GND GND nfet_03v3 ad=3.69235p pd=13.64u as=3.69235p ps=13.64u w=6.22u l=0.28u
X5415 A44_DCTRL_STRIP_W_R2_0/XDCTRL_CH2_R0/MID DCTRL[2] VDD VDD pfet_03v3 ad=2.77275p pd=10.54u as=2.77275p ps=10.54u w=4.67u l=0.28u
X5416 A44_DCTRL_STRIP_W_R2_0/XDCTRL_CH2_R0/MID DCTRL[2] GND GND nfet_03v3 ad=1.3897p pd=5.88u as=1.3897p ps=5.88u w=2.34u l=0.28u
X5417 A44_DCTRL_STRIP_W_R2_0/CTRL_OUT[2] A44_DCTRL_STRIP_W_R2_0/XDCTRL_CH2_R0/MID VDD VDD pfet_03v3 ad=7.38405p pd=26.08u as=7.38405p ps=26.08u w=12.44u l=0.28u
X5418 A44_DCTRL_STRIP_W_R2_0/CTRL_OUT[5] A44_DCTRL_STRIP_W_R2_0/XDCTRL_CH5_R0/MID GND GND nfet_03v3 ad=3.69235p pd=13.64u as=46.03025p ps=0.1916m w=6.22u l=0.28u
X5419 A44_DCTRL_STRIP_W_R2_0/XDCTRL_CH5_R0/MID DCTRL[5] VDD VDD pfet_03v3 ad=2.77275p pd=10.54u as=92.0003p ps=0.33938m w=4.67u l=0.28u
X5420 A44_DCTRL_STRIP_W_R2_0/XDCTRL_CH5_R0/MID DCTRL[5] GND GND nfet_03v3 ad=1.3897p pd=5.88u as=0 ps=0 w=2.34u l=0.28u
X5421 A44_DCTRL_STRIP_W_R2_0/CTRL_OUT[5] A44_DCTRL_STRIP_W_R2_0/XDCTRL_CH5_R0/MID VDD VDD pfet_03v3 ad=7.38405p pd=26.08u as=0 ps=0 w=12.44u l=0.28u
X5422 A44_DCTRL_STRIP_W_R2_0/CTRL_OUT[3] A44_DCTRL_STRIP_W_R2_0/XDCTRL_CH3_R0/MID GND GND nfet_03v3 ad=3.69235p pd=13.64u as=0 ps=0 w=6.22u l=0.28u
X5423 A44_DCTRL_STRIP_W_R2_0/XDCTRL_CH3_R0/MID DCTRL[3] VDD VDD pfet_03v3 ad=2.77275p pd=10.54u as=0 ps=0 w=4.67u l=0.28u
X5424 A44_DCTRL_STRIP_W_R2_0/XDCTRL_CH3_R0/MID DCTRL[3] GND GND nfet_03v3 ad=1.3897p pd=5.88u as=0 ps=0 w=2.34u l=0.28u
X5425 A44_DCTRL_STRIP_W_R2_0/CTRL_OUT[3] A44_DCTRL_STRIP_W_R2_0/XDCTRL_CH3_R0/MID VDD VDD pfet_03v3 ad=7.38405p pd=26.08u as=0 ps=0 w=12.44u l=0.28u
X5426 A44_DCTRL_STRIP_W_R2_0/CTRL_OUT[6] A44_DCTRL_STRIP_W_R2_0/XDCTRL_CH6_R0/MID GND GND nfet_03v3 ad=3.69235p pd=13.64u as=0 ps=0 w=6.22u l=0.28u
X5427 A44_DCTRL_STRIP_W_R2_0/XDCTRL_CH6_R0/MID DCTRL[6] VDD VDD pfet_03v3 ad=2.77275p pd=10.54u as=0 ps=0 w=4.67u l=0.28u
X5428 A44_DCTRL_STRIP_W_R2_0/XDCTRL_CH6_R0/MID DCTRL[6] GND GND nfet_03v3 ad=1.3897p pd=5.88u as=0 ps=0 w=2.34u l=0.28u
X5429 A44_DCTRL_STRIP_W_R2_0/CTRL_OUT[6] A44_DCTRL_STRIP_W_R2_0/XDCTRL_CH6_R0/MID VDD VDD pfet_03v3 ad=7.38405p pd=26.08u as=0 ps=0 w=12.44u l=0.28u
X5430 A44_DCTRL_STRIP_W_R2_0/CTRL_OUT[1] A44_DCTRL_STRIP_W_R2_0/XDCTRL_CH1_R0/MID GND GND nfet_03v3 ad=3.69235p pd=13.64u as=0 ps=0 w=6.22u l=0.28u
X5431 A44_DCTRL_STRIP_W_R2_0/XDCTRL_CH1_R0/MID DCTRL[1] VDD VDD pfet_03v3 ad=2.77275p pd=10.54u as=0 ps=0 w=4.67u l=0.28u
X5432 A44_DCTRL_STRIP_W_R2_0/XDCTRL_CH1_R0/MID DCTRL[1] GND GND nfet_03v3 ad=1.3897p pd=5.88u as=0 ps=0 w=2.34u l=0.28u
X5433 A44_DCTRL_STRIP_W_R2_0/CTRL_OUT[1] A44_DCTRL_STRIP_W_R2_0/XDCTRL_CH1_R0/MID VDD VDD pfet_03v3 ad=7.38405p pd=26.08u as=0 ps=0 w=12.44u l=0.28u
X5434 A44_DCTRL_STRIP_W_R2_0/CTRL_OUT[4] A44_DCTRL_STRIP_W_R2_0/XDCTRL_CH4_R0/MID GND GND nfet_03v3 ad=3.69235p pd=13.64u as=0 ps=0 w=6.22u l=0.28u
X5435 A44_DCTRL_STRIP_W_R2_0/XDCTRL_CH4_R0/MID DCTRL[4] VDD VDD pfet_03v3 ad=2.77275p pd=10.54u as=0 ps=0 w=4.67u l=0.28u
X5436 A44_DCTRL_STRIP_W_R2_0/XDCTRL_CH4_R0/MID DCTRL[4] GND GND nfet_03v3 ad=1.3897p pd=5.88u as=0 ps=0 w=2.34u l=0.28u
X5437 A44_DCTRL_STRIP_W_R2_0/CTRL_OUT[4] A44_DCTRL_STRIP_W_R2_0/XDCTRL_CH4_R0/MID VDD VDD pfet_03v3 ad=7.38405p pd=26.08u as=0 ps=0 w=12.44u l=0.28u
X5438 A44_DCTRL_STRIP_W_R2_0/CTRL_OUT[7] A44_DCTRL_STRIP_W_R2_0/XDCTRL_CH7_R0/MID GND GND nfet_03v3 ad=3.69235p pd=13.64u as=0 ps=0 w=6.22u l=0.28u
X5439 A44_DCTRL_STRIP_W_R2_0/XDCTRL_CH7_R0/MID DCTRL[7] VDD VDD pfet_03v3 ad=2.77275p pd=10.54u as=0 ps=0 w=4.67u l=0.28u
X5440 A44_DCTRL_STRIP_W_R2_0/XDCTRL_CH7_R0/MID DCTRL[7] GND GND nfet_03v3 ad=1.3897p pd=5.88u as=0 ps=0 w=2.34u l=0.28u
X5441 A44_DCTRL_STRIP_W_R2_0/CTRL_OUT[7] A44_DCTRL_STRIP_W_R2_0/XDCTRL_CH7_R0/MID VDD VDD pfet_03v3 ad=7.38405p pd=26.08u as=0 ps=0 w=12.44u l=0.28u
.ends
