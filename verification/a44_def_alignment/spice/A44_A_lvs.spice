* NGSPICE file created from A44_A.ext - technology: gf180mcuD

.subckt gf180mcu_fd_sc_mcu7t5v0__tiel ZN VDD VSS VNW VPW
X0 ZN a_124_24# VSS VPW nfet_05v0 ad=0.3608p pd=2.52u as=0.3608p ps=2.52u w=0.82u l=0.6u
X1 a_124_24# a_124_24# VDD VNW pfet_05v0 ad=0.5368p pd=3.32u as=0.5368p ps=3.32u w=1.22u l=0.5u
.ends

.subckt gf180mcu_fd_sc_mcu7t5v0__fillcap_4 VDD VSS VNW VPW
X0 a_124_375# a_36_472# VSS VPW nfet_05v0 ad=0.3608p pd=2.52u as=0.3608p ps=2.52u w=0.82u l=1u
X1 VDD a_124_375# a_36_472# VNW pfet_05v0 ad=0.5368p pd=3.32u as=0.5368p ps=3.32u w=1.22u l=1u
.ends

.subckt gf180mcu_fd_sc_mcu7t5v0__oai31_1 VDD ZN B A1 A2 VSS A3 VNW VPW
X0 a_468_497# A1 ZN VNW pfet_05v0 ad=0.58035p pd=2.155u as=0.4012p ps=1.85u w=1.095u l=0.5u
X1 a_244_69# A2 ZN VPW nfet_05v0 ad=0.2119p pd=1.335u as=0.4137p ps=1.9u w=0.815u l=0.6u
X2 a_780_497# A2 a_468_497# VNW pfet_05v0 ad=0.2847p pd=1.615u as=0.58035p ps=2.155u w=1.095u l=0.5u
X3 ZN A1 a_244_69# VPW nfet_05v0 ad=0.4137p pd=1.9u as=0.2119p ps=1.335u w=0.815u l=0.6u
X4 VDD A3 a_780_497# VNW pfet_05v0 ad=0.5913p pd=3.27u as=0.2847p ps=1.615u w=1.095u l=0.5u
X5 a_244_69# B VSS VPW nfet_05v0 ad=0.2119p pd=1.335u as=0.3586p ps=2.51u w=0.815u l=0.6u
X6 ZN B VDD VNW pfet_05v0 ad=0.4012p pd=1.85u as=0.4972p ps=3.14u w=1.13u l=0.5u
X7 ZN A3 a_244_69# VPW nfet_05v0 ad=0.3586p pd=2.51u as=0.2119p ps=1.335u w=0.815u l=0.6u
.ends

.subckt gf180mcu_fd_sc_mcu7t5v0__clkbuf_2 Z VSS VDD I VNW VPW
X0 VDD I a_36_160# VNW pfet_05v0 ad=0.458p pd=2.02u as=0.4488p ps=2.92u w=1.02u l=0.5u
X1 VSS I a_36_160# VPW nfet_05v0 ad=0.151p pd=1.185u as=0.1584p ps=1.6u w=0.36u l=0.6u
X2 VDD a_36_160# Z VNW pfet_05v0 ad=0.5368p pd=3.32u as=0.3782p ps=1.84u w=1.22u l=0.5u
X3 Z a_36_160# VDD VNW pfet_05v0 ad=0.3782p pd=1.84u as=0.458p ps=2.02u w=1.22u l=0.5u
X4 VSS a_36_160# Z VPW nfet_05v0 ad=0.2134p pd=1.85u as=0.1261p ps=1.005u w=0.485u l=0.6u
X5 Z a_36_160# VSS VPW nfet_05v0 ad=0.1261p pd=1.005u as=0.151p ps=1.185u w=0.485u l=0.6u
.ends

.subckt gf180mcu_fd_sc_mcu7t5v0__buf_4 Z I VDD VSS VNW VPW
X0 Z a_224_472# VDD VNW pfet_05v0 ad=0.3782p pd=1.84u as=0.3782p ps=1.84u w=1.22u l=0.5u
X1 Z a_224_472# VSS VPW nfet_05v0 ad=0.2132p pd=1.34u as=0.2132p ps=1.34u w=0.82u l=0.6u
X2 VDD a_224_472# Z VNW pfet_05v0 ad=0.5368p pd=3.32u as=0.3782p ps=1.84u w=1.22u l=0.5u
X3 a_224_472# I VSS VPW nfet_05v0 ad=0.2132p pd=1.34u as=0.3608p ps=2.52u w=0.82u l=0.6u
X4 VDD I a_224_472# VNW pfet_05v0 ad=0.3782p pd=1.84u as=0.3782p ps=1.84u w=1.22u l=0.5u
X5 Z a_224_472# VDD VNW pfet_05v0 ad=0.3782p pd=1.84u as=0.3782p ps=1.84u w=1.22u l=0.5u
X6 VDD a_224_472# Z VNW pfet_05v0 ad=0.3782p pd=1.84u as=0.3782p ps=1.84u w=1.22u l=0.5u
X7 VSS a_224_472# Z VPW nfet_05v0 ad=0.3608p pd=2.52u as=0.2132p ps=1.34u w=0.82u l=0.6u
X8 VSS a_224_472# Z VPW nfet_05v0 ad=0.2132p pd=1.34u as=0.2132p ps=1.34u w=0.82u l=0.6u
X9 a_224_472# I VDD VNW pfet_05v0 ad=0.3782p pd=1.84u as=0.5368p ps=3.32u w=1.22u l=0.5u
X10 VSS I a_224_472# VPW nfet_05v0 ad=0.2132p pd=1.34u as=0.2132p ps=1.34u w=0.82u l=0.6u
X11 Z a_224_472# VSS VPW nfet_05v0 ad=0.2132p pd=1.34u as=0.2132p ps=1.34u w=0.82u l=0.6u
.ends

.subckt gf180mcu_fd_sc_mcu7t5v0__clkbuf_8 Z VSS VDD I VNW VPW
X0 Z a_224_552# VSS VPW nfet_05v0 ad=0.1118p pd=0.95u as=0.1892p ps=1.74u w=0.43u l=0.6u
X1 VSS a_224_552# Z VPW nfet_05v0 ad=0.1118p pd=0.95u as=0.1118p ps=0.95u w=0.43u l=0.6u
X2 VDD a_224_552# Z VNW pfet_05v0 ad=0.3172p pd=1.74u as=0.4392p ps=1.94u w=1.22u l=0.5u
X3 a_224_552# I VDD VNW pfet_05v0 ad=0.2952p pd=1.54u as=0.3608p ps=2.52u w=0.82u l=0.5u
X4 VDD I a_224_552# VNW pfet_05v0 ad=0.2132p pd=1.34u as=0.2952p ps=1.54u w=0.82u l=0.5u
X5 Z a_224_552# VDD VNW pfet_05v0 ad=0.4392p pd=1.94u as=0.3172p ps=1.74u w=1.22u l=0.5u
X6 VDD a_224_552# Z VNW pfet_05v0 ad=0.3172p pd=1.74u as=0.4392p ps=1.94u w=1.22u l=0.5u
X7 VSS I a_224_552# VPW nfet_05v0 ad=0.1053p pd=0.925u as=0.1053p ps=0.925u w=0.405u l=0.6u
X8 a_224_552# I VDD VNW pfet_05v0 ad=0.2952p pd=1.54u as=0.2132p ps=1.34u w=0.82u l=0.5u
X9 VDD a_224_552# Z VNW pfet_05v0 ad=0.3172p pd=1.74u as=0.4392p ps=1.94u w=1.22u l=0.5u
X10 VSS a_224_552# Z VPW nfet_05v0 ad=0.1892p pd=1.74u as=0.1118p ps=0.95u w=0.43u l=0.6u
X11 Z a_224_552# VDD VNW pfet_05v0 ad=0.4392p pd=1.94u as=0.3172p ps=1.74u w=1.22u l=0.5u
X12 Z a_224_552# VSS VPW nfet_05v0 ad=0.1118p pd=0.95u as=0.1118p ps=0.95u w=0.43u l=0.6u
X13 VSS a_224_552# Z VPW nfet_05v0 ad=0.1118p pd=0.95u as=0.1118p ps=0.95u w=0.43u l=0.6u
X14 Z a_224_552# VSS VPW nfet_05v0 ad=0.1118p pd=0.95u as=0.1118p ps=0.95u w=0.43u l=0.6u
X15 Z a_224_552# VDD VNW pfet_05v0 ad=0.4392p pd=1.94u as=0.3172p ps=1.74u w=1.22u l=0.5u
X16 VDD I a_224_552# VNW pfet_05v0 ad=0.367p pd=1.92u as=0.2952p ps=1.54u w=0.82u l=0.5u
X17 VDD a_224_552# Z VNW pfet_05v0 ad=0.5368p pd=3.32u as=0.4392p ps=1.94u w=1.22u l=0.5u
X18 a_224_552# I VSS VPW nfet_05v0 ad=0.1053p pd=0.925u as=0.1782p ps=1.69u w=0.405u l=0.6u
X19 Z a_224_552# VSS VPW nfet_05v0 ad=0.1118p pd=0.95u as=0.1118p ps=0.95u w=0.43u l=0.6u
X20 Z a_224_552# VDD VNW pfet_05v0 ad=0.4392p pd=1.94u as=0.367p ps=1.92u w=1.22u l=0.5u
X21 a_224_552# I VSS VPW nfet_05v0 ad=0.1782p pd=1.69u as=0.1053p ps=0.925u w=0.405u l=0.6u
X22 VSS a_224_552# Z VPW nfet_05v0 ad=0.1118p pd=0.95u as=0.1118p ps=0.95u w=0.43u l=0.6u
.ends

.subckt gf180mcu_fd_sc_mcu7t5v0__fillcap_8 VDD VSS VNW VPW
X0 VDD a_572_375# a_484_472# VNW pfet_05v0 ad=0.5368p pd=3.32u as=0.5368p ps=3.32u w=1.22u l=1u
X1 a_572_375# a_484_472# VSS VPW nfet_05v0 ad=0.3608p pd=2.52u as=0.3608p ps=2.52u w=0.82u l=1u
X2 a_124_375# a_36_472# VSS VPW nfet_05v0 ad=0.3608p pd=2.52u as=0.3608p ps=2.52u w=0.82u l=1u
X3 VDD a_124_375# a_36_472# VNW pfet_05v0 ad=0.5368p pd=3.32u as=0.5368p ps=3.32u w=1.22u l=1u
.ends

.subckt gf180mcu_fd_sc_mcu7t5v0__fillcap_64 VDD VSS VNW VPW
X0 a_4604_375# a_4516_472# VSS VPW nfet_05v0 ad=0.3608p pd=2.52u as=0.3608p ps=2.52u w=0.82u l=1u
X1 VDD a_572_375# a_484_472# VNW pfet_05v0 ad=0.5368p pd=3.32u as=0.5368p ps=3.32u w=1.22u l=1u
X2 VDD a_2364_375# a_2276_472# VNW pfet_05v0 ad=0.5368p pd=3.32u as=0.5368p ps=3.32u w=1.22u l=1u
X3 a_4156_375# a_4068_472# VSS VPW nfet_05v0 ad=0.3608p pd=2.52u as=0.3608p ps=2.52u w=0.82u l=1u
X4 a_5500_375# a_5412_472# VSS VPW nfet_05v0 ad=0.3608p pd=2.52u as=0.3608p ps=2.52u w=0.82u l=1u
X5 a_572_375# a_484_472# VSS VPW nfet_05v0 ad=0.3608p pd=2.52u as=0.3608p ps=2.52u w=0.82u l=1u
X6 VDD a_5052_375# a_4964_472# VNW pfet_05v0 ad=0.5368p pd=3.32u as=0.5368p ps=3.32u w=1.22u l=1u
X7 VDD a_6844_375# a_6756_472# VNW pfet_05v0 ad=0.5368p pd=3.32u as=0.5368p ps=3.32u w=1.22u l=1u
X8 VDD a_1916_375# a_1828_472# VNW pfet_05v0 ad=0.5368p pd=3.32u as=0.5368p ps=3.32u w=1.22u l=1u
X9 a_124_375# a_36_472# VSS VPW nfet_05v0 ad=0.3608p pd=2.52u as=0.3608p ps=2.52u w=0.82u l=1u
X10 a_5052_375# a_4964_472# VSS VPW nfet_05v0 ad=0.3608p pd=2.52u as=0.3608p ps=2.52u w=0.82u l=1u
X11 a_1916_375# a_1828_472# VSS VPW nfet_05v0 ad=0.3608p pd=2.52u as=0.3608p ps=2.52u w=0.82u l=1u
X12 VDD a_4604_375# a_4516_472# VNW pfet_05v0 ad=0.5368p pd=3.32u as=0.5368p ps=3.32u w=1.22u l=1u
X13 a_1468_375# a_1380_472# VSS VPW nfet_05v0 ad=0.3608p pd=2.52u as=0.3608p ps=2.52u w=0.82u l=1u
X14 a_2812_375# a_2724_472# VSS VPW nfet_05v0 ad=0.3608p pd=2.52u as=0.3608p ps=2.52u w=0.82u l=1u
X15 VDD a_3260_375# a_3172_472# VNW pfet_05v0 ad=0.5368p pd=3.32u as=0.5368p ps=3.32u w=1.22u l=1u
X16 a_2364_375# a_2276_472# VSS VPW nfet_05v0 ad=0.3608p pd=2.52u as=0.3608p ps=2.52u w=0.82u l=1u
X17 a_5948_375# a_5860_472# VSS VPW nfet_05v0 ad=0.3608p pd=2.52u as=0.3608p ps=2.52u w=0.82u l=1u
X18 VDD a_2812_375# a_2724_472# VNW pfet_05v0 ad=0.5368p pd=3.32u as=0.5368p ps=3.32u w=1.22u l=1u
X19 a_3260_375# a_3172_472# VSS VPW nfet_05v0 ad=0.3608p pd=2.52u as=0.3608p ps=2.52u w=0.82u l=1u
X20 VDD a_1020_375# a_932_472# VNW pfet_05v0 ad=0.5368p pd=3.32u as=0.5368p ps=3.32u w=1.22u l=1u
X21 VDD a_5500_375# a_5412_472# VNW pfet_05v0 ad=0.5368p pd=3.32u as=0.5368p ps=3.32u w=1.22u l=1u
X22 a_6844_375# a_6756_472# VSS VPW nfet_05v0 ad=0.3608p pd=2.52u as=0.3608p ps=2.52u w=0.82u l=1u
X23 a_6396_375# a_6308_472# VSS VPW nfet_05v0 ad=0.3608p pd=2.52u as=0.3608p ps=2.52u w=0.82u l=1u
X24 VDD a_6396_375# a_6308_472# VNW pfet_05v0 ad=0.5368p pd=3.32u as=0.5368p ps=3.32u w=1.22u l=1u
X25 VDD a_1468_375# a_1380_472# VNW pfet_05v0 ad=0.5368p pd=3.32u as=0.5368p ps=3.32u w=1.22u l=1u
X26 VDD a_4156_375# a_4068_472# VNW pfet_05v0 ad=0.5368p pd=3.32u as=0.5368p ps=3.32u w=1.22u l=1u
X27 VDD a_5948_375# a_5860_472# VNW pfet_05v0 ad=0.5368p pd=3.32u as=0.5368p ps=3.32u w=1.22u l=1u
X28 VDD a_124_375# a_36_472# VNW pfet_05v0 ad=0.5368p pd=3.32u as=0.5368p ps=3.32u w=1.22u l=1u
X29 a_3708_375# a_3620_472# VSS VPW nfet_05v0 ad=0.3608p pd=2.52u as=0.3608p ps=2.52u w=0.82u l=1u
X30 VDD a_3708_375# a_3620_472# VNW pfet_05v0 ad=0.5368p pd=3.32u as=0.5368p ps=3.32u w=1.22u l=1u
X31 a_1020_375# a_932_472# VSS VPW nfet_05v0 ad=0.3608p pd=2.52u as=0.3608p ps=2.52u w=0.82u l=1u
.ends

.subckt gf180mcu_fd_sc_mcu7t5v0__buf_1 VSS Z I VDD VNW VPW
X0 Z a_36_160# VSS VPW nfet_05v0 ad=0.3608p pd=2.52u as=0.2344p ps=1.56u w=0.82u l=0.6u
X1 Z a_36_160# VDD VNW pfet_05v0 ad=0.5368p pd=3.32u as=0.35315p ps=1.96u w=1.22u l=0.5u
X2 VDD I a_36_160# VNW pfet_05v0 ad=0.35315p pd=1.96u as=0.2486p ps=2.01u w=0.565u l=0.5u
X3 VSS I a_36_160# VPW nfet_05v0 ad=0.2344p pd=1.56u as=0.1584p ps=1.6u w=0.36u l=0.6u
.ends

.subckt gf180mcu_fd_sc_mcu7t5v0__dffnq_1 CLKN VDD VSS D Q VNW VPW
X0 a_474_472# a_62_124# VDD VNW pfet_05v0 ad=0.3806p pd=2.61u as=0.2249p ps=1.385u w=0.865u l=0.5u
X1 Q a_2406_24# VSS VPW nfet_05v0 ad=0.3608p pd=2.52u as=0.3608p ps=2.52u w=0.82u l=0.6u
X2 a_1993_500# a_474_472# a_1358_112# VNW pfet_05v0 ad=0.2611p pd=1.55u as=0.1522p ps=1.11u w=0.495u l=0.5u
X3 a_862_156# D VSS VPW nfet_05v0 ad=93.59999f pd=0.88u as=0.1584p ps=1.6u w=0.36u l=0.6u
X4 a_2238_185# a_62_124# a_1993_500# VNW pfet_05v0 ad=0.31075p pd=1.815u as=0.2611p ps=1.55u w=0.495u l=0.5u
X5 a_474_472# a_62_124# VSS VPW nfet_05v0 ad=0.2046p pd=1.81u as=0.1209p ps=0.985u w=0.465u l=0.6u
X6 a_1358_112# a_1070_500# VSS VPW nfet_05v0 ad=93.59999f pd=0.88u as=0.2466p ps=1.73u w=0.36u l=0.6u
X7 a_2406_24# a_1993_500# VSS VPW nfet_05v0 ad=0.2772p pd=2.14u as=0.1827p ps=1.21u w=0.63u l=0.6u
X8 VSS a_1358_112# a_1310_156# VPW nfet_05v0 ad=0.2466p pd=1.73u as=43.2f ps=0.6u w=0.36u l=0.6u
X9 a_1310_156# a_62_124# a_1070_500# VPW nfet_05v0 ad=43.2f pd=0.6u as=93.59999f ps=0.88u w=0.36u l=0.6u
X10 a_2238_185# a_474_472# a_1993_500# VPW nfet_05v0 ad=0.2106p pd=1.47u as=93.59999f ps=0.88u w=0.36u l=0.6u
X11 Q a_2406_24# VDD VNW pfet_05v0 ad=0.4972p pd=3.14u as=0.6102p ps=3.34u w=1.13u l=0.5u
X12 VSS a_2406_24# a_2238_185# VPW nfet_05v0 ad=0.1827p pd=1.21u as=0.2106p ps=1.47u w=0.63u l=0.6u
X13 VSS CLKN a_62_124# VPW nfet_05v0 ad=0.1209p pd=0.985u as=0.2046p ps=1.81u w=0.465u l=0.6u
X14 a_862_156# D VDD VNW pfet_05v0 ad=0.1287p pd=1.015u as=0.4365p ps=2.92u w=0.495u l=0.5u
X15 a_1358_112# a_1070_500# VDD VNW pfet_05v0 ad=0.1522p pd=1.11u as=0.2376p ps=1.455u w=0.495u l=0.5u
X16 a_1070_500# a_62_124# a_862_156# VNW pfet_05v0 ad=0.1621p pd=1.15u as=0.1287p ps=1.015u w=0.495u l=0.5u
X17 a_1070_500# a_474_472# a_862_156# VPW nfet_05v0 ad=93.59999f pd=0.88u as=93.59999f ps=0.88u w=0.36u l=0.6u
X18 a_1993_500# a_62_124# a_1358_112# VPW nfet_05v0 ad=93.59999f pd=0.88u as=93.59999f ps=0.88u w=0.36u l=0.6u
X19 a_1301_500# a_474_472# a_1070_500# VNW pfet_05v0 ad=95.275f pd=0.88u as=0.1621p ps=1.15u w=0.495u l=0.5u
X20 VDD a_2406_24# a_2238_185# VNW pfet_05v0 ad=0.2795p pd=1.595u as=0.31075p ps=1.815u w=1.075u l=0.5u
X21 VDD CLKN a_62_124# VNW pfet_05v0 ad=0.2249p pd=1.385u as=0.3806p ps=2.61u w=0.865u l=0.5u
X22 VDD a_1358_112# a_1301_500# VNW pfet_05v0 ad=0.2376p pd=1.455u as=95.275f ps=0.88u w=0.495u l=0.5u
X23 a_2406_24# a_1993_500# VDD VNW pfet_05v0 ad=0.473p pd=3.03u as=0.2795p ps=1.595u w=1.075u l=0.5u
.ends

.subckt gf180mcu_fd_sc_mcu7t5v0__nand2_1 VDD VSS ZN A1 A2 VNW VPW
X0 ZN A2 VDD VNW pfet_05v0 ad=0.2938p pd=1.65u as=0.4972p ps=3.14u w=1.13u l=0.5u
X1 ZN A1 a_245_68# VPW nfet_05v0 ad=0.3608p pd=2.52u as=0.1312p ps=1.14u w=0.82u l=0.6u
X2 VDD A1 ZN VNW pfet_05v0 ad=0.4972p pd=3.14u as=0.2938p ps=1.65u w=1.13u l=0.5u
X3 a_245_68# A2 VSS VPW nfet_05v0 ad=0.1312p pd=1.14u as=0.3608p ps=2.52u w=0.82u l=0.6u
.ends

.subckt gf180mcu_fd_sc_mcu7t5v0__dffnsnq_1 CLKN Q SETN VDD VSS D VNW VPW
X0 a_1308_156# a_36_124# a_1044_472# VPW nfet_05v0 ad=45.6f pd=0.62u as=98.8f ps=0.9u w=0.38u l=0.6u
X1 a_2384_156# a_36_124# a_2160_156# VNW pfet_05v0 ad=0.286p pd=2.18u as=0.21025p ps=1.35u w=0.65u l=0.5u
X2 a_2384_156# SETN VDD VNW pfet_05v0 ad=0.26825p pd=1.68u as=0.3102p ps=2.29u w=0.705u l=0.5u
X3 a_1248_472# a_448_472# a_1044_472# VNW pfet_05v0 ad=72.59999f pd=0.845u as=0.1573p ps=1.125u w=0.605u l=0.5u
X4 VDD a_3148_126# a_2384_156# VNW pfet_05v0 ad=0.2427p pd=1.435u as=0.26825p ps=1.68u w=0.58u l=0.5u
X5 VDD a_1296_336# a_1248_472# VNW pfet_05v0 ad=0.38775p pd=2.135u as=72.59999f ps=0.845u w=0.605u l=0.5u
X6 a_840_156# D VSS VPW nfet_05v0 ad=0.1178p pd=1u as=0.1672p ps=1.64u w=0.38u l=0.6u
X7 a_2384_156# a_448_472# a_2160_156# VPW nfet_05v0 ad=0.1672p pd=1.64u as=98.8f ps=0.9u w=0.38u l=0.6u
X8 a_1044_472# a_448_472# a_840_156# VPW nfet_05v0 ad=98.8f pd=0.9u as=0.1178p ps=1u w=0.38u l=0.6u
X9 VDD CLKN a_36_124# VNW pfet_05v0 ad=0.2444p pd=1.46u as=0.4136p ps=2.76u w=0.94u l=0.5u
X10 a_1296_336# SETN a_1708_156# VPW nfet_05v0 ad=98.8f pd=0.9u as=0.1026p ps=0.92u w=0.38u l=0.6u
X11 a_2160_156# a_448_472# a_1296_336# VNW pfet_05v0 ad=0.21025p pd=1.35u as=0.2354p ps=1.95u w=0.535u l=0.5u
X12 a_3148_126# a_2160_156# VSS VPW nfet_05v0 ad=0.165p pd=1.63u as=0.129p ps=1.115u w=0.375u l=0.6u
X13 a_448_472# a_36_124# VDD VNW pfet_05v0 ad=0.4136p pd=2.76u as=0.2444p ps=1.46u w=0.94u l=0.5u
X14 a_448_472# a_36_124# VSS VPW nfet_05v0 ad=0.2376p pd=1.96u as=0.1404p ps=1.06u w=0.54u l=0.6u
X15 a_3148_126# a_2160_156# VDD VNW pfet_05v0 ad=0.2882p pd=2.19u as=0.2427p ps=1.435u w=0.655u l=0.5u
X16 a_3008_145# SETN a_2384_156# VPW nfet_05v0 ad=0.1335p pd=1.135u as=0.1914p ps=1.75u w=0.435u l=0.6u
X17 a_2160_156# a_36_124# a_1296_336# VPW nfet_05v0 ad=98.8f pd=0.9u as=98.8f ps=0.9u w=0.38u l=0.6u
X18 VSS a_1296_336# a_1308_156# VPW nfet_05v0 ad=0.1064p pd=0.94u as=45.6f ps=0.62u w=0.38u l=0.6u
X19 a_1708_156# a_1044_472# VSS VPW nfet_05v0 ad=0.1026p pd=0.92u as=0.1064p ps=0.94u w=0.38u l=0.6u
X20 Q a_3148_126# VSS VPW nfet_05v0 ad=0.3586p pd=2.51u as=0.3586p ps=2.51u w=0.815u l=0.6u
X21 a_840_156# D VDD VNW pfet_05v0 ad=0.1573p pd=1.125u as=0.5199p ps=3.2u w=0.605u l=0.5u
X22 VDD SETN a_1296_336# VNW pfet_05v0 ad=0.2772p pd=2.14u as=0.23515p ps=1.615u w=0.63u l=0.5u
X23 Q a_3148_126# VDD VNW pfet_05v0 ad=0.5346p pd=3.31u as=0.5346p ps=3.31u w=1.215u l=0.5u
X24 VSS a_3148_126# a_3008_145# VPW nfet_05v0 ad=0.129p pd=1.115u as=0.1335p ps=1.135u w=0.31u l=0.6u
X25 a_1296_336# a_1044_472# VDD VNW pfet_05v0 ad=0.23515p pd=1.615u as=0.38775p ps=2.135u w=0.57u l=0.5u
X26 a_1044_472# a_36_124# a_840_156# VNW pfet_05v0 ad=0.1573p pd=1.125u as=0.1573p ps=1.125u w=0.605u l=0.5u
X27 VSS CLKN a_36_124# VPW nfet_05v0 ad=0.1404p pd=1.06u as=0.2376p ps=1.96u w=0.54u l=0.6u
.ends

.subckt gf180mcu_fd_sc_mcu7t5v0__aoi211_1 B C VDD VSS ZN A1 A2 VNW VPW
X0 ZN A2 a_37_472# VNW pfet_05v0 ad=0.3159p pd=1.735u as=0.5346p ps=3.31u w=1.215u l=0.5u
X1 VSS B ZN VPW nfet_05v0 ad=0.1209p pd=0.985u as=0.21175p ps=1.41u w=0.465u l=0.6u
X2 a_37_472# A1 ZN VNW pfet_05v0 ad=0.37665p pd=1.835u as=0.3159p ps=1.735u w=1.215u l=0.5u
X3 VDD C a_653_472# VNW pfet_05v0 ad=0.5346p pd=3.31u as=0.37665p ps=1.835u w=1.215u l=0.5u
X4 a_245_90# A2 VSS VPW nfet_05v0 ad=85.2f pd=0.95u as=0.3124p ps=2.3u w=0.71u l=0.6u
X5 ZN A1 a_245_90# VPW nfet_05v0 ad=0.21175p pd=1.41u as=85.2f ps=0.95u w=0.71u l=0.6u
X6 a_653_472# B a_37_472# VNW pfet_05v0 ad=0.37665p pd=1.835u as=0.37665p ps=1.835u w=1.215u l=0.5u
X7 ZN C VSS VPW nfet_05v0 ad=0.2046p pd=1.81u as=0.1209p ps=0.985u w=0.465u l=0.6u
.ends

.subckt gf180mcu_fd_sc_mcu7t5v0__oai22_1 A2 B1 B2 VDD VSS ZN A1 VNW VPW
X0 ZN A1 a_36_68# VPW nfet_05v0 ad=0.2132p pd=1.34u as=0.2132p ps=1.34u w=0.82u l=0.6u
X1 VSS B2 a_36_68# VPW nfet_05v0 ad=0.2132p pd=1.34u as=0.3608p ps=2.52u w=0.82u l=0.6u
X2 a_244_472# B2 VDD VNW pfet_05v0 ad=0.3782p pd=1.84u as=0.6588p ps=3.52u w=1.22u l=0.5u
X3 a_692_472# A1 ZN VNW pfet_05v0 ad=0.3172p pd=1.74u as=0.3782p ps=1.84u w=1.22u l=0.5u
X4 VDD A2 a_692_472# VNW pfet_05v0 ad=0.5368p pd=3.32u as=0.3172p ps=1.74u w=1.22u l=0.5u
X5 a_36_68# A2 ZN VPW nfet_05v0 ad=0.3608p pd=2.52u as=0.2132p ps=1.34u w=0.82u l=0.6u
X6 a_36_68# B1 VSS VPW nfet_05v0 ad=0.2132p pd=1.34u as=0.2132p ps=1.34u w=0.82u l=0.6u
X7 ZN B1 a_244_472# VNW pfet_05v0 ad=0.3782p pd=1.84u as=0.3782p ps=1.84u w=1.22u l=0.5u
.ends

.subckt gf180mcu_fd_sc_mcu7t5v0__nor4_1 A3 A4 VDD VSS ZN A1 A2 VNW VPW
X0 a_672_472# A2 a_448_472# VNW pfet_05v0 ad=0.3782p pd=1.84u as=0.3782p ps=1.84u w=1.22u l=0.5u
X1 VSS A1 ZN VPW nfet_05v0 ad=0.1584p pd=1.6u as=93.59999f ps=0.88u w=0.36u l=0.6u
X2 VSS A3 ZN VPW nfet_05v0 ad=93.59999f pd=0.88u as=93.59999f ps=0.88u w=0.36u l=0.6u
X3 a_244_472# A4 VDD VNW pfet_05v0 ad=0.3172p pd=1.74u as=0.5368p ps=3.32u w=1.22u l=0.5u
X4 a_448_472# A3 a_244_472# VNW pfet_05v0 ad=0.3782p pd=1.84u as=0.3172p ps=1.74u w=1.22u l=0.5u
X5 ZN A2 VSS VPW nfet_05v0 ad=93.59999f pd=0.88u as=93.59999f ps=0.88u w=0.36u l=0.6u
X6 ZN A4 VSS VPW nfet_05v0 ad=93.59999f pd=0.88u as=0.1584p ps=1.6u w=0.36u l=0.6u
X7 ZN A1 a_672_472# VNW pfet_05v0 ad=0.5368p pd=3.32u as=0.3782p ps=1.84u w=1.22u l=0.5u
.ends

.subckt gf180mcu_fd_sc_mcu7t5v0__dffnrnq_1 D VSS CLKN RN Q VDD VNW VPW
X0 a_1228_476# a_448_472# a_1024_476# VNW pfet_05v0 ad=0.2432p pd=1.4u as=0.1976p ps=1.28u w=0.76u l=0.5u
X1 a_1228_476# RN VDD VNW pfet_05v0 ad=0.3344p pd=2.4u as=0.3936p ps=1.88u w=0.76u l=0.5u
X2 a_1356_112# a_1024_476# VDD VNW pfet_05v0 ad=0.17927p pd=1.215u as=0.2222p ps=1.89u w=0.505u l=0.5u
X3 a_1024_476# a_448_472# a_820_476# VPW nfet_05v0 ad=0.1209p pd=1.01u as=0.1014p ps=0.91u w=0.39u l=0.6u
X4 VDD a_2682_301# a_2563_527# VNW pfet_05v0 ad=0.28255p pd=1.68u as=0.15022p ps=1.1u w=0.505u l=0.5u
X5 a_2682_301# RN VDD VNW pfet_05v0 ad=0.376p pd=1.74u as=0.28255p ps=1.68u w=0.94u l=0.5u
X6 a_1304_156# a_36_124# a_1024_476# VPW nfet_05v0 ad=50.7f pd=0.65u as=0.1209p ps=1.01u w=0.39u l=0.6u
X7 Q a_2682_301# VSS VPW nfet_05v0 ad=0.3498p pd=2.47u as=0.3498p ps=2.47u w=0.795u l=0.6u
X8 VDD a_1356_112# a_1228_476# VNW pfet_05v0 ad=0.3936p pd=1.88u as=0.2432p ps=1.4u w=0.76u l=0.5u
X9 a_2563_527# a_448_472# a_2268_156# VPW nfet_05v0 ad=0.1014p pd=0.91u as=0.20985p ps=1.475u w=0.39u l=0.6u
X10 VDD CLKN a_36_124# VNW pfet_05v0 ad=0.2249p pd=1.385u as=0.3806p ps=2.61u w=0.865u l=0.5u
X11 a_448_472# a_36_124# VDD VNW pfet_05v0 ad=0.3806p pd=2.61u as=0.2249p ps=1.385u w=0.865u l=0.5u
X12 a_2563_527# a_36_124# a_2268_156# VNW pfet_05v0 ad=0.15022p pd=1.1u as=0.1578p ps=1.13u w=0.505u l=0.5u
X13 a_820_476# D VSS VPW nfet_05v0 ad=0.1014p pd=0.91u as=0.1716p ps=1.66u w=0.39u l=0.6u
X14 a_448_472# a_36_124# VSS VPW nfet_05v0 ad=0.1782p pd=1.69u as=0.1053p ps=0.925u w=0.405u l=0.6u
X15 Q a_2682_301# VDD VNW pfet_05v0 ad=0.517p pd=3.23u as=0.517p ps=3.23u w=1.175u l=0.5u
X16 VSS RN a_1476_156# VPW nfet_05v0 ad=0.216p pd=1.51u as=46.8f ps=0.63u w=0.39u l=0.6u
X17 a_2682_301# a_2268_156# a_3030_156# VPW nfet_05v0 ad=0.176p pd=1.68u as=0.1385p ps=1.1u w=0.4u l=0.6u
X18 a_820_476# D VDD VNW pfet_05v0 ad=0.1976p pd=1.28u as=0.3344p ps=2.4u w=0.76u l=0.5u
X19 a_3030_156# RN VSS VPW nfet_05v0 ad=0.1385p pd=1.1u as=0.1014p ps=0.91u w=0.39u l=0.6u
X20 a_2268_156# a_36_124# a_1356_112# VPW nfet_05v0 ad=0.20985p pd=1.475u as=0.2079p ps=1.465u w=0.39u l=0.6u
X21 a_2268_156# a_448_472# a_1356_112# VNW pfet_05v0 ad=0.1578p pd=1.13u as=0.17927p ps=1.215u w=0.505u l=0.5u
X22 a_1476_156# a_1356_112# a_1304_156# VPW nfet_05v0 ad=46.8f pd=0.63u as=50.7f ps=0.65u w=0.39u l=0.6u
X23 a_1024_476# a_36_124# a_820_476# VNW pfet_05v0 ad=0.1976p pd=1.28u as=0.1976p ps=1.28u w=0.76u l=0.5u
X24 a_1356_112# a_1024_476# VSS VPW nfet_05v0 ad=0.2079p pd=1.465u as=0.216p ps=1.51u w=0.39u l=0.6u
X25 VDD a_2268_156# a_2682_301# VNW pfet_05v0 ad=0.4136p pd=2.76u as=0.376p ps=1.74u w=0.94u l=0.5u
X26 VSS a_2682_301# a_2563_527# VPW nfet_05v0 ad=0.1014p pd=0.91u as=0.1014p ps=0.91u w=0.39u l=0.6u
X27 VSS CLKN a_36_124# VPW nfet_05v0 ad=0.1053p pd=0.925u as=0.1782p ps=1.69u w=0.405u l=0.6u
.ends

.subckt gf180mcu_fd_sc_mcu7t5v0__clkinv_1 VDD VSS I ZN VNW VPW
X0 ZN I VSS VPW nfet_05v0 ad=0.2112p pd=1.84u as=0.2112p ps=1.84u w=0.48u l=0.6u
X1 ZN I VDD VNW pfet_05v0 ad=0.5368p pd=3.32u as=0.5368p ps=3.32u w=1.22u l=0.5u
.ends

.subckt gf180mcu_fd_sc_mcu7t5v0__nand4_1 A3 A4 VDD VSS ZN A1 A2 VNW VPW
X0 ZN A4 VDD VNW pfet_05v0 ad=0.2197p pd=1.365u as=0.3718p ps=2.57u w=0.845u l=0.5u
X1 VDD A3 ZN VNW pfet_05v0 ad=0.2197p pd=1.365u as=0.2197p ps=1.365u w=0.845u l=0.5u
X2 ZN A2 VDD VNW pfet_05v0 ad=0.2197p pd=1.365u as=0.2197p ps=1.365u w=0.845u l=0.5u
X3 VDD A1 ZN VNW pfet_05v0 ad=0.3718p pd=2.57u as=0.2197p ps=1.365u w=0.845u l=0.5u
X4 a_275_68# A4 VSS VPW nfet_05v0 ad=0.1517p pd=1.19u as=0.3608p ps=2.52u w=0.82u l=0.6u
X5 a_673_68# A2 a_469_68# VPW nfet_05v0 ad=0.1517p pd=1.19u as=0.1722p ps=1.24u w=0.82u l=0.6u
X6 a_469_68# A3 a_275_68# VPW nfet_05v0 ad=0.1722p pd=1.24u as=0.1517p ps=1.19u w=0.82u l=0.6u
X7 ZN A1 a_673_68# VPW nfet_05v0 ad=0.3608p pd=2.52u as=0.1517p ps=1.19u w=0.82u l=0.6u
.ends

.subckt gf180mcu_fd_sc_mcu7t5v0__and4_1 A3 A4 VDD VSS Z A1 A2 VNW VPW
X0 a_48_148# A1 VDD VNW pfet_05v0 ad=0.156p pd=1.12u as=0.264p ps=2.08u w=0.6u l=0.5u
X1 a_440_148# A2 a_256_148# VPW nfet_05v0 ad=88.2f pd=0.84u as=67.2f ps=0.74u w=0.42u l=0.6u
X2 Z a_48_148# VSS VPW nfet_05v0 ad=0.3586p pd=2.51u as=0.226p ps=1.515u w=0.815u l=0.6u
X3 VDD A2 a_48_148# VNW pfet_05v0 ad=0.156p pd=1.12u as=0.156p ps=1.12u w=0.6u l=0.5u
X4 Z a_48_148# VDD VNW pfet_05v0 ad=0.5368p pd=3.32u as=0.395p ps=2.02u w=1.22u l=0.5u
X5 a_644_148# A3 a_440_148# VPW nfet_05v0 ad=88.2f pd=0.84u as=88.2f ps=0.84u w=0.42u l=0.6u
X6 a_48_148# A3 VDD VNW pfet_05v0 ad=0.156p pd=1.12u as=0.156p ps=1.12u w=0.6u l=0.5u
X7 VSS A4 a_644_148# VPW nfet_05v0 ad=0.226p pd=1.515u as=88.2f ps=0.84u w=0.42u l=0.6u
X8 VDD A4 a_48_148# VNW pfet_05v0 ad=0.395p pd=2.02u as=0.156p ps=1.12u w=0.6u l=0.5u
X9 a_256_148# A1 a_48_148# VPW nfet_05v0 ad=67.2f pd=0.74u as=0.1848p ps=1.72u w=0.42u l=0.6u
.ends

.subckt gf180mcu_fd_sc_mcu7t5v0__dlyb_1 VDD I VSS Z VNW VPW
X0 a_523_68# a_47_68# VSS VPW nfet_05v0 ad=43.2f pd=0.6u as=93.59999f ps=0.88u w=0.36u l=0.6u
X1 a_671_644# a_47_68# a_523_68# VPW nfet_05v0 ad=0.369p pd=2.77u as=43.2f ps=0.6u w=0.36u l=0.6u
X2 a_503_644# a_47_68# VDD VNW pfet_05v0 ad=61.19999f pd=0.7u as=0.1116p ps=0.98u w=0.36u l=0.5u
X3 VDD a_671_644# a_1127_622# VNW pfet_05v0 ad=0.379p pd=2.37u as=61.19999f ps=0.7u w=0.36u l=0.5u
X4 VDD I a_47_68# VNW pfet_05v0 ad=0.1116p pd=0.98u as=0.3852p ps=2.86u w=0.36u l=0.5u
X5 Z a_895_68# VSS VPW nfet_05v0 ad=0.3608p pd=2.52u as=0.28262p ps=1.87u w=0.82u l=0.6u
X6 a_1147_68# a_671_644# a_895_68# VPW nfet_05v0 ad=43.8f pd=0.605u as=0.3705p ps=2.77u w=0.365u l=0.6u
X7 a_1127_622# a_671_644# a_895_68# VNW pfet_05v0 ad=61.19999f pd=0.7u as=0.3456p ps=2.64u w=0.36u l=0.5u
X8 VSS a_671_644# a_1147_68# VPW nfet_05v0 ad=0.28262p pd=1.87u as=43.8f ps=0.605u w=0.365u l=0.6u
X9 a_671_644# a_47_68# a_503_644# VNW pfet_05v0 ad=0.3852p pd=2.86u as=61.19999f ps=0.7u w=0.36u l=0.5u
X10 VSS I a_47_68# VPW nfet_05v0 ad=93.59999f pd=0.88u as=0.333p ps=2.57u w=0.36u l=0.6u
X11 Z a_895_68# VDD VNW pfet_05v0 ad=0.5368p pd=3.32u as=0.379p ps=2.37u w=1.22u l=0.5u
.ends

.subckt gf180mcu_fd_sc_mcu7t5v0__fillcap_32 VDD VSS VNW VPW
X0 VDD a_572_375# a_484_472# VNW pfet_05v0 ad=0.5368p pd=3.32u as=0.5368p ps=3.32u w=1.22u l=1u
X1 VDD a_2364_375# a_2276_472# VNW pfet_05v0 ad=0.5368p pd=3.32u as=0.5368p ps=3.32u w=1.22u l=1u
X2 a_572_375# a_484_472# VSS VPW nfet_05v0 ad=0.3608p pd=2.52u as=0.3608p ps=2.52u w=0.82u l=1u
X3 VDD a_1916_375# a_1828_472# VNW pfet_05v0 ad=0.5368p pd=3.32u as=0.5368p ps=3.32u w=1.22u l=1u
X4 a_124_375# a_36_472# VSS VPW nfet_05v0 ad=0.3608p pd=2.52u as=0.3608p ps=2.52u w=0.82u l=1u
X5 a_1916_375# a_1828_472# VSS VPW nfet_05v0 ad=0.3608p pd=2.52u as=0.3608p ps=2.52u w=0.82u l=1u
X6 a_1468_375# a_1380_472# VSS VPW nfet_05v0 ad=0.3608p pd=2.52u as=0.3608p ps=2.52u w=0.82u l=1u
X7 a_2812_375# a_2724_472# VSS VPW nfet_05v0 ad=0.3608p pd=2.52u as=0.3608p ps=2.52u w=0.82u l=1u
X8 VDD a_3260_375# a_3172_472# VNW pfet_05v0 ad=0.5368p pd=3.32u as=0.5368p ps=3.32u w=1.22u l=1u
X9 a_2364_375# a_2276_472# VSS VPW nfet_05v0 ad=0.3608p pd=2.52u as=0.3608p ps=2.52u w=0.82u l=1u
X10 VDD a_2812_375# a_2724_472# VNW pfet_05v0 ad=0.5368p pd=3.32u as=0.5368p ps=3.32u w=1.22u l=1u
X11 a_3260_375# a_3172_472# VSS VPW nfet_05v0 ad=0.3608p pd=2.52u as=0.3608p ps=2.52u w=0.82u l=1u
X12 VDD a_1020_375# a_932_472# VNW pfet_05v0 ad=0.5368p pd=3.32u as=0.5368p ps=3.32u w=1.22u l=1u
X13 VDD a_1468_375# a_1380_472# VNW pfet_05v0 ad=0.5368p pd=3.32u as=0.5368p ps=3.32u w=1.22u l=1u
X14 VDD a_124_375# a_36_472# VNW pfet_05v0 ad=0.5368p pd=3.32u as=0.5368p ps=3.32u w=1.22u l=1u
X15 a_1020_375# a_932_472# VSS VPW nfet_05v0 ad=0.3608p pd=2.52u as=0.3608p ps=2.52u w=0.82u l=1u
.ends

.subckt gf180mcu_fd_sc_mcu7t5v0__nand2_2 VDD VSS ZN A1 A2 VNW VPW
X0 a_244_68# A2 VSS VPW nfet_05v0 ad=0.1312p pd=1.14u as=0.3608p ps=2.52u w=0.82u l=0.6u
X1 ZN A1 a_244_68# VPW nfet_05v0 ad=0.2132p pd=1.34u as=0.1312p ps=1.14u w=0.82u l=0.6u
X2 ZN A2 VDD VNW pfet_05v0 ad=0.2938p pd=1.65u as=0.4972p ps=3.14u w=1.13u l=0.5u
X3 VDD A1 ZN VNW pfet_05v0 ad=0.2938p pd=1.65u as=0.2938p ps=1.65u w=1.13u l=0.5u
X4 a_652_68# A1 ZN VPW nfet_05v0 ad=0.1312p pd=1.14u as=0.2132p ps=1.34u w=0.82u l=0.6u
X5 VSS A2 a_652_68# VPW nfet_05v0 ad=0.3608p pd=2.52u as=0.1312p ps=1.14u w=0.82u l=0.6u
X6 ZN A1 VDD VNW pfet_05v0 ad=0.2938p pd=1.65u as=0.2938p ps=1.65u w=1.13u l=0.5u
X7 VDD A2 ZN VNW pfet_05v0 ad=0.4972p pd=3.14u as=0.2938p ps=1.65u w=1.13u l=0.5u
.ends

.subckt gf180mcu_fd_sc_mcu7t5v0__buf_2 VSS Z I VDD VNW VPW
X0 Z a_36_68# VDD VNW pfet_05v0 ad=0.3782p pd=1.84u as=0.4941p ps=2.03u w=1.22u l=0.5u
X1 VSS I a_36_68# VPW nfet_05v0 ad=0.2911p pd=1.53u as=0.3608p ps=2.52u w=0.82u l=0.6u
X2 Z a_36_68# VSS VPW nfet_05v0 ad=0.2132p pd=1.34u as=0.2911p ps=1.53u w=0.82u l=0.6u
X3 VDD I a_36_68# VNW pfet_05v0 ad=0.4941p pd=2.03u as=0.5368p ps=3.32u w=1.22u l=0.5u
X4 VSS a_36_68# Z VPW nfet_05v0 ad=0.3608p pd=2.52u as=0.2132p ps=1.34u w=0.82u l=0.6u
X5 VDD a_36_68# Z VNW pfet_05v0 ad=0.5368p pd=3.32u as=0.3782p ps=1.84u w=1.22u l=0.5u
.ends

.subckt gf180mcu_fd_sc_mcu7t5v0__fillcap_16 VDD VSS VNW VPW
X0 VDD a_572_375# a_484_472# VNW pfet_05v0 ad=0.5368p pd=3.32u as=0.5368p ps=3.32u w=1.22u l=1u
X1 a_572_375# a_484_472# VSS VPW nfet_05v0 ad=0.3608p pd=2.52u as=0.3608p ps=2.52u w=0.82u l=1u
X2 a_124_375# a_36_472# VSS VPW nfet_05v0 ad=0.3608p pd=2.52u as=0.3608p ps=2.52u w=0.82u l=1u
X3 a_1468_375# a_1380_472# VSS VPW nfet_05v0 ad=0.3608p pd=2.52u as=0.3608p ps=2.52u w=0.82u l=1u
X4 VDD a_1020_375# a_932_472# VNW pfet_05v0 ad=0.5368p pd=3.32u as=0.5368p ps=3.32u w=1.22u l=1u
X5 VDD a_1468_375# a_1380_472# VNW pfet_05v0 ad=0.5368p pd=3.32u as=0.5368p ps=3.32u w=1.22u l=1u
X6 VDD a_124_375# a_36_472# VNW pfet_05v0 ad=0.5368p pd=3.32u as=0.5368p ps=3.32u w=1.22u l=1u
X7 a_1020_375# a_932_472# VSS VPW nfet_05v0 ad=0.3608p pd=2.52u as=0.3608p ps=2.52u w=0.82u l=1u
.ends

.subckt gf180mcu_fd_sc_mcu7t5v0__oai21_1 VDD B A2 ZN A1 VSS VNW VPW
X0 VSS B a_36_68# VPW nfet_05v0 ad=0.3608p pd=2.52u as=0.2132p ps=1.34u w=0.82u l=0.6u
X1 ZN A2 a_36_68# VPW nfet_05v0 ad=0.2132p pd=1.34u as=0.3608p ps=2.52u w=0.82u l=0.6u
X2 VDD B ZN VNW pfet_05v0 ad=0.4972p pd=3.14u as=0.4248p ps=1.94u w=1.13u l=0.5u
X3 a_244_472# A2 VDD VNW pfet_05v0 ad=0.3172p pd=1.74u as=0.5978p ps=3.42u w=1.22u l=0.5u
X4 ZN A1 a_244_472# VNW pfet_05v0 ad=0.4248p pd=1.94u as=0.3172p ps=1.74u w=1.22u l=0.5u
X5 a_36_68# A1 ZN VPW nfet_05v0 ad=0.2132p pd=1.34u as=0.2132p ps=1.34u w=0.82u l=0.6u
.ends

.subckt gf180mcu_fd_sc_mcu7t5v0__nor3_1 A3 VDD VSS ZN A1 A2 VNW VPW
X0 ZN A1 a_448_472# VNW pfet_05v0 ad=0.5368p pd=3.32u as=0.3782p ps=1.84u w=1.22u l=0.5u
X1 ZN A1 VSS VPW nfet_05v0 ad=0.2046p pd=1.81u as=0.1209p ps=0.985u w=0.465u l=0.6u
X2 a_244_472# A3 VDD VNW pfet_05v0 ad=0.3172p pd=1.74u as=0.5368p ps=3.32u w=1.22u l=0.5u
X3 a_448_472# A2 a_244_472# VNW pfet_05v0 ad=0.3782p pd=1.84u as=0.3172p ps=1.74u w=1.22u l=0.5u
X4 VSS A2 ZN VPW nfet_05v0 ad=0.1209p pd=0.985u as=0.1209p ps=0.985u w=0.465u l=0.6u
X5 ZN A3 VSS VPW nfet_05v0 ad=0.1209p pd=0.985u as=0.2046p ps=1.81u w=0.465u l=0.6u
.ends

.subckt gf180mcu_fd_sc_mcu7t5v0__antenna VSS I VDD VNW VPW
D0 VPW I diode_nd2ps_06v0 pj=1.86u area=0.2052p
D1 I VNW diode_pd2nw_06v0 pj=1.86u area=0.2052p
.ends

.subckt gf180mcu_fd_sc_mcu7t5v0__nand3_1 A3 VDD VSS ZN A1 A2 VNW VPW
X0 ZN A1 a_455_68# VPW nfet_05v0 ad=0.3608p pd=2.52u as=0.1722p ps=1.24u w=0.82u l=0.6u
X1 ZN A3 VDD VNW pfet_05v0 ad=0.2561p pd=1.505u as=0.4334p ps=2.85u w=0.985u l=0.5u
X2 VDD A2 ZN VNW pfet_05v0 ad=0.2561p pd=1.505u as=0.2561p ps=1.505u w=0.985u l=0.5u
X3 ZN A1 VDD VNW pfet_05v0 ad=0.4334p pd=2.85u as=0.2561p ps=1.505u w=0.985u l=0.5u
X4 a_271_68# A3 VSS VPW nfet_05v0 ad=0.1312p pd=1.14u as=0.3608p ps=2.52u w=0.82u l=0.6u
X5 a_455_68# A2 a_271_68# VPW nfet_05v0 ad=0.1722p pd=1.24u as=0.1312p ps=1.14u w=0.82u l=0.6u
.ends

.subckt gf180mcu_fd_sc_mcu7t5v0__aoi21_1 B VDD VSS ZN A1 A2 VNW VPW
X0 a_244_68# A2 VSS VPW nfet_05v0 ad=0.1312p pd=1.14u as=0.3608p ps=2.52u w=0.82u l=0.6u
X1 ZN A1 a_244_68# VPW nfet_05v0 ad=0.2569p pd=1.56u as=0.1312p ps=1.14u w=0.82u l=0.6u
X2 VDD B a_36_472# VNW pfet_05v0 ad=0.5346p pd=3.31u as=0.44955p ps=1.955u w=1.215u l=0.5u
X3 ZN A2 a_36_472# VNW pfet_05v0 ad=0.3159p pd=1.735u as=0.5346p ps=3.31u w=1.215u l=0.5u
X4 a_36_472# A1 ZN VNW pfet_05v0 ad=0.44955p pd=1.955u as=0.3159p ps=1.735u w=1.215u l=0.5u
X5 VSS B ZN VPW nfet_05v0 ad=0.2244p pd=1.9u as=0.2569p ps=1.56u w=0.51u l=0.6u
.ends

.subckt gf180mcu_fd_sc_mcu7t5v0__oai211_1 B C VDD VSS ZN A1 A2 VNW VPW
X0 a_692_68# B a_36_68# VPW nfet_05v0 ad=0.2132p pd=1.34u as=0.2132p ps=1.34u w=0.82u l=0.6u
X1 ZN A2 a_36_68# VPW nfet_05v0 ad=0.2132p pd=1.34u as=0.3608p ps=2.52u w=0.82u l=0.6u
X2 a_244_472# A2 VDD VNW pfet_05v0 ad=0.3172p pd=1.74u as=0.5978p ps=3.42u w=1.22u l=0.5u
X3 VDD B ZN VNW pfet_05v0 ad=0.2561p pd=1.505u as=0.4016p ps=1.94u w=0.985u l=0.5u
X4 ZN A1 a_244_472# VNW pfet_05v0 ad=0.4016p pd=1.94u as=0.3172p ps=1.74u w=1.22u l=0.5u
X5 ZN C VDD VNW pfet_05v0 ad=0.44325p pd=2.87u as=0.2561p ps=1.505u w=0.985u l=0.5u
X6 VSS C a_692_68# VPW nfet_05v0 ad=0.3608p pd=2.52u as=0.2132p ps=1.34u w=0.82u l=0.6u
X7 a_36_68# A1 ZN VPW nfet_05v0 ad=0.2132p pd=1.34u as=0.2132p ps=1.34u w=0.82u l=0.6u
.ends

.subckt gf180mcu_fd_sc_mcu7t5v0__or2_1 VDD VSS Z A1 A2 VNW VPW
X0 a_255_603# A1 a_67_603# VNW pfet_05v0 ad=0.1469p pd=1.085u as=0.2486p ps=2.01u w=0.565u l=0.5u
X1 Z a_67_603# VSS VPW nfet_05v0 ad=0.3608p pd=2.52u as=0.2288p ps=1.58u w=0.82u l=0.6u
X2 VDD A2 a_255_603# VNW pfet_05v0 ad=0.38705p pd=2.08u as=0.1469p ps=1.085u w=0.565u l=0.5u
X3 VSS A2 a_67_603# VPW nfet_05v0 ad=0.2288p pd=1.58u as=93.59999f ps=0.88u w=0.36u l=0.6u
X4 Z a_67_603# VDD VNW pfet_05v0 ad=0.5368p pd=3.32u as=0.38705p ps=2.08u w=1.22u l=0.5u
X5 a_67_603# A1 VSS VPW nfet_05v0 ad=93.59999f pd=0.88u as=0.1584p ps=1.6u w=0.36u l=0.6u
.ends

.subckt gf180mcu_fd_sc_mcu7t5v0__and4_4 A2 A3 A4 VDD VSS Z A1 VNW VPW
X0 VDD A2 a_227_494# VNW pfet_05v0 ad=0.2886p pd=1.63u as=0.2886p ps=1.63u w=1.11u l=0.5u
X1 a_247_68# A4 VSS VPW nfet_05v0 ad=0.1032p pd=0.965u as=0.2838p ps=2.17u w=0.645u l=0.6u
X2 a_227_494# A3 VDD VNW pfet_05v0 ad=0.2886p pd=1.63u as=0.2886p ps=1.63u w=1.11u l=0.5u
X3 VDD A4 a_227_494# VNW pfet_05v0 ad=0.4105p pd=1.92u as=0.2886p ps=1.63u w=1.11u l=0.5u
X4 a_1451_68# A3 a_1247_68# VPW nfet_05v0 ad=0.13545p pd=1.065u as=0.13545p ps=1.065u w=0.645u l=0.6u
X5 Z a_227_494# VSS VPW nfet_05v0 ad=0.1677p pd=1.165u as=0.1677p ps=1.165u w=0.645u l=0.6u
X6 a_1247_68# A2 a_1063_68# VPW nfet_05v0 ad=0.13545p pd=1.065u as=0.1032p ps=0.965u w=0.645u l=0.6u
X7 a_227_494# A1 a_635_68# VPW nfet_05v0 ad=0.19832p pd=1.26u as=0.1048p ps=0.97u w=0.645u l=0.6u
X8 a_227_494# A4 VDD VNW pfet_05v0 ad=0.2886p pd=1.63u as=0.4884p ps=3.1u w=1.11u l=0.5u
X9 Z a_227_494# VSS VPW nfet_05v0 ad=0.1677p pd=1.165u as=0.1677p ps=1.165u w=0.645u l=0.6u
X10 VDD A3 a_227_494# VNW pfet_05v0 ad=0.2886p pd=1.63u as=0.2886p ps=1.63u w=1.11u l=0.5u
X11 a_1063_68# A1 a_227_494# VPW nfet_05v0 ad=0.1032p pd=0.965u as=0.19832p ps=1.26u w=0.645u l=0.6u
X12 Z a_227_494# VDD VNW pfet_05v0 ad=0.3172p pd=1.74u as=0.4105p ps=1.92u w=1.22u l=0.5u
X13 a_431_68# A3 a_247_68# VPW nfet_05v0 ad=0.13545p pd=1.065u as=0.1032p ps=0.965u w=0.645u l=0.6u
X14 VSS a_227_494# Z VPW nfet_05v0 ad=0.1677p pd=1.165u as=0.1677p ps=1.165u w=0.645u l=0.6u
X15 a_227_494# A2 VDD VNW pfet_05v0 ad=0.2886p pd=1.63u as=0.2886p ps=1.63u w=1.11u l=0.5u
X16 VDD a_227_494# Z VNW pfet_05v0 ad=0.3172p pd=1.74u as=0.3172p ps=1.74u w=1.22u l=0.5u
X17 VSS A4 a_1451_68# VPW nfet_05v0 ad=0.1677p pd=1.165u as=0.13545p ps=1.065u w=0.645u l=0.6u
X18 Z a_227_494# VDD VNW pfet_05v0 ad=0.3172p pd=1.74u as=0.3172p ps=1.74u w=1.22u l=0.5u
X19 VSS a_227_494# Z VPW nfet_05v0 ad=0.2838p pd=2.17u as=0.1677p ps=1.165u w=0.645u l=0.6u
X20 VDD A1 a_227_494# VNW pfet_05v0 ad=0.2886p pd=1.63u as=0.2886p ps=1.63u w=1.11u l=0.5u
X21 a_227_494# A1 VDD VNW pfet_05v0 ad=0.2886p pd=1.63u as=0.2886p ps=1.63u w=1.11u l=0.5u
X22 VDD a_227_494# Z VNW pfet_05v0 ad=0.5368p pd=3.32u as=0.3172p ps=1.74u w=1.22u l=0.5u
X23 a_635_68# A2 a_431_68# VPW nfet_05v0 ad=0.1048p pd=0.97u as=0.13545p ps=1.065u w=0.645u l=0.6u
.ends

.subckt gf180mcu_fd_sc_mcu7t5v0__aoi211_2 B C VDD VSS ZN A1 A2 VNW VPW
X0 VSS B ZN VPW nfet_05v0 ad=0.2266p pd=1.91u as=0.1339p ps=1.035u w=0.515u l=0.6u
X1 VSS C ZN VPW nfet_05v0 ad=0.1339p pd=1.035u as=0.1339p ps=1.035u w=0.515u l=0.6u
X2 a_244_68# A2 VSS VPW nfet_05v0 ad=93.59999f pd=1.02u as=0.3432p ps=2.44u w=0.78u l=0.6u
X3 ZN A1 a_244_68# VPW nfet_05v0 ad=0.2028p pd=1.3u as=93.59999f ps=1.02u w=0.78u l=0.6u
X4 ZN C VSS VPW nfet_05v0 ad=0.1339p pd=1.035u as=0.1339p ps=1.035u w=0.515u l=0.6u
X5 VDD C a_1044_488# VNW pfet_05v0 ad=0.3534p pd=1.76u as=0.3534p ps=1.76u w=1.14u l=0.5u
X6 ZN A1 a_36_488# VNW pfet_05v0 ad=0.2964p pd=1.66u as=0.3078p ps=1.68u w=1.14u l=0.5u
X7 ZN B VSS VPW nfet_05v0 ad=0.1339p pd=1.035u as=0.23325p ps=1.48u w=0.515u l=0.6u
X8 ZN A2 a_36_488# VNW pfet_05v0 ad=0.2964p pd=1.66u as=0.5016p ps=3.16u w=1.14u l=0.5u
X9 a_36_488# A2 ZN VNW pfet_05v0 ad=0.2964p pd=1.66u as=0.2964p ps=1.66u w=1.14u l=0.5u
X10 a_1044_488# B a_36_488# VNW pfet_05v0 ad=0.3534p pd=1.76u as=0.2964p ps=1.66u w=1.14u l=0.5u
X11 a_36_488# A1 ZN VNW pfet_05v0 ad=0.3078p pd=1.68u as=0.2964p ps=1.66u w=1.14u l=0.5u
X12 a_36_488# B a_1492_488# VNW pfet_05v0 ad=0.5016p pd=3.16u as=0.3534p ps=1.76u w=1.14u l=0.5u
X13 a_636_68# A1 ZN VPW nfet_05v0 ad=93.59999f pd=1.02u as=0.2028p ps=1.3u w=0.78u l=0.6u
X14 a_1492_488# C VDD VNW pfet_05v0 ad=0.3534p pd=1.76u as=0.3534p ps=1.76u w=1.14u l=0.5u
X15 VSS A2 a_636_68# VPW nfet_05v0 ad=0.23325p pd=1.48u as=93.59999f ps=1.02u w=0.78u l=0.6u
.ends

.subckt gf180mcu_fd_sc_mcu7t5v0__oai31_2 A2 A3 B VDD VSS ZN A1 VNW VPW
X0 VDD A3 a_1612_497# VNW pfet_05v0 ad=0.4818p pd=3.07u as=0.4599p ps=1.935u w=1.095u l=0.5u
X1 a_960_497# A2 a_692_497# VNW pfet_05v0 ad=0.33945p pd=1.715u as=0.4599p ps=1.935u w=1.095u l=0.5u
X2 ZN A3 a_36_68# VPW nfet_05v0 ad=0.30965p pd=1.685u as=0.2132p ps=1.34u w=0.82u l=0.6u
X3 VSS B a_36_68# VPW nfet_05v0 ad=0.2132p pd=1.34u as=0.3608p ps=2.52u w=0.82u l=0.6u
X4 a_36_68# A3 ZN VPW nfet_05v0 ad=0.3608p pd=2.52u as=0.30965p ps=1.685u w=0.82u l=0.6u
X5 a_36_68# A2 ZN VPW nfet_05v0 ad=0.2132p pd=1.34u as=0.30965p ps=1.685u w=0.82u l=0.6u
X6 ZN B VDD VNW pfet_05v0 ad=0.2808p pd=1.6u as=0.5292p ps=3.14u w=1.08u l=0.5u
X7 a_36_68# A1 ZN VPW nfet_05v0 ad=0.2132p pd=1.34u as=0.2132p ps=1.34u w=0.82u l=0.6u
X8 a_692_497# A3 VDD VNW pfet_05v0 ad=0.4599p pd=1.935u as=0.3918p ps=1.815u w=1.095u l=0.5u
X9 VDD B ZN VNW pfet_05v0 ad=0.3918p pd=1.815u as=0.2808p ps=1.6u w=1.08u l=0.5u
X10 a_1612_497# A2 a_1388_497# VNW pfet_05v0 ad=0.4599p pd=1.935u as=0.33945p ps=1.715u w=1.095u l=0.5u
X11 ZN A2 a_36_68# VPW nfet_05v0 ad=0.30965p pd=1.685u as=0.2132p ps=1.34u w=0.82u l=0.6u
X12 ZN A1 a_960_497# VNW pfet_05v0 ad=0.2847p pd=1.615u as=0.33945p ps=1.715u w=1.095u l=0.5u
X13 a_36_68# B VSS VPW nfet_05v0 ad=0.2132p pd=1.34u as=0.2132p ps=1.34u w=0.82u l=0.6u
X14 ZN A1 a_36_68# VPW nfet_05v0 ad=0.2132p pd=1.34u as=0.2132p ps=1.34u w=0.82u l=0.6u
X15 a_1388_497# A1 ZN VNW pfet_05v0 ad=0.33945p pd=1.715u as=0.2847p ps=1.615u w=1.095u l=0.5u
.ends

.subckt gf180mcu_fd_sc_mcu7t5v0__nand4_2 A3 A4 VDD VSS ZN A1 A2 VNW VPW
X0 a_1458_68# A3 a_1254_68# VPW nfet_05v0 ad=0.1517p pd=1.19u as=0.1722p ps=1.24u w=0.82u l=0.6u
X1 a_632_68# A2 a_438_68# VPW nfet_05v0 ad=0.1722p pd=1.24u as=0.1517p ps=1.19u w=0.82u l=0.6u
X2 VDD A4 ZN VNW pfet_05v0 ad=0.2197p pd=1.365u as=0.3718p ps=2.57u w=0.845u l=0.5u
X3 a_244_68# A4 VSS VPW nfet_05v0 ad=0.1517p pd=1.19u as=0.3608p ps=2.52u w=0.82u l=0.6u
X4 ZN A3 VDD VNW pfet_05v0 ad=0.2197p pd=1.365u as=0.2197p ps=1.365u w=0.845u l=0.5u
X5 a_438_68# A3 a_244_68# VPW nfet_05v0 ad=0.1517p pd=1.19u as=0.1517p ps=1.19u w=0.82u l=0.6u
X6 VDD A2 ZN VNW pfet_05v0 ad=0.2197p pd=1.365u as=0.2197p ps=1.365u w=0.845u l=0.5u
X7 ZN A1 a_632_68# VPW nfet_05v0 ad=0.2132p pd=1.34u as=0.1722p ps=1.24u w=0.82u l=0.6u
X8 ZN A1 VDD VNW pfet_05v0 ad=0.2197p pd=1.365u as=0.2197p ps=1.365u w=0.845u l=0.5u
X9 VDD A1 ZN VNW pfet_05v0 ad=0.2197p pd=1.365u as=0.2197p ps=1.365u w=0.845u l=0.5u
X10 a_1060_68# A1 ZN VPW nfet_05v0 ad=0.1517p pd=1.19u as=0.2132p ps=1.34u w=0.82u l=0.6u
X11 a_1254_68# A2 a_1060_68# VPW nfet_05v0 ad=0.1722p pd=1.24u as=0.1517p ps=1.19u w=0.82u l=0.6u
X12 ZN A2 VDD VNW pfet_05v0 ad=0.2197p pd=1.365u as=0.2197p ps=1.365u w=0.845u l=0.5u
X13 VSS A4 a_1458_68# VPW nfet_05v0 ad=0.3608p pd=2.52u as=0.1517p ps=1.19u w=0.82u l=0.6u
X14 VDD A3 ZN VNW pfet_05v0 ad=0.2197p pd=1.365u as=0.2197p ps=1.365u w=0.845u l=0.5u
X15 ZN A4 VDD VNW pfet_05v0 ad=0.3718p pd=2.57u as=0.2197p ps=1.365u w=0.845u l=0.5u
.ends

.subckt gf180mcu_fd_sc_mcu7t5v0__aoi22_2 B1 B2 VDD VSS ZN A1 A2 VNW VPW
X0 VDD B1 a_36_472# VNW pfet_05v0 ad=0.3159p pd=1.735u as=0.3159p ps=1.735u w=1.215u l=0.5u
X1 VSS A2 a_1468_69# VPW nfet_05v0 ad=0.3586p pd=2.51u as=0.1304p ps=1.135u w=0.815u l=0.6u
X2 a_36_472# B2 VDD VNW pfet_05v0 ad=0.3159p pd=1.735u as=0.3159p ps=1.735u w=1.215u l=0.5u
X3 ZN A2 a_36_472# VNW pfet_05v0 ad=0.3159p pd=1.735u as=0.3159p ps=1.735u w=1.215u l=0.5u
X4 a_36_472# A1 ZN VNW pfet_05v0 ad=0.3159p pd=1.735u as=0.3159p ps=1.735u w=1.215u l=0.5u
X5 ZN B1 a_244_69# VPW nfet_05v0 ad=0.22615p pd=1.37u as=0.1304p ps=1.135u w=0.815u l=0.6u
X6 a_659_69# B1 ZN VPW nfet_05v0 ad=0.11612p pd=1.1u as=0.22615p ps=1.37u w=0.815u l=0.6u
X7 a_244_69# B2 VSS VPW nfet_05v0 ad=0.1304p pd=1.135u as=0.3586p ps=2.51u w=0.815u l=0.6u
X8 ZN A1 a_36_472# VNW pfet_05v0 ad=0.3159p pd=1.735u as=0.3159p ps=1.735u w=1.215u l=0.5u
X9 a_1468_69# A1 ZN VPW nfet_05v0 ad=0.1304p pd=1.135u as=0.2119p ps=1.335u w=0.815u l=0.6u
X10 a_36_472# A2 ZN VNW pfet_05v0 ad=0.5346p pd=3.31u as=0.3159p ps=1.735u w=1.215u l=0.5u
X11 VSS B2 a_659_69# VPW nfet_05v0 ad=0.2119p pd=1.335u as=0.11612p ps=1.1u w=0.815u l=0.6u
X12 VDD B2 a_36_472# VNW pfet_05v0 ad=0.3159p pd=1.735u as=0.5346p ps=3.31u w=1.215u l=0.5u
X13 ZN A1 a_1060_69# VPW nfet_05v0 ad=0.2119p pd=1.335u as=0.1304p ps=1.135u w=0.815u l=0.6u
X14 a_36_472# B1 VDD VNW pfet_05v0 ad=0.3159p pd=1.735u as=0.3159p ps=1.735u w=1.215u l=0.5u
X15 a_1060_69# A2 VSS VPW nfet_05v0 ad=0.1304p pd=1.135u as=0.2119p ps=1.335u w=0.815u l=0.6u
.ends

.subckt gf180mcu_fd_sc_mcu7t5v0__or3_2 A3 VDD VSS Z A1 A2 VNW VPW
X0 VDD A3 a_448_472# VNW pfet_05v0 ad=0.488p pd=2.02u as=0.3782p ps=1.84u w=1.22u l=0.5u
X1 VSS A3 a_36_68# VPW nfet_05v0 ad=0.26375p pd=1.52u as=0.1729p ps=1.185u w=0.665u l=0.6u
X2 Z a_36_68# VDD VNW pfet_05v0 ad=0.3782p pd=1.84u as=0.488p ps=2.02u w=1.22u l=0.5u
X3 VSS A1 a_36_68# VPW nfet_05v0 ad=0.1729p pd=1.185u as=0.2926p ps=2.21u w=0.665u l=0.6u
X4 VSS a_36_68# Z VPW nfet_05v0 ad=0.3608p pd=2.52u as=0.2132p ps=1.34u w=0.82u l=0.6u
X5 a_244_472# A1 a_36_68# VNW pfet_05v0 ad=0.3172p pd=1.74u as=0.5368p ps=3.32u w=1.22u l=0.5u
X6 a_448_472# A2 a_244_472# VNW pfet_05v0 ad=0.3782p pd=1.84u as=0.3172p ps=1.74u w=1.22u l=0.5u
X7 Z a_36_68# VSS VPW nfet_05v0 ad=0.2132p pd=1.34u as=0.26375p ps=1.52u w=0.82u l=0.6u
X8 VDD a_36_68# Z VNW pfet_05v0 ad=0.5368p pd=3.32u as=0.3782p ps=1.84u w=1.22u l=0.5u
X9 a_36_68# A2 VSS VPW nfet_05v0 ad=0.1729p pd=1.185u as=0.1729p ps=1.185u w=0.665u l=0.6u
.ends

.subckt gf180mcu_fd_sc_mcu7t5v0__dffrnq_2 D Q RN VDD VSS CLK VNW VPW
X0 VSS CLK a_36_151# VPW nfet_05v0 ad=0.1053p pd=0.925u as=0.1782p ps=1.69u w=0.405u l=0.6u
X1 Q a_2665_112# VDD VNW pfet_05v0 ad=0.3159p pd=1.735u as=0.5346p ps=3.31u w=1.215u l=0.5u
X2 VSS RN a_1456_156# VPW nfet_05v0 ad=0.2016p pd=1.48u as=43.2f ps=0.6u w=0.36u l=0.6u
X3 VDD a_2665_112# Q VNW pfet_05v0 ad=0.5346p pd=3.31u as=0.3159p ps=1.735u w=1.215u l=0.5u
X4 a_796_472# D VSS VPW nfet_05v0 ad=93.59999f pd=0.88u as=0.1584p ps=1.6u w=0.36u l=0.6u
X5 VSS a_2665_112# a_2560_156# VPW nfet_05v0 ad=0.1224p pd=1.04u as=94.5f ps=0.885u w=0.36u l=0.6u
X6 a_1000_472# a_448_472# a_796_472# VNW pfet_05v0 ad=0.2028p pd=1.3u as=0.2028p ps=1.3u w=0.78u l=0.5u
X7 a_2248_156# a_36_151# a_1308_423# VNW pfet_05v0 ad=0.25375p pd=1.51u as=0.2424p ps=1.465u w=0.505u l=0.5u
X8 a_2248_156# a_448_472# a_1308_423# VPW nfet_05v0 ad=0.2007p pd=1.475u as=0.2007p ps=1.475u w=0.36u l=0.6u
X9 VDD CLK a_36_151# VNW pfet_05v0 ad=0.2249p pd=1.385u as=0.3806p ps=2.61u w=0.865u l=0.5u
X10 a_1456_156# a_1308_423# a_1288_156# VPW nfet_05v0 ad=43.2f pd=0.6u as=43.2f ps=0.6u w=0.36u l=0.6u
X11 a_1308_423# a_1000_472# VSS VPW nfet_05v0 ad=0.2007p pd=1.475u as=0.2016p ps=1.48u w=0.36u l=0.6u
X12 Q a_2665_112# VSS VPW nfet_05v0 ad=0.2119p pd=1.335u as=0.3586p ps=2.51u w=0.815u l=0.6u
X13 a_2665_112# a_2248_156# a_3041_156# VPW nfet_05v0 ad=0.3586p pd=2.51u as=0.217p ps=1.515u w=0.815u l=0.6u
X14 a_448_472# a_36_151# VDD VNW pfet_05v0 ad=0.3806p pd=2.61u as=0.2249p ps=1.385u w=0.865u l=0.5u
X15 a_1204_472# a_36_151# a_1000_472# VNW pfet_05v0 ad=0.2028p pd=1.3u as=0.2028p ps=1.3u w=0.78u l=0.5u
X16 a_1204_472# RN VDD VNW pfet_05v0 ad=0.3432p pd=2.44u as=0.45p ps=2.02u w=0.78u l=0.5u
X17 a_2560_156# a_36_151# a_2248_156# VPW nfet_05v0 ad=94.5f pd=0.885u as=0.2007p ps=1.475u w=0.36u l=0.6u
X18 a_1288_156# a_448_472# a_1000_472# VPW nfet_05v0 ad=43.2f pd=0.6u as=93.59999f ps=0.88u w=0.36u l=0.6u
X19 a_2665_112# RN VDD VNW pfet_05v0 ad=0.3159p pd=1.735u as=0.33755p ps=1.955u w=1.215u l=0.5u
X20 VDD a_1308_423# a_1204_472# VNW pfet_05v0 ad=0.45p pd=2.02u as=0.2028p ps=1.3u w=0.78u l=0.5u
X21 a_2560_156# a_448_472# a_2248_156# VNW pfet_05v0 ad=0.1313p pd=1.025u as=0.25375p ps=1.51u w=0.505u l=0.5u
X22 a_448_472# a_36_151# VSS VPW nfet_05v0 ad=0.1782p pd=1.69u as=0.1053p ps=0.925u w=0.405u l=0.6u
X23 VDD a_2248_156# a_2665_112# VNW pfet_05v0 ad=0.5346p pd=3.31u as=0.3159p ps=1.735u w=1.215u l=0.5u
X24 a_3041_156# RN VSS VPW nfet_05v0 ad=0.217p pd=1.515u as=0.1224p ps=1.04u w=0.36u l=0.6u
X25 VSS a_2665_112# Q VPW nfet_05v0 ad=0.3586p pd=2.51u as=0.2119p ps=1.335u w=0.815u l=0.6u
X26 VDD a_2665_112# a_2560_156# VNW pfet_05v0 ad=0.33755p pd=1.955u as=0.1313p ps=1.025u w=0.505u l=0.5u
X27 a_1308_423# a_1000_472# VDD VNW pfet_05v0 ad=0.2424p pd=1.465u as=0.2222p ps=1.89u w=0.505u l=0.5u
X28 a_1000_472# a_36_151# a_796_472# VPW nfet_05v0 ad=93.59999f pd=0.88u as=93.59999f ps=0.88u w=0.36u l=0.6u
X29 a_796_472# D VDD VNW pfet_05v0 ad=0.2028p pd=1.3u as=0.3432p ps=2.44u w=0.78u l=0.5u
.ends

.subckt gf180mcu_fd_sc_mcu7t5v0__clkbuf_16 VDD VSS Z I VNW VPW
X0 VSS I a_224_552# VPW nfet_05v0 ad=0.1053p pd=0.925u as=0.1053p ps=0.925u w=0.405u l=0.6u
X1 VSS a_224_552# Z VPW nfet_05v0 ad=0.1261p pd=1.005u as=0.1261p ps=1.005u w=0.485u l=0.6u
X2 a_224_552# I VDD VNW pfet_05v0 ad=0.2542p pd=1.44u as=0.2542p ps=1.44u w=0.82u l=0.5u
X3 Z a_224_552# VDD VNW pfet_05v0 ad=0.3782p pd=1.84u as=0.3782p ps=1.84u w=1.22u l=0.5u
X4 Z a_224_552# VSS VPW nfet_05v0 ad=0.1261p pd=1.005u as=0.1261p ps=1.005u w=0.485u l=0.6u
X5 VDD a_224_552# Z VNW pfet_05v0 ad=0.3782p pd=1.84u as=0.3782p ps=1.84u w=1.22u l=0.5u
X6 VDD a_224_552# Z VNW pfet_05v0 ad=0.3782p pd=1.84u as=0.3782p ps=1.84u w=1.22u l=0.5u
X7 Z a_224_552# VDD VNW pfet_05v0 ad=0.3782p pd=1.84u as=0.3782p ps=1.84u w=1.22u l=0.5u
X8 a_224_552# I VDD VNW pfet_05v0 ad=0.2542p pd=1.44u as=0.3608p ps=2.52u w=0.82u l=0.5u
X9 VDD a_224_552# Z VNW pfet_05v0 ad=0.3782p pd=1.84u as=0.3782p ps=1.84u w=1.22u l=0.5u
X10 Z a_224_552# VSS VPW nfet_05v0 ad=0.1261p pd=1.005u as=0.1261p ps=1.005u w=0.485u l=0.6u
X11 VSS a_224_552# Z VPW nfet_05v0 ad=0.1261p pd=1.005u as=0.1261p ps=1.005u w=0.485u l=0.6u
X12 VSS a_224_552# Z VPW nfet_05v0 ad=0.1261p pd=1.005u as=0.1261p ps=1.005u w=0.485u l=0.6u
X13 VDD a_224_552# Z VNW pfet_05v0 ad=0.5368p pd=3.32u as=0.3782p ps=1.84u w=1.22u l=0.5u
X14 Z a_224_552# VSS VPW nfet_05v0 ad=0.1261p pd=1.005u as=0.1261p ps=1.005u w=0.485u l=0.6u
X15 VSS I a_224_552# VPW nfet_05v0 ad=0.1053p pd=0.925u as=0.1782p ps=1.69u w=0.405u l=0.6u
X16 a_224_552# I VDD VNW pfet_05v0 ad=0.2542p pd=1.44u as=0.2542p ps=1.44u w=0.82u l=0.5u
X17 a_224_552# I VSS VPW nfet_05v0 ad=0.1053p pd=0.925u as=0.1053p ps=0.925u w=0.405u l=0.6u
X18 VSS a_224_552# Z VPW nfet_05v0 ad=0.1261p pd=1.005u as=0.1261p ps=1.005u w=0.485u l=0.6u
X19 Z a_224_552# VDD VNW pfet_05v0 ad=0.3782p pd=1.84u as=0.428p ps=2.02u w=1.22u l=0.5u
X20 VDD I a_224_552# VNW pfet_05v0 ad=0.2542p pd=1.44u as=0.2542p ps=1.44u w=0.82u l=0.5u
X21 Z a_224_552# VDD VNW pfet_05v0 ad=0.3782p pd=1.84u as=0.3782p ps=1.84u w=1.22u l=0.5u
X22 Z a_224_552# VDD VNW pfet_05v0 ad=0.3782p pd=1.84u as=0.3782p ps=1.84u w=1.22u l=0.5u
X23 VSS I a_224_552# VPW nfet_05v0 ad=0.1053p pd=0.925u as=0.1053p ps=0.925u w=0.405u l=0.6u
X24 VDD a_224_552# Z VNW pfet_05v0 ad=0.3782p pd=1.84u as=0.3782p ps=1.84u w=1.22u l=0.5u
X25 Z a_224_552# VSS VPW nfet_05v0 ad=0.1261p pd=1.005u as=0.1261p ps=1.005u w=0.485u l=0.6u
X26 VSS a_224_552# Z VPW nfet_05v0 ad=0.1261p pd=1.005u as=0.1261p ps=1.005u w=0.485u l=0.6u
X27 VSS a_224_552# Z VPW nfet_05v0 ad=0.1261p pd=1.005u as=0.1261p ps=1.005u w=0.485u l=0.6u
X28 VDD I a_224_552# VNW pfet_05v0 ad=0.428p pd=2.02u as=0.2542p ps=1.44u w=0.82u l=0.5u
X29 Z a_224_552# VDD VNW pfet_05v0 ad=0.3782p pd=1.84u as=0.3782p ps=1.84u w=1.22u l=0.5u
X30 a_224_552# I VSS VPW nfet_05v0 ad=0.1782p pd=1.69u as=0.1053p ps=0.925u w=0.405u l=0.6u
X31 Z a_224_552# VSS VPW nfet_05v0 ad=0.1261p pd=1.005u as=0.1261p ps=1.005u w=0.485u l=0.6u
X32 VSS a_224_552# Z VPW nfet_05v0 ad=0.1261p pd=1.005u as=0.1261p ps=1.005u w=0.485u l=0.6u
X33 Z a_224_552# VDD VNW pfet_05v0 ad=0.3782p pd=1.84u as=0.3782p ps=1.84u w=1.22u l=0.5u
X34 VSS a_224_552# Z VPW nfet_05v0 ad=0.2134p pd=1.85u as=0.1261p ps=1.005u w=0.485u l=0.6u
X35 VDD I a_224_552# VNW pfet_05v0 ad=0.2542p pd=1.44u as=0.2542p ps=1.44u w=0.82u l=0.5u
X36 VDD a_224_552# Z VNW pfet_05v0 ad=0.3782p pd=1.84u as=0.3782p ps=1.84u w=1.22u l=0.5u
X37 VDD a_224_552# Z VNW pfet_05v0 ad=0.3782p pd=1.84u as=0.3782p ps=1.84u w=1.22u l=0.5u
X38 Z a_224_552# VDD VNW pfet_05v0 ad=0.3782p pd=1.84u as=0.3782p ps=1.84u w=1.22u l=0.5u
X39 a_224_552# I VDD VNW pfet_05v0 ad=0.2542p pd=1.44u as=0.2542p ps=1.44u w=0.82u l=0.5u
X40 a_224_552# I VSS VPW nfet_05v0 ad=0.1053p pd=0.925u as=0.1053p ps=0.925u w=0.405u l=0.6u
X41 Z a_224_552# VSS VPW nfet_05v0 ad=0.1261p pd=1.005u as=0.2134p ps=1.85u w=0.485u l=0.6u
X42 VDD I a_224_552# VNW pfet_05v0 ad=0.2542p pd=1.44u as=0.2542p ps=1.44u w=0.82u l=0.5u
X43 VDD a_224_552# Z VNW pfet_05v0 ad=0.3782p pd=1.84u as=0.3782p ps=1.84u w=1.22u l=0.5u
X44 Z a_224_552# VSS VPW nfet_05v0 ad=0.1261p pd=1.005u as=0.1261p ps=1.005u w=0.485u l=0.6u
X45 Z a_224_552# VSS VPW nfet_05v0 ad=0.1261p pd=1.005u as=0.1261p ps=1.005u w=0.485u l=0.6u
.ends

.subckt gf180mcu_fd_sc_mcu7t5v0__nor2_1 VDD VSS ZN A1 A2 VNW VPW
X0 ZN A1 a_224_472# VNW pfet_05v0 ad=0.5368p pd=3.32u as=0.4087p ps=1.89u w=1.22u l=0.5u
X1 VSS A1 ZN VPW nfet_05v0 ad=0.2486p pd=2.01u as=0.1469p ps=1.085u w=0.565u l=0.6u
X2 a_224_472# A2 VDD VNW pfet_05v0 ad=0.4087p pd=1.89u as=0.5368p ps=3.32u w=1.22u l=0.5u
X3 ZN A2 VSS VPW nfet_05v0 ad=0.1469p pd=1.085u as=0.2486p ps=2.01u w=0.565u l=0.6u
.ends

.subckt gf180mcu_fd_sc_mcu7t5v0__and2_1 VDD VSS Z A1 A2 VNW VPW
X0 VDD A2 a_36_159# VNW pfet_05v0 ad=0.40575p pd=2.055u as=0.156p ps=1.12u w=0.6u l=0.5u
X1 Z a_36_159# VDD VNW pfet_05v0 ad=0.5346p pd=3.31u as=0.40575p ps=2.055u w=1.215u l=0.5u
X2 Z a_36_159# VSS VPW nfet_05v0 ad=0.3586p pd=2.51u as=0.23405p ps=1.555u w=0.815u l=0.6u
X3 VSS A2 a_244_159# VPW nfet_05v0 ad=0.23405p pd=1.555u as=58.39999f ps=0.685u w=0.365u l=0.6u
X4 a_244_159# A1 a_36_159# VPW nfet_05v0 ad=58.39999f pd=0.685u as=0.1606p ps=1.61u w=0.365u l=0.6u
X5 a_36_159# A1 VDD VNW pfet_05v0 ad=0.156p pd=1.12u as=0.264p ps=2.08u w=0.6u l=0.5u
.ends

.subckt gf180mcu_fd_sc_mcu7t5v0__aoi221_1 B2 C VDD VSS ZN A1 A2 B1 VNW VPW
X0 a_672_472# C a_56_472# VNW pfet_05v0 ad=0.3402p pd=1.775u as=0.37665p ps=1.835u w=1.215u l=0.5u
X1 VDD B2 a_56_472# VNW pfet_05v0 ad=0.3159p pd=1.735u as=0.5346p ps=3.31u w=1.215u l=0.5u
X2 ZN A1 a_940_90# VPW nfet_05v0 ad=0.3124p pd=2.3u as=85.2f ps=0.95u w=0.71u l=0.6u
X3 a_56_472# B1 VDD VNW pfet_05v0 ad=0.37665p pd=1.835u as=0.3159p ps=1.735u w=1.215u l=0.5u
X4 a_672_472# A1 ZN VNW pfet_05v0 ad=0.5346p pd=3.31u as=0.37665p ps=1.835u w=1.215u l=0.5u
X5 ZN A2 a_672_472# VNW pfet_05v0 ad=0.37665p pd=1.835u as=0.3402p ps=1.775u w=1.215u l=0.5u
X6 a_244_90# B2 VSS VPW nfet_05v0 ad=85.2f pd=0.95u as=0.3124p ps=2.3u w=0.71u l=0.6u
X7 ZN B1 a_244_90# VPW nfet_05v0 ad=0.21175p pd=1.41u as=85.2f ps=0.95u w=0.71u l=0.6u
X8 a_940_90# A2 VSS VPW nfet_05v0 ad=85.2f pd=0.95u as=0.22595p ps=1.45u w=0.71u l=0.6u
X9 VSS C ZN VPW nfet_05v0 ad=0.22595p pd=1.45u as=0.21175p ps=1.41u w=0.465u l=0.6u
.ends

.subckt gf180mcu_fd_sc_mcu7t5v0__oai32_1 A3 B1 B2 VDD VSS ZN A1 A2 VNW VPW
X0 ZN A1 a_468_472# VNW pfet_05v0 ad=0.4392p pd=1.94u as=0.3172p ps=1.74u w=1.22u l=0.5u
X1 a_244_68# A1 VSS VPW nfet_05v0 ad=0.2132p pd=1.34u as=0.2132p ps=1.34u w=0.82u l=0.6u
X2 a_244_68# A3 VSS VPW nfet_05v0 ad=0.2132p pd=1.34u as=0.3608p ps=2.52u w=0.82u l=0.6u
X3 a_916_472# B1 ZN VNW pfet_05v0 ad=0.3172p pd=1.74u as=0.4392p ps=1.94u w=1.22u l=0.5u
X4 VDD B2 a_916_472# VNW pfet_05v0 ad=0.5368p pd=3.32u as=0.3172p ps=1.74u w=1.22u l=0.5u
X5 ZN B1 a_244_68# VPW nfet_05v0 ad=0.2132p pd=1.34u as=0.2132p ps=1.34u w=0.82u l=0.6u
X6 a_224_472# A3 VDD VNW pfet_05v0 ad=0.4392p pd=1.94u as=0.5368p ps=3.32u w=1.22u l=0.5u
X7 VSS A2 a_244_68# VPW nfet_05v0 ad=0.2132p pd=1.34u as=0.2132p ps=1.34u w=0.82u l=0.6u
X8 a_244_68# B2 ZN VPW nfet_05v0 ad=0.3608p pd=2.52u as=0.2132p ps=1.34u w=0.82u l=0.6u
X9 a_468_472# A2 a_224_472# VNW pfet_05v0 ad=0.3172p pd=1.74u as=0.4392p ps=1.94u w=1.22u l=0.5u
.ends

.subckt gf180mcu_fd_sc_mcu7t5v0__nor3_4 A3 VDD VSS ZN A1 A2 VNW VPW
X0 a_672_472# A3 VDD VNW pfet_05v0 ad=0.3782p pd=1.84u as=0.3782p ps=1.84u w=1.22u l=0.5u
X1 ZN A1 a_36_472# VNW pfet_05v0 ad=0.3782p pd=1.84u as=0.3782p ps=1.84u w=1.22u l=0.5u
X2 ZN A1 VSS VPW nfet_05v0 ad=0.1209p pd=0.985u as=0.1209p ps=0.985u w=0.465u l=0.6u
X3 VDD A3 a_1120_472# VNW pfet_05v0 ad=0.3782p pd=1.84u as=0.3782p ps=1.84u w=1.22u l=0.5u
X4 ZN A1 a_1792_472# VNW pfet_05v0 ad=0.3782p pd=1.84u as=0.3782p ps=1.84u w=1.22u l=0.5u
X5 VSS A2 ZN VPW nfet_05v0 ad=0.1209p pd=0.985u as=0.1209p ps=0.985u w=0.465u l=0.6u
X6 VSS A3 ZN VPW nfet_05v0 ad=0.1209p pd=0.985u as=0.1209p ps=0.985u w=0.465u l=0.6u
X7 a_1792_472# A2 a_1568_472# VNW pfet_05v0 ad=0.3782p pd=1.84u as=0.3782p ps=1.84u w=1.22u l=0.5u
X8 VSS A1 ZN VPW nfet_05v0 ad=0.1209p pd=0.985u as=0.1209p ps=0.985u w=0.465u l=0.6u
X9 VDD A3 a_224_472# VNW pfet_05v0 ad=0.3782p pd=1.84u as=0.3782p ps=1.84u w=1.22u l=0.5u
X10 VSS A2 ZN VPW nfet_05v0 ad=0.1209p pd=0.985u as=0.1209p ps=0.985u w=0.465u l=0.6u
X11 a_36_472# A1 ZN VNW pfet_05v0 ad=0.3782p pd=1.84u as=0.3782p ps=1.84u w=1.22u l=0.5u
X12 VSS A3 ZN VPW nfet_05v0 ad=0.1209p pd=0.985u as=0.1209p ps=0.985u w=0.465u l=0.6u
X13 a_1120_472# A2 a_36_472# VNW pfet_05v0 ad=0.3782p pd=1.84u as=0.3782p ps=1.84u w=1.22u l=0.5u
X14 ZN A2 VSS VPW nfet_05v0 ad=0.1209p pd=0.985u as=0.1209p ps=0.985u w=0.465u l=0.6u
X15 a_36_472# A2 a_672_472# VNW pfet_05v0 ad=0.3782p pd=1.84u as=0.3782p ps=1.84u w=1.22u l=0.5u
X16 a_36_472# A1 ZN VNW pfet_05v0 ad=0.5368p pd=3.32u as=0.3782p ps=1.84u w=1.22u l=0.5u
X17 a_1568_472# A3 VDD VNW pfet_05v0 ad=0.3782p pd=1.84u as=0.3782p ps=1.84u w=1.22u l=0.5u
X18 ZN A3 VSS VPW nfet_05v0 ad=0.1209p pd=0.985u as=0.1209p ps=0.985u w=0.465u l=0.6u
X19 VSS A1 ZN VPW nfet_05v0 ad=0.2046p pd=1.81u as=0.1209p ps=0.985u w=0.465u l=0.6u
X20 ZN A2 VSS VPW nfet_05v0 ad=0.1209p pd=0.985u as=0.2046p ps=1.81u w=0.465u l=0.6u
X21 a_224_472# A2 a_36_472# VNW pfet_05v0 ad=0.3782p pd=1.84u as=0.5368p ps=3.32u w=1.22u l=0.5u
X22 ZN A1 VSS VPW nfet_05v0 ad=0.1209p pd=0.985u as=0.1209p ps=0.985u w=0.465u l=0.6u
X23 ZN A3 VSS VPW nfet_05v0 ad=0.1209p pd=0.985u as=0.1209p ps=0.985u w=0.465u l=0.6u
.ends

.subckt gf180mcu_fd_sc_mcu7t5v0__oai211_4 B C VDD VSS ZN A1 A2 VNW VPW
X0 VDD A2 a_1612_497# VNW pfet_05v0 ad=0.3766p pd=1.815u as=0.4599p ps=1.935u w=1.095u l=0.5u
X1 VDD C ZN VNW pfet_05v0 ad=0.2561p pd=1.505u as=0.2561p ps=1.505u w=0.985u l=0.5u
X2 ZN A1 a_36_68# VPW nfet_05v0 ad=0.2132p pd=1.34u as=0.2132p ps=1.34u w=0.82u l=0.6u
X3 a_716_497# A1 ZN VNW pfet_05v0 ad=0.3942p pd=1.815u as=0.2847p ps=1.615u w=1.095u l=0.5u
X4 VDD A2 a_716_497# VNW pfet_05v0 ad=0.2847p pd=1.615u as=0.3942p ps=1.815u w=1.095u l=0.5u
X5 ZN C VDD VNW pfet_05v0 ad=0.2561p pd=1.505u as=0.2561p ps=1.505u w=0.985u l=0.5u
X6 a_2124_68# B a_36_68# VPW nfet_05v0 ad=0.1722p pd=1.24u as=0.2132p ps=1.34u w=0.82u l=0.6u
X7 VDD C ZN VNW pfet_05v0 ad=0.2561p pd=1.505u as=0.2561p ps=1.505u w=0.985u l=0.5u
X8 ZN A2 a_36_68# VPW nfet_05v0 ad=0.30965p pd=1.685u as=0.3608p ps=2.52u w=0.82u l=0.6u
X9 a_36_68# A2 ZN VPW nfet_05v0 ad=0.2132p pd=1.34u as=0.30965p ps=1.685u w=0.82u l=0.6u
X10 VSS C a_2960_68# VPW nfet_05v0 ad=0.2132p pd=1.34u as=0.1312p ps=1.14u w=0.82u l=0.6u
X11 VDD B ZN VNW pfet_05v0 ad=0.2561p pd=1.505u as=0.2561p ps=1.505u w=0.985u l=0.5u
X12 ZN C VDD VNW pfet_05v0 ad=0.2561p pd=1.505u as=0.2561p ps=1.505u w=0.985u l=0.5u
X13 a_36_68# A2 ZN VPW nfet_05v0 ad=0.2132p pd=1.34u as=0.2132p ps=1.34u w=0.82u l=0.6u
X14 a_1164_497# A2 VDD VNW pfet_05v0 ad=0.3942p pd=1.815u as=0.2847p ps=1.615u w=1.095u l=0.5u
X15 ZN B VDD VNW pfet_05v0 ad=0.2561p pd=1.505u as=0.2561p ps=1.505u w=0.985u l=0.5u
X16 VDD B ZN VNW pfet_05v0 ad=0.4334p pd=2.85u as=0.2561p ps=1.505u w=0.985u l=0.5u
X17 a_36_68# A1 ZN VPW nfet_05v0 ad=0.2132p pd=1.34u as=0.30965p ps=1.685u w=0.82u l=0.6u
X18 a_36_68# B a_3368_68# VPW nfet_05v0 ad=0.3608p pd=2.52u as=0.1312p ps=1.14u w=0.82u l=0.6u
X19 a_244_497# A2 VDD VNW pfet_05v0 ad=0.4599p pd=1.935u as=0.4818p ps=3.07u w=1.095u l=0.5u
X20 VSS C a_2124_68# VPW nfet_05v0 ad=0.2132p pd=1.34u as=0.1722p ps=1.24u w=0.82u l=0.6u
X21 a_36_68# A1 ZN VPW nfet_05v0 ad=0.2132p pd=1.34u as=0.2132p ps=1.34u w=0.82u l=0.6u
X22 ZN A1 a_1164_497# VNW pfet_05v0 ad=0.2847p pd=1.615u as=0.3942p ps=1.815u w=1.095u l=0.5u
X23 a_36_68# B a_2552_68# VPW nfet_05v0 ad=0.2132p pd=1.34u as=0.1312p ps=1.14u w=0.82u l=0.6u
X24 a_2552_68# C VSS VPW nfet_05v0 ad=0.1312p pd=1.14u as=0.2132p ps=1.34u w=0.82u l=0.6u
X25 a_1612_497# A1 ZN VNW pfet_05v0 ad=0.4599p pd=1.935u as=0.2847p ps=1.615u w=1.095u l=0.5u
X26 ZN A1 a_36_68# VPW nfet_05v0 ad=0.30965p pd=1.685u as=0.2132p ps=1.34u w=0.82u l=0.6u
X27 ZN A2 a_36_68# VPW nfet_05v0 ad=0.2132p pd=1.34u as=0.2132p ps=1.34u w=0.82u l=0.6u
X28 a_3368_68# C VSS VPW nfet_05v0 ad=0.1312p pd=1.14u as=0.2132p ps=1.34u w=0.82u l=0.6u
X29 ZN B VDD VNW pfet_05v0 ad=0.2561p pd=1.505u as=0.3766p ps=1.815u w=0.985u l=0.5u
X30 a_2960_68# B a_36_68# VPW nfet_05v0 ad=0.1312p pd=1.14u as=0.2132p ps=1.34u w=0.82u l=0.6u
X31 ZN A1 a_244_497# VNW pfet_05v0 ad=0.2847p pd=1.615u as=0.4599p ps=1.935u w=1.095u l=0.5u
.ends

.subckt gf180mcu_fd_sc_mcu7t5v0__or2_4 VDD VSS Z A1 A2 VNW VPW
X0 Z a_244_68# VSS VPW nfet_05v0 ad=0.2132p pd=1.34u as=0.2706p ps=1.48u w=0.82u l=0.6u
X1 a_244_68# A1 VSS VPW nfet_05v0 ad=0.2132p pd=1.34u as=0.2132p ps=1.34u w=0.82u l=0.6u
X2 VSS a_244_68# Z VPW nfet_05v0 ad=0.3608p pd=2.52u as=0.2132p ps=1.34u w=0.82u l=0.6u
X3 a_244_68# A2 VSS VPW nfet_05v0 ad=0.2132p pd=1.34u as=0.3608p ps=2.52u w=0.82u l=0.6u
X4 a_244_68# A1 a_244_472# VNW pfet_05v0 ad=0.3782p pd=1.84u as=0.3477p ps=1.79u w=1.22u l=0.5u
X5 VSS a_244_68# Z VPW nfet_05v0 ad=0.2132p pd=1.34u as=0.2132p ps=1.34u w=0.82u l=0.6u
X6 a_244_472# A2 VDD VNW pfet_05v0 ad=0.3477p pd=1.79u as=0.5368p ps=3.32u w=1.22u l=0.5u
X7 VDD a_244_68# Z VNW pfet_05v0 ad=0.5368p pd=3.32u as=0.3477p ps=1.79u w=1.22u l=0.5u
X8 VDD a_244_68# Z VNW pfet_05v0 ad=0.3477p pd=1.79u as=0.3782p ps=1.84u w=1.22u l=0.5u
X9 VDD A2 a_682_472# VNW pfet_05v0 ad=0.5246p pd=2.08u as=0.3477p ps=1.79u w=1.22u l=0.5u
X10 Z a_244_68# VDD VNW pfet_05v0 ad=0.3477p pd=1.79u as=0.3477p ps=1.79u w=1.22u l=0.5u
X11 a_682_472# A1 a_244_68# VNW pfet_05v0 ad=0.3477p pd=1.79u as=0.3782p ps=1.84u w=1.22u l=0.5u
X12 VSS A2 a_244_68# VPW nfet_05v0 ad=0.2706p pd=1.48u as=0.2132p ps=1.34u w=0.82u l=0.6u
X13 VSS A1 a_244_68# VPW nfet_05v0 ad=0.2132p pd=1.34u as=0.2132p ps=1.34u w=0.82u l=0.6u
X14 Z a_244_68# VDD VNW pfet_05v0 ad=0.3782p pd=1.84u as=0.5246p ps=2.08u w=1.22u l=0.5u
X15 Z a_244_68# VSS VPW nfet_05v0 ad=0.2132p pd=1.34u as=0.2132p ps=1.34u w=0.82u l=0.6u
.ends

.subckt gf180mcu_fd_sc_mcu7t5v0__nand3_2 A3 VDD VSS ZN A1 A2 VNW VPW
X0 ZN A1 VDD VNW pfet_05v0 ad=0.2561p pd=1.505u as=0.2561p ps=1.505u w=0.985u l=0.5u
X1 VDD A1 ZN VNW pfet_05v0 ad=0.2561p pd=1.505u as=0.2561p ps=1.505u w=0.985u l=0.5u
X2 a_1044_68# A2 a_860_68# VPW nfet_05v0 ad=0.1722p pd=1.24u as=0.1312p ps=1.14u w=0.82u l=0.6u
X3 a_860_68# A1 ZN VPW nfet_05v0 ad=0.1312p pd=1.14u as=0.2132p ps=1.34u w=0.82u l=0.6u
X4 ZN A2 VDD VNW pfet_05v0 ad=0.2561p pd=1.505u as=0.2561p ps=1.505u w=0.985u l=0.5u
X5 VDD A3 ZN VNW pfet_05v0 ad=0.4334p pd=2.85u as=0.2561p ps=1.505u w=0.985u l=0.5u
X6 VSS A3 a_1044_68# VPW nfet_05v0 ad=0.3608p pd=2.52u as=0.1722p ps=1.24u w=0.82u l=0.6u
X7 a_276_68# A3 VSS VPW nfet_05v0 ad=0.1148p pd=1.1u as=0.3608p ps=2.52u w=0.82u l=0.6u
X8 ZN A3 VDD VNW pfet_05v0 ad=0.2561p pd=1.505u as=0.4334p ps=2.85u w=0.985u l=0.5u
X9 VDD A2 ZN VNW pfet_05v0 ad=0.2561p pd=1.505u as=0.2561p ps=1.505u w=0.985u l=0.5u
X10 a_452_68# A2 a_276_68# VPW nfet_05v0 ad=0.1312p pd=1.14u as=0.1148p ps=1.1u w=0.82u l=0.6u
X11 ZN A1 a_452_68# VPW nfet_05v0 ad=0.2132p pd=1.34u as=0.1312p ps=1.14u w=0.82u l=0.6u
.ends

.subckt gf180mcu_fd_sc_mcu7t5v0__or4_1 A3 A4 VDD VSS Z A1 A2 VNW VPW
X0 VSS A4 a_56_604# VPW nfet_05v0 ad=0.218p pd=1.52u as=93.59999f ps=0.88u w=0.36u l=0.6u
X1 Z a_56_604# VSS VPW nfet_05v0 ad=0.3608p pd=2.52u as=0.218p ps=1.52u w=0.82u l=0.6u
X2 Z a_56_604# VDD VNW pfet_05v0 ad=0.5368p pd=3.32u as=0.389p ps=2.02u w=1.22u l=0.5u
X3 VSS A2 a_56_604# VPW nfet_05v0 ad=93.59999f pd=0.88u as=0.126p ps=1.06u w=0.36u l=0.6u
X4 VDD A4 a_708_604# VNW pfet_05v0 ad=0.389p pd=2.02u as=0.1736p ps=1.18u w=0.56u l=0.5u
X5 a_244_604# A1 a_56_604# VNW pfet_05v0 ad=0.196p pd=1.26u as=0.2464p ps=2u w=0.56u l=0.5u
X6 a_56_604# A1 VSS VPW nfet_05v0 ad=0.126p pd=1.06u as=0.1584p ps=1.6u w=0.36u l=0.6u
X7 a_56_604# A3 VSS VPW nfet_05v0 ad=93.59999f pd=0.88u as=93.59999f ps=0.88u w=0.36u l=0.6u
X8 a_708_604# A3 a_484_604# VNW pfet_05v0 ad=0.1736p pd=1.18u as=0.1736p ps=1.18u w=0.56u l=0.5u
X9 a_484_604# A2 a_244_604# VNW pfet_05v0 ad=0.1736p pd=1.18u as=0.196p ps=1.26u w=0.56u l=0.5u
.ends

.subckt gf180mcu_fd_sc_mcu7t5v0__oai211_2 A2 ZN A1 B C VDD VSS VNW VPW
X0 a_1229_68# B a_36_68# VPW nfet_05v0 ad=0.1722p pd=1.24u as=0.21525p ps=1.345u w=0.82u l=0.6u
X1 VDD B ZN VNW pfet_05v0 ad=0.4334p pd=2.85u as=0.2561p ps=1.505u w=0.985u l=0.5u
X2 ZN A1 a_36_68# VPW nfet_05v0 ad=0.30965p pd=1.685u as=0.2132p ps=1.34u w=0.82u l=0.6u
X3 a_716_497# A1 ZN VNW pfet_05v0 ad=0.4599p pd=1.935u as=0.2847p ps=1.615u w=1.095u l=0.5u
X4 a_36_68# B a_1657_68# VPW nfet_05v0 ad=0.3608p pd=2.52u as=0.1312p ps=1.14u w=0.82u l=0.6u
X5 ZN A2 a_36_68# VPW nfet_05v0 ad=0.31215p pd=1.685u as=0.3608p ps=2.52u w=0.82u l=0.6u
X6 VDD A2 a_716_497# VNW pfet_05v0 ad=0.37905p pd=1.82u as=0.4599p ps=1.935u w=1.095u l=0.5u
X7 a_36_68# A1 ZN VPW nfet_05v0 ad=0.2132p pd=1.34u as=0.31215p ps=1.685u w=0.82u l=0.6u
X8 a_244_497# A2 VDD VNW pfet_05v0 ad=0.4599p pd=1.935u as=0.4818p ps=3.07u w=1.095u l=0.5u
X9 a_36_68# A2 ZN VPW nfet_05v0 ad=0.21525p pd=1.345u as=0.30965p ps=1.685u w=0.82u l=0.6u
X10 a_1657_68# C VSS VPW nfet_05v0 ad=0.1312p pd=1.14u as=0.2132p ps=1.34u w=0.82u l=0.6u
X11 ZN B VDD VNW pfet_05v0 ad=0.2561p pd=1.505u as=0.37905p ps=1.82u w=0.985u l=0.5u
X12 VDD C ZN VNW pfet_05v0 ad=0.2561p pd=1.505u as=0.2561p ps=1.505u w=0.985u l=0.5u
X13 VSS C a_1229_68# VPW nfet_05v0 ad=0.2132p pd=1.34u as=0.1722p ps=1.24u w=0.82u l=0.6u
X14 ZN A1 a_244_497# VNW pfet_05v0 ad=0.2847p pd=1.615u as=0.4599p ps=1.935u w=1.095u l=0.5u
X15 ZN C VDD VNW pfet_05v0 ad=0.2561p pd=1.505u as=0.2561p ps=1.505u w=0.985u l=0.5u
.ends

.subckt SAR_LOGIC_ACTUAL_RTL_SS DCTRLN[1] DCTRLN[2] DCTRLN[3] DCTRLN[4] DCTRLN[5]
+ DCTRLN[6] DCTRLN[7] DCTRLP[1] DCTRLP[2] DCTRLP[3] DCTRLP[4] DCTRLP[5] DCTRLP[6]
+ DCTRLP[7] CLKS CMPCK DCMPN DCMPP DOUT[0] DOUT[1] DOUT[2] DOUT[3] DOUT[4] DOUT[5]
+ DOUT[6] DOUT[7] VDD VSS
Xgf180mcu_fd_sc_mcu7t5v0__fillcap_4_206 VDD VSS VDD VSS gf180mcu_fd_sc_mcu7t5v0__fillcap_4
Xgf180mcu_fd_sc_mcu7t5v0__oai31_1_13 VDD gf180mcu_fd_sc_mcu7t5v0__oai31_1_12/B gf180mcu_fd_sc_mcu7t5v0__buf_4_21/I
+ gf180mcu_fd_sc_mcu7t5v0__buf_2_5/Z gf180mcu_fd_sc_mcu7t5v0__buf_1_4/Z VSS gf180mcu_fd_sc_mcu7t5v0__buf_1_43/Z
+ VDD VSS gf180mcu_fd_sc_mcu7t5v0__oai31_1
Xgf180mcu_fd_sc_mcu7t5v0__clkbuf_2_12 gf180mcu_fd_sc_mcu7t5v0__clkbuf_2_12/Z VSS VDD
+ gf180mcu_fd_sc_mcu7t5v0__clkbuf_8_18/Z VDD VSS gf180mcu_fd_sc_mcu7t5v0__clkbuf_2
Xgf180mcu_fd_sc_mcu7t5v0__buf_4_15 gf180mcu_fd_sc_mcu7t5v0__buf_4_15/Z gf180mcu_fd_sc_mcu7t5v0__or2_4_0/Z
+ VDD VSS VDD VSS gf180mcu_fd_sc_mcu7t5v0__buf_4
Xgf180mcu_fd_sc_mcu7t5v0__clkbuf_8_7 gf180mcu_fd_sc_mcu7t5v0__clkbuf_8_7/Z VSS VDD
+ gf180mcu_fd_sc_mcu7t5v0__clkbuf_8_9/I VDD VSS gf180mcu_fd_sc_mcu7t5v0__clkbuf_8
Xgf180mcu_fd_sc_mcu7t5v0__fillcap_8_6 VDD VSS VDD VSS gf180mcu_fd_sc_mcu7t5v0__fillcap_8
Xgf180mcu_fd_sc_mcu7t5v0__fillcap_64_73 VDD VSS VDD VSS gf180mcu_fd_sc_mcu7t5v0__fillcap_64
Xgf180mcu_fd_sc_mcu7t5v0__fillcap_64_51 VDD VSS VDD VSS gf180mcu_fd_sc_mcu7t5v0__fillcap_64
Xgf180mcu_fd_sc_mcu7t5v0__fillcap_64_40 VDD VSS VDD VSS gf180mcu_fd_sc_mcu7t5v0__fillcap_64
Xgf180mcu_fd_sc_mcu7t5v0__fillcap_64_62 VDD VSS VDD VSS gf180mcu_fd_sc_mcu7t5v0__fillcap_64
Xgf180mcu_fd_sc_mcu7t5v0__fillcap_64_84 VDD VSS VDD VSS gf180mcu_fd_sc_mcu7t5v0__fillcap_64
Xgf180mcu_fd_sc_mcu7t5v0__clkbuf_8_22 gf180mcu_fd_sc_mcu7t5v0__clkbuf_8_22/Z VSS VDD
+ gf180mcu_fd_sc_mcu7t5v0__clkbuf_8_22/I VDD VSS gf180mcu_fd_sc_mcu7t5v0__clkbuf_8
Xgf180mcu_fd_sc_mcu7t5v0__clkbuf_8_11 gf180mcu_fd_sc_mcu7t5v0__clkinv_1_22/I VSS VDD
+ gf180mcu_fd_sc_mcu7t5v0__clkbuf_8_9/I VDD VSS gf180mcu_fd_sc_mcu7t5v0__clkbuf_8
Xgf180mcu_fd_sc_mcu7t5v0__buf_1_38 VSS gf180mcu_fd_sc_mcu7t5v0__buf_1_4/I gf180mcu_fd_sc_mcu7t5v0__buf_1_38/I
+ VDD VDD VSS gf180mcu_fd_sc_mcu7t5v0__buf_1
Xgf180mcu_fd_sc_mcu7t5v0__buf_1_27 VSS gf180mcu_fd_sc_mcu7t5v0__or2_4_0/A1 gf180mcu_fd_sc_mcu7t5v0__buf_1_40/Z
+ VDD VDD VSS gf180mcu_fd_sc_mcu7t5v0__buf_1
Xgf180mcu_fd_sc_mcu7t5v0__buf_1_16 VSS gf180mcu_fd_sc_mcu7t5v0__buf_1_16/Z gf180mcu_fd_sc_mcu7t5v0__buf_1_3/I
+ VDD VDD VSS gf180mcu_fd_sc_mcu7t5v0__buf_1
Xgf180mcu_fd_sc_mcu7t5v0__fillcap_4_207 VDD VSS VDD VSS gf180mcu_fd_sc_mcu7t5v0__fillcap_4
Xgf180mcu_fd_sc_mcu7t5v0__fillcap_4_0 VDD VSS VDD VSS gf180mcu_fd_sc_mcu7t5v0__fillcap_4
Xgf180mcu_fd_sc_mcu7t5v0__dffnq_1_0 gf180mcu_fd_sc_mcu7t5v0__clkbuf_2_4/I VDD VSS
+ gf180mcu_fd_sc_mcu7t5v0__dffnq_1_0/D gf180mcu_fd_sc_mcu7t5v0__buf_4_2/I VDD VSS
+ gf180mcu_fd_sc_mcu7t5v0__dffnq_1
Xgf180mcu_fd_sc_mcu7t5v0__nand2_1_20 VDD VSS gf180mcu_fd_sc_mcu7t5v0__buf_2_8/I gf180mcu_fd_sc_mcu7t5v0__buf_1_42/Z
+ gf180mcu_fd_sc_mcu7t5v0__or2_1_0/A2 VDD VSS gf180mcu_fd_sc_mcu7t5v0__nand2_1
Xgf180mcu_fd_sc_mcu7t5v0__clkbuf_2_13 gf180mcu_fd_sc_mcu7t5v0__clkbuf_2_13/Z VSS VDD
+ gf180mcu_fd_sc_mcu7t5v0__clkbuf_8_21/Z VDD VSS gf180mcu_fd_sc_mcu7t5v0__clkbuf_2
Xgf180mcu_fd_sc_mcu7t5v0__buf_4_16 DCTRLN[7] gf180mcu_fd_sc_mcu7t5v0__buf_4_16/I VDD
+ VSS VDD VSS gf180mcu_fd_sc_mcu7t5v0__buf_4
Xgf180mcu_fd_sc_mcu7t5v0__clkbuf_8_8 gf180mcu_fd_sc_mcu7t5v0__clkbuf_8_8/Z VSS VDD
+ gf180mcu_fd_sc_mcu7t5v0__clkbuf_8_8/I VDD VSS gf180mcu_fd_sc_mcu7t5v0__clkbuf_8
Xgf180mcu_fd_sc_mcu7t5v0__fillcap_4_90 VDD VSS VDD VSS gf180mcu_fd_sc_mcu7t5v0__fillcap_4
Xgf180mcu_fd_sc_mcu7t5v0__fillcap_8_7 VDD VSS VDD VSS gf180mcu_fd_sc_mcu7t5v0__fillcap_8
Xgf180mcu_fd_sc_mcu7t5v0__fillcap_64_63 VDD VSS VDD VSS gf180mcu_fd_sc_mcu7t5v0__fillcap_64
Xgf180mcu_fd_sc_mcu7t5v0__fillcap_64_52 VDD VSS VDD VSS gf180mcu_fd_sc_mcu7t5v0__fillcap_64
Xgf180mcu_fd_sc_mcu7t5v0__fillcap_64_41 VDD VSS VDD VSS gf180mcu_fd_sc_mcu7t5v0__fillcap_64
Xgf180mcu_fd_sc_mcu7t5v0__fillcap_64_30 VDD VSS VDD VSS gf180mcu_fd_sc_mcu7t5v0__fillcap_64
Xgf180mcu_fd_sc_mcu7t5v0__fillcap_64_74 VDD VSS VDD VSS gf180mcu_fd_sc_mcu7t5v0__fillcap_64
Xgf180mcu_fd_sc_mcu7t5v0__fillcap_64_85 VDD VSS VDD VSS gf180mcu_fd_sc_mcu7t5v0__fillcap_64
Xgf180mcu_fd_sc_mcu7t5v0__dffnsnq_1_0 gf180mcu_fd_sc_mcu7t5v0__clkbuf_8_18/Z gf180mcu_fd_sc_mcu7t5v0__buf_4_19/I
+ gf180mcu_fd_sc_mcu7t5v0__clkinv_1_38/ZN VDD VSS gf180mcu_fd_sc_mcu7t5v0__oai31_1_10/ZN
+ VDD VSS gf180mcu_fd_sc_mcu7t5v0__dffnsnq_1
Xgf180mcu_fd_sc_mcu7t5v0__clkbuf_8_23 gf180mcu_fd_sc_mcu7t5v0__clkinv_1_39/I VSS VDD
+ gf180mcu_fd_sc_mcu7t5v0__clkbuf_8_24/I VDD VSS gf180mcu_fd_sc_mcu7t5v0__clkbuf_8
Xgf180mcu_fd_sc_mcu7t5v0__clkbuf_8_12 gf180mcu_fd_sc_mcu7t5v0__clkbuf_2_2/I VSS VDD
+ gf180mcu_fd_sc_mcu7t5v0__clkbuf_8_5/I VDD VSS gf180mcu_fd_sc_mcu7t5v0__clkbuf_8
Xgf180mcu_fd_sc_mcu7t5v0__buf_1_39 VSS gf180mcu_fd_sc_mcu7t5v0__buf_1_39/Z gf180mcu_fd_sc_mcu7t5v0__buf_1_44/I
+ VDD VDD VSS gf180mcu_fd_sc_mcu7t5v0__buf_1
Xgf180mcu_fd_sc_mcu7t5v0__buf_1_28 VSS gf180mcu_fd_sc_mcu7t5v0__buf_1_28/Z gf180mcu_fd_sc_mcu7t5v0__buf_2_4/I
+ VDD VDD VSS gf180mcu_fd_sc_mcu7t5v0__buf_1
Xgf180mcu_fd_sc_mcu7t5v0__buf_1_17 VSS gf180mcu_fd_sc_mcu7t5v0__buf_1_17/Z gf180mcu_fd_sc_mcu7t5v0__buf_1_23/I
+ VDD VDD VSS gf180mcu_fd_sc_mcu7t5v0__buf_1
Xgf180mcu_fd_sc_mcu7t5v0__fillcap_4_208 VDD VSS VDD VSS gf180mcu_fd_sc_mcu7t5v0__fillcap_4
Xgf180mcu_fd_sc_mcu7t5v0__fillcap_4_1 VDD VSS VDD VSS gf180mcu_fd_sc_mcu7t5v0__fillcap_4
Xgf180mcu_fd_sc_mcu7t5v0__aoi211_1_0 gf180mcu_fd_sc_mcu7t5v0__buf_1_26/I gf180mcu_fd_sc_mcu7t5v0__buf_1_39/Z
+ VDD VSS gf180mcu_fd_sc_mcu7t5v0__nor2_1_0/A2 gf180mcu_fd_sc_mcu7t5v0__buf_2_9/Z
+ gf180mcu_fd_sc_mcu7t5v0__buf_2_6/I VDD VSS gf180mcu_fd_sc_mcu7t5v0__aoi211_1
Xgf180mcu_fd_sc_mcu7t5v0__dffnq_1_1 gf180mcu_fd_sc_mcu7t5v0__clkbuf_2_4/I VDD VSS
+ gf180mcu_fd_sc_mcu7t5v0__dffnq_1_1/D gf180mcu_fd_sc_mcu7t5v0__buf_4_0/I VDD VSS
+ gf180mcu_fd_sc_mcu7t5v0__dffnq_1
Xgf180mcu_fd_sc_mcu7t5v0__oai31_1_0 VDD gf180mcu_fd_sc_mcu7t5v0__oai31_1_0/ZN gf180mcu_fd_sc_mcu7t5v0__buf_4_4/I
+ gf180mcu_fd_sc_mcu7t5v0__nor3_4_0/A1 gf180mcu_fd_sc_mcu7t5v0__buf_1_0/Z VSS gf180mcu_fd_sc_mcu7t5v0__nor4_1_0/A1
+ VDD VSS gf180mcu_fd_sc_mcu7t5v0__oai31_1
Xgf180mcu_fd_sc_mcu7t5v0__nand2_1_10 VDD VSS gf180mcu_fd_sc_mcu7t5v0__or4_1_0/A2 gf180mcu_fd_sc_mcu7t5v0__or3_2_0/A3
+ gf180mcu_fd_sc_mcu7t5v0__buf_1_17/Z VDD VSS gf180mcu_fd_sc_mcu7t5v0__nand2_1
Xgf180mcu_fd_sc_mcu7t5v0__nand2_1_21 VDD VSS gf180mcu_fd_sc_mcu7t5v0__oai22_1_0/B2
+ gf180mcu_fd_sc_mcu7t5v0__and4_1_0/Z gf180mcu_fd_sc_mcu7t5v0__nand2_1_21/A2 VDD VSS
+ gf180mcu_fd_sc_mcu7t5v0__nand2_1
Xgf180mcu_fd_sc_mcu7t5v0__buf_1_0 VSS gf180mcu_fd_sc_mcu7t5v0__buf_1_0/Z gf180mcu_fd_sc_mcu7t5v0__buf_1_0/I
+ VDD VDD VSS gf180mcu_fd_sc_mcu7t5v0__buf_1
Xgf180mcu_fd_sc_mcu7t5v0__oai22_1_0 gf180mcu_fd_sc_mcu7t5v0__oai22_1_0/A2 gf180mcu_fd_sc_mcu7t5v0__buf_2_0/Z
+ gf180mcu_fd_sc_mcu7t5v0__oai22_1_0/B2 VDD VSS gf180mcu_fd_sc_mcu7t5v0__dffnq_1_1/D
+ gf180mcu_fd_sc_mcu7t5v0__buf_4_24/Z VDD VSS gf180mcu_fd_sc_mcu7t5v0__oai22_1
Xgf180mcu_fd_sc_mcu7t5v0__clkbuf_2_14 gf180mcu_fd_sc_mcu7t5v0__clkbuf_2_14/Z VSS VDD
+ gf180mcu_fd_sc_mcu7t5v0__clkbuf_8_17/Z VDD VSS gf180mcu_fd_sc_mcu7t5v0__clkbuf_2
Xgf180mcu_fd_sc_mcu7t5v0__buf_4_17 DCTRLN[5] gf180mcu_fd_sc_mcu7t5v0__buf_4_17/I VDD
+ VSS VDD VSS gf180mcu_fd_sc_mcu7t5v0__buf_4
Xgf180mcu_fd_sc_mcu7t5v0__fillcap_64_0 VDD VSS VDD VSS gf180mcu_fd_sc_mcu7t5v0__fillcap_64
Xgf180mcu_fd_sc_mcu7t5v0__fillcap_4_80 VDD VSS VDD VSS gf180mcu_fd_sc_mcu7t5v0__fillcap_4
Xgf180mcu_fd_sc_mcu7t5v0__fillcap_4_91 VDD VSS VDD VSS gf180mcu_fd_sc_mcu7t5v0__fillcap_4
Xgf180mcu_fd_sc_mcu7t5v0__clkbuf_8_9 gf180mcu_fd_sc_mcu7t5v0__clkbuf_8_9/Z VSS VDD
+ gf180mcu_fd_sc_mcu7t5v0__clkbuf_8_9/I VDD VSS gf180mcu_fd_sc_mcu7t5v0__clkbuf_8
Xgf180mcu_fd_sc_mcu7t5v0__fillcap_8_8 VDD VSS VDD VSS gf180mcu_fd_sc_mcu7t5v0__fillcap_8
Xgf180mcu_fd_sc_mcu7t5v0__fillcap_64_20 VDD VSS VDD VSS gf180mcu_fd_sc_mcu7t5v0__fillcap_64
Xgf180mcu_fd_sc_mcu7t5v0__fillcap_64_42 VDD VSS VDD VSS gf180mcu_fd_sc_mcu7t5v0__fillcap_64
Xgf180mcu_fd_sc_mcu7t5v0__fillcap_64_31 VDD VSS VDD VSS gf180mcu_fd_sc_mcu7t5v0__fillcap_64
Xgf180mcu_fd_sc_mcu7t5v0__fillcap_64_86 VDD VSS VDD VSS gf180mcu_fd_sc_mcu7t5v0__fillcap_64
Xgf180mcu_fd_sc_mcu7t5v0__fillcap_64_53 VDD VSS VDD VSS gf180mcu_fd_sc_mcu7t5v0__fillcap_64
Xgf180mcu_fd_sc_mcu7t5v0__fillcap_64_75 VDD VSS VDD VSS gf180mcu_fd_sc_mcu7t5v0__fillcap_64
Xgf180mcu_fd_sc_mcu7t5v0__fillcap_64_64 VDD VSS VDD VSS gf180mcu_fd_sc_mcu7t5v0__fillcap_64
Xgf180mcu_fd_sc_mcu7t5v0__dffnsnq_1_1 gf180mcu_fd_sc_mcu7t5v0__clkbuf_8_22/Z gf180mcu_fd_sc_mcu7t5v0__buf_4_16/I
+ gf180mcu_fd_sc_mcu7t5v0__clkinv_1_40/ZN VDD VSS gf180mcu_fd_sc_mcu7t5v0__oai21_1_5/ZN
+ VDD VSS gf180mcu_fd_sc_mcu7t5v0__dffnsnq_1
Xgf180mcu_fd_sc_mcu7t5v0__clkbuf_8_24 gf180mcu_fd_sc_mcu7t5v0__clkinv_1_41/I VSS VDD
+ gf180mcu_fd_sc_mcu7t5v0__clkbuf_8_24/I VDD VSS gf180mcu_fd_sc_mcu7t5v0__clkbuf_8
Xgf180mcu_fd_sc_mcu7t5v0__clkbuf_8_13 gf180mcu_fd_sc_mcu7t5v0__clkbuf_2_3/I VSS VDD
+ gf180mcu_fd_sc_mcu7t5v0__clkbuf_8_5/I VDD VSS gf180mcu_fd_sc_mcu7t5v0__clkbuf_8
Xgf180mcu_fd_sc_mcu7t5v0__buf_1_29 VSS gf180mcu_fd_sc_mcu7t5v0__buf_1_9/I gf180mcu_fd_sc_mcu7t5v0__buf_1_29/I
+ VDD VDD VSS gf180mcu_fd_sc_mcu7t5v0__buf_1
Xgf180mcu_fd_sc_mcu7t5v0__buf_1_18 VSS gf180mcu_fd_sc_mcu7t5v0__buf_1_24/I gf180mcu_fd_sc_mcu7t5v0__buf_1_18/I
+ VDD VDD VSS gf180mcu_fd_sc_mcu7t5v0__buf_1
Xgf180mcu_fd_sc_mcu7t5v0__nor4_1_0 gf180mcu_fd_sc_mcu7t5v0__nor4_1_0/A3 gf180mcu_fd_sc_mcu7t5v0__or4_1_0/A1
+ VDD VSS gf180mcu_fd_sc_mcu7t5v0__nor4_1_0/ZN gf180mcu_fd_sc_mcu7t5v0__nor4_1_0/A1
+ gf180mcu_fd_sc_mcu7t5v0__and2_1_1/Z VDD VSS gf180mcu_fd_sc_mcu7t5v0__nor4_1
Xgf180mcu_fd_sc_mcu7t5v0__fillcap_4_209 VDD VSS VDD VSS gf180mcu_fd_sc_mcu7t5v0__fillcap_4
Xgf180mcu_fd_sc_mcu7t5v0__fillcap_4_2 VDD VSS VDD VSS gf180mcu_fd_sc_mcu7t5v0__fillcap_4
Xgf180mcu_fd_sc_mcu7t5v0__dffnrnq_1_0 gf180mcu_fd_sc_mcu7t5v0__nand2_1_6/ZN VSS gf180mcu_fd_sc_mcu7t5v0__clkbuf_8_2/Z
+ gf180mcu_fd_sc_mcu7t5v0__clkinv_1_6/ZN gf180mcu_fd_sc_mcu7t5v0__buf_4_5/I VDD VDD
+ VSS gf180mcu_fd_sc_mcu7t5v0__dffnrnq_1
Xgf180mcu_fd_sc_mcu7t5v0__aoi211_1_1 gf180mcu_fd_sc_mcu7t5v0__buf_2_12/I gf180mcu_fd_sc_mcu7t5v0__buf_1_39/Z
+ VDD VSS gf180mcu_fd_sc_mcu7t5v0__nor2_1_1/A2 gf180mcu_fd_sc_mcu7t5v0__buf_2_9/Z
+ gf180mcu_fd_sc_mcu7t5v0__buf_2_6/I VDD VSS gf180mcu_fd_sc_mcu7t5v0__aoi211_1
Xgf180mcu_fd_sc_mcu7t5v0__clkbuf_2_0 gf180mcu_fd_sc_mcu7t5v0__clkbuf_2_0/Z VSS VDD
+ gf180mcu_fd_sc_mcu7t5v0__clkbuf_8_3/Z VDD VSS gf180mcu_fd_sc_mcu7t5v0__clkbuf_2
Xgf180mcu_fd_sc_mcu7t5v0__dffnq_1_2 gf180mcu_fd_sc_mcu7t5v0__clkbuf_8_1/Z VDD VSS
+ gf180mcu_fd_sc_mcu7t5v0__dffnq_1_2/D gf180mcu_fd_sc_mcu7t5v0__buf_4_4/I VDD VSS
+ gf180mcu_fd_sc_mcu7t5v0__dffnq_1
Xgf180mcu_fd_sc_mcu7t5v0__oai31_1_1 VDD gf180mcu_fd_sc_mcu7t5v0__oai31_1_1/ZN gf180mcu_fd_sc_mcu7t5v0__oai31_1_1/B
+ gf180mcu_fd_sc_mcu7t5v0__buf_1_16/Z gf180mcu_fd_sc_mcu7t5v0__buf_1_7/Z VSS gf180mcu_fd_sc_mcu7t5v0__buf_1_6/Z
+ VDD VSS gf180mcu_fd_sc_mcu7t5v0__oai31_1
Xgf180mcu_fd_sc_mcu7t5v0__nand2_1_11 VDD VSS gf180mcu_fd_sc_mcu7t5v0__aoi211_2_0/B
+ gf180mcu_fd_sc_mcu7t5v0__or4_1_0/A2 gf180mcu_fd_sc_mcu7t5v0__buf_1_12/Z VDD VSS
+ gf180mcu_fd_sc_mcu7t5v0__nand2_1
Xgf180mcu_fd_sc_mcu7t5v0__buf_1_1 VSS gf180mcu_fd_sc_mcu7t5v0__buf_1_1/Z gf180mcu_fd_sc_mcu7t5v0__buf_1_1/I
+ VDD VDD VSS gf180mcu_fd_sc_mcu7t5v0__buf_1
Xgf180mcu_fd_sc_mcu7t5v0__oai22_1_1 gf180mcu_fd_sc_mcu7t5v0__oai22_1_1/A2 gf180mcu_fd_sc_mcu7t5v0__buf_2_0/Z
+ gf180mcu_fd_sc_mcu7t5v0__oai22_1_1/B2 VDD VSS gf180mcu_fd_sc_mcu7t5v0__dffnq_1_0/D
+ gf180mcu_fd_sc_mcu7t5v0__buf_4_24/Z VDD VSS gf180mcu_fd_sc_mcu7t5v0__oai22_1
Xgf180mcu_fd_sc_mcu7t5v0__clkinv_1_40 VDD VSS gf180mcu_fd_sc_mcu7t5v0__clkinv_1_41/I
+ gf180mcu_fd_sc_mcu7t5v0__clkinv_1_40/ZN VDD VSS gf180mcu_fd_sc_mcu7t5v0__clkinv_1
Xgf180mcu_fd_sc_mcu7t5v0__clkbuf_2_15 gf180mcu_fd_sc_mcu7t5v0__clkbuf_2_15/Z VSS VDD
+ gf180mcu_fd_sc_mcu7t5v0__dlyb_1_1/I VDD VSS gf180mcu_fd_sc_mcu7t5v0__clkbuf_2
Xgf180mcu_fd_sc_mcu7t5v0__buf_4_18 DCTRLN[6] gf180mcu_fd_sc_mcu7t5v0__buf_4_18/I VDD
+ VSS VDD VSS gf180mcu_fd_sc_mcu7t5v0__buf_4
Xgf180mcu_fd_sc_mcu7t5v0__nand4_1_0 gf180mcu_fd_sc_mcu7t5v0__buf_2_1/Z gf180mcu_fd_sc_mcu7t5v0__buf_1_1/I
+ VDD VSS gf180mcu_fd_sc_mcu7t5v0__nand4_1_0/ZN gf180mcu_fd_sc_mcu7t5v0__dlyb_1_0/I
+ gf180mcu_fd_sc_mcu7t5v0__nor4_1_0/ZN VDD VSS gf180mcu_fd_sc_mcu7t5v0__nand4_1
Xgf180mcu_fd_sc_mcu7t5v0__fillcap_64_1 VDD VSS VDD VSS gf180mcu_fd_sc_mcu7t5v0__fillcap_64
Xgf180mcu_fd_sc_mcu7t5v0__fillcap_4_70 VDD VSS VDD VSS gf180mcu_fd_sc_mcu7t5v0__fillcap_4
Xgf180mcu_fd_sc_mcu7t5v0__fillcap_4_81 VDD VSS VDD VSS gf180mcu_fd_sc_mcu7t5v0__fillcap_4
Xgf180mcu_fd_sc_mcu7t5v0__fillcap_4_92 VDD VSS VDD VSS gf180mcu_fd_sc_mcu7t5v0__fillcap_4
Xgf180mcu_fd_sc_mcu7t5v0__fillcap_8_9 VDD VSS VDD VSS gf180mcu_fd_sc_mcu7t5v0__fillcap_8
Xgf180mcu_fd_sc_mcu7t5v0__fillcap_64_43 VDD VSS VDD VSS gf180mcu_fd_sc_mcu7t5v0__fillcap_64
Xgf180mcu_fd_sc_mcu7t5v0__fillcap_64_32 VDD VSS VDD VSS gf180mcu_fd_sc_mcu7t5v0__fillcap_64
Xgf180mcu_fd_sc_mcu7t5v0__fillcap_64_54 VDD VSS VDD VSS gf180mcu_fd_sc_mcu7t5v0__fillcap_64
Xgf180mcu_fd_sc_mcu7t5v0__fillcap_64_10 VDD VSS VDD VSS gf180mcu_fd_sc_mcu7t5v0__fillcap_64
Xgf180mcu_fd_sc_mcu7t5v0__fillcap_64_21 VDD VSS VDD VSS gf180mcu_fd_sc_mcu7t5v0__fillcap_64
Xgf180mcu_fd_sc_mcu7t5v0__fillcap_64_87 VDD VSS VDD VSS gf180mcu_fd_sc_mcu7t5v0__fillcap_64
Xgf180mcu_fd_sc_mcu7t5v0__fillcap_64_65 VDD VSS VDD VSS gf180mcu_fd_sc_mcu7t5v0__fillcap_64
Xgf180mcu_fd_sc_mcu7t5v0__fillcap_64_76 VDD VSS VDD VSS gf180mcu_fd_sc_mcu7t5v0__fillcap_64
Xgf180mcu_fd_sc_mcu7t5v0__clkbuf_8_14 gf180mcu_fd_sc_mcu7t5v0__clkinv_1_36/I VSS VDD
+ gf180mcu_fd_sc_mcu7t5v0__clkbuf_8_29/I VDD VSS gf180mcu_fd_sc_mcu7t5v0__clkbuf_8
Xgf180mcu_fd_sc_mcu7t5v0__clkbuf_8_25 gf180mcu_fd_sc_mcu7t5v0__clkinv_1_46/I VSS VDD
+ gf180mcu_fd_sc_mcu7t5v0__clkbuf_8_29/I VDD VSS gf180mcu_fd_sc_mcu7t5v0__clkbuf_8
Xgf180mcu_fd_sc_mcu7t5v0__buf_1_19 VSS gf180mcu_fd_sc_mcu7t5v0__buf_1_1/I gf180mcu_fd_sc_mcu7t5v0__buf_1_30/I
+ VDD VDD VSS gf180mcu_fd_sc_mcu7t5v0__buf_1
Xgf180mcu_fd_sc_mcu7t5v0__fillcap_4_3 VDD VSS VDD VSS gf180mcu_fd_sc_mcu7t5v0__fillcap_4
Xgf180mcu_fd_sc_mcu7t5v0__dffnrnq_1_1 gf180mcu_fd_sc_mcu7t5v0__nand2_1_1/ZN VSS gf180mcu_fd_sc_mcu7t5v0__clkbuf_2_8/I
+ gf180mcu_fd_sc_mcu7t5v0__clkinv_1_8/ZN gf180mcu_fd_sc_mcu7t5v0__clkinv_1_9/I VDD
+ VDD VSS gf180mcu_fd_sc_mcu7t5v0__dffnrnq_1
Xgf180mcu_fd_sc_mcu7t5v0__dffnq_1_3 gf180mcu_fd_sc_mcu7t5v0__clkbuf_8_4/Z VDD VSS
+ gf180mcu_fd_sc_mcu7t5v0__dffnq_1_3/D gf180mcu_fd_sc_mcu7t5v0__buf_4_7/I VDD VSS
+ gf180mcu_fd_sc_mcu7t5v0__dffnq_1
Xgf180mcu_fd_sc_mcu7t5v0__clkbuf_2_1 gf180mcu_fd_sc_mcu7t5v0__clkbuf_2_1/Z VSS VDD
+ gf180mcu_fd_sc_mcu7t5v0__clkbuf_8_4/Z VDD VSS gf180mcu_fd_sc_mcu7t5v0__clkbuf_2
Xgf180mcu_fd_sc_mcu7t5v0__oai31_1_2 VDD gf180mcu_fd_sc_mcu7t5v0__oai31_1_2/ZN gf180mcu_fd_sc_mcu7t5v0__oai31_1_2/B
+ gf180mcu_fd_sc_mcu7t5v0__buf_2_3/Z gf180mcu_fd_sc_mcu7t5v0__or4_1_2/A4 VSS gf180mcu_fd_sc_mcu7t5v0__buf_1_6/Z
+ VDD VSS gf180mcu_fd_sc_mcu7t5v0__oai31_1
Xgf180mcu_fd_sc_mcu7t5v0__nand2_1_12 VDD VSS gf180mcu_fd_sc_mcu7t5v0__oai211_1_1/A2
+ gf180mcu_fd_sc_mcu7t5v0__buf_4_14/Z gf180mcu_fd_sc_mcu7t5v0__buf_2_8/Z VDD VSS gf180mcu_fd_sc_mcu7t5v0__nand2_1
Xgf180mcu_fd_sc_mcu7t5v0__and4_1_0 gf180mcu_fd_sc_mcu7t5v0__buf_1_8/Z gf180mcu_fd_sc_mcu7t5v0__buf_4_25/I
+ VDD VSS gf180mcu_fd_sc_mcu7t5v0__and4_1_0/Z gf180mcu_fd_sc_mcu7t5v0__buf_1_5/Z gf180mcu_fd_sc_mcu7t5v0__buf_1_24/Z
+ VDD VSS gf180mcu_fd_sc_mcu7t5v0__and4_1
Xgf180mcu_fd_sc_mcu7t5v0__buf_1_2 VSS gf180mcu_fd_sc_mcu7t5v0__buf_1_2/Z gf180mcu_fd_sc_mcu7t5v0__buf_2_9/I
+ VDD VDD VSS gf180mcu_fd_sc_mcu7t5v0__buf_1
Xgf180mcu_fd_sc_mcu7t5v0__oai22_1_2 gf180mcu_fd_sc_mcu7t5v0__oai22_1_2/A2 gf180mcu_fd_sc_mcu7t5v0__buf_2_2/Z
+ gf180mcu_fd_sc_mcu7t5v0__or4_1_0/Z VDD VSS gf180mcu_fd_sc_mcu7t5v0__dffnq_1_6/D
+ gf180mcu_fd_sc_mcu7t5v0__buf_4_12/Z VDD VSS gf180mcu_fd_sc_mcu7t5v0__oai22_1
Xgf180mcu_fd_sc_mcu7t5v0__clkinv_1_41 VDD VSS gf180mcu_fd_sc_mcu7t5v0__clkinv_1_41/I
+ gf180mcu_fd_sc_mcu7t5v0__clkinv_1_41/ZN VDD VSS gf180mcu_fd_sc_mcu7t5v0__clkinv_1
Xgf180mcu_fd_sc_mcu7t5v0__clkinv_1_30 VDD VSS gf180mcu_fd_sc_mcu7t5v0__clkinv_1_39/I
+ gf180mcu_fd_sc_mcu7t5v0__clkinv_1_30/ZN VDD VSS gf180mcu_fd_sc_mcu7t5v0__clkinv_1
Xgf180mcu_fd_sc_mcu7t5v0__clkbuf_2_16 gf180mcu_fd_sc_mcu7t5v0__clkbuf_2_16/Z VSS VDD
+ gf180mcu_fd_sc_mcu7t5v0__clkbuf_8_8/Z VDD VSS gf180mcu_fd_sc_mcu7t5v0__clkbuf_2
Xgf180mcu_fd_sc_mcu7t5v0__buf_4_19 DCTRLP[7] gf180mcu_fd_sc_mcu7t5v0__buf_4_19/I VDD
+ VSS VDD VSS gf180mcu_fd_sc_mcu7t5v0__buf_4
Xgf180mcu_fd_sc_mcu7t5v0__fillcap_64_2 VDD VSS VDD VSS gf180mcu_fd_sc_mcu7t5v0__fillcap_64
Xgf180mcu_fd_sc_mcu7t5v0__nand4_1_1 gf180mcu_fd_sc_mcu7t5v0__buf_1_30/Z gf180mcu_fd_sc_mcu7t5v0__buf_1_9/Z
+ VDD VSS gf180mcu_fd_sc_mcu7t5v0__oai21_1_7/A2 gf180mcu_fd_sc_mcu7t5v0__oai22_1_7/A1
+ gf180mcu_fd_sc_mcu7t5v0__or4_1_0/A3 VDD VSS gf180mcu_fd_sc_mcu7t5v0__nand4_1
Xgf180mcu_fd_sc_mcu7t5v0__fillcap_4_93 VDD VSS VDD VSS gf180mcu_fd_sc_mcu7t5v0__fillcap_4
Xgf180mcu_fd_sc_mcu7t5v0__fillcap_4_60 VDD VSS VDD VSS gf180mcu_fd_sc_mcu7t5v0__fillcap_4
Xgf180mcu_fd_sc_mcu7t5v0__fillcap_4_71 VDD VSS VDD VSS gf180mcu_fd_sc_mcu7t5v0__fillcap_4
Xgf180mcu_fd_sc_mcu7t5v0__fillcap_4_82 VDD VSS VDD VSS gf180mcu_fd_sc_mcu7t5v0__fillcap_4
Xgf180mcu_fd_sc_mcu7t5v0__fillcap_4_190 VDD VSS VDD VSS gf180mcu_fd_sc_mcu7t5v0__fillcap_4
Xgf180mcu_fd_sc_mcu7t5v0__dlyb_1_0 VDD gf180mcu_fd_sc_mcu7t5v0__dlyb_1_0/I VSS gf180mcu_fd_sc_mcu7t5v0__dlyb_1_0/Z
+ VDD VSS gf180mcu_fd_sc_mcu7t5v0__dlyb_1
Xgf180mcu_fd_sc_mcu7t5v0__fillcap_64_33 VDD VSS VDD VSS gf180mcu_fd_sc_mcu7t5v0__fillcap_64
Xgf180mcu_fd_sc_mcu7t5v0__fillcap_64_44 VDD VSS VDD VSS gf180mcu_fd_sc_mcu7t5v0__fillcap_64
Xgf180mcu_fd_sc_mcu7t5v0__fillcap_64_66 VDD VSS VDD VSS gf180mcu_fd_sc_mcu7t5v0__fillcap_64
Xgf180mcu_fd_sc_mcu7t5v0__fillcap_64_77 VDD VSS VDD VSS gf180mcu_fd_sc_mcu7t5v0__fillcap_64
Xgf180mcu_fd_sc_mcu7t5v0__fillcap_64_55 VDD VSS VDD VSS gf180mcu_fd_sc_mcu7t5v0__fillcap_64
Xgf180mcu_fd_sc_mcu7t5v0__fillcap_64_22 VDD VSS VDD VSS gf180mcu_fd_sc_mcu7t5v0__fillcap_64
Xgf180mcu_fd_sc_mcu7t5v0__fillcap_64_11 VDD VSS VDD VSS gf180mcu_fd_sc_mcu7t5v0__fillcap_64
Xgf180mcu_fd_sc_mcu7t5v0__fillcap_64_88 VDD VSS VDD VSS gf180mcu_fd_sc_mcu7t5v0__fillcap_64
Xgf180mcu_fd_sc_mcu7t5v0__clkbuf_8_15 gf180mcu_fd_sc_mcu7t5v0__clkbuf_8_15/Z VSS VDD
+ gf180mcu_fd_sc_mcu7t5v0__clkbuf_8_8/I VDD VSS gf180mcu_fd_sc_mcu7t5v0__clkbuf_8
Xgf180mcu_fd_sc_mcu7t5v0__clkbuf_8_26 gf180mcu_fd_sc_mcu7t5v0__clkinv_1_8/I VSS VDD
+ gf180mcu_fd_sc_mcu7t5v0__clkbuf_8_29/I VDD VSS gf180mcu_fd_sc_mcu7t5v0__clkbuf_8
Xgf180mcu_fd_sc_mcu7t5v0__fillcap_4_4 VDD VSS VDD VSS gf180mcu_fd_sc_mcu7t5v0__fillcap_4
Xgf180mcu_fd_sc_mcu7t5v0__dffnrnq_1_2 gf180mcu_fd_sc_mcu7t5v0__oai21_1_7/ZN VSS gf180mcu_fd_sc_mcu7t5v0__clkbuf_8_2/Z
+ gf180mcu_fd_sc_mcu7t5v0__clkinv_1_7/ZN gf180mcu_fd_sc_mcu7t5v0__buf_4_3/I VDD VDD
+ VSS gf180mcu_fd_sc_mcu7t5v0__dffnrnq_1
Xgf180mcu_fd_sc_mcu7t5v0__fillcap_32_0 VDD VSS VDD VSS gf180mcu_fd_sc_mcu7t5v0__fillcap_32
Xgf180mcu_fd_sc_mcu7t5v0__dffnq_1_4 gf180mcu_fd_sc_mcu7t5v0__clkbuf_8_5/Z VDD VSS
+ gf180mcu_fd_sc_mcu7t5v0__dffnq_1_4/D gf180mcu_fd_sc_mcu7t5v0__buf_4_6/I VDD VSS
+ gf180mcu_fd_sc_mcu7t5v0__dffnq_1
Xgf180mcu_fd_sc_mcu7t5v0__clkbuf_2_2 gf180mcu_fd_sc_mcu7t5v0__clkbuf_2_2/Z VSS VDD
+ gf180mcu_fd_sc_mcu7t5v0__clkbuf_2_2/I VDD VSS gf180mcu_fd_sc_mcu7t5v0__clkbuf_2
Xgf180mcu_fd_sc_mcu7t5v0__oai31_1_3 VDD gf180mcu_fd_sc_mcu7t5v0__oai31_1_2/B gf180mcu_fd_sc_mcu7t5v0__buf_4_13/I
+ gf180mcu_fd_sc_mcu7t5v0__oai31_1_3/A1 gf180mcu_fd_sc_mcu7t5v0__or4_1_2/A4 VSS gf180mcu_fd_sc_mcu7t5v0__buf_1_6/Z
+ VDD VSS gf180mcu_fd_sc_mcu7t5v0__oai31_1
Xgf180mcu_fd_sc_mcu7t5v0__and4_1_1 gf180mcu_fd_sc_mcu7t5v0__buf_1_8/Z gf180mcu_fd_sc_mcu7t5v0__buf_4_5/I
+ VDD VSS gf180mcu_fd_sc_mcu7t5v0__and4_1_1/Z gf180mcu_fd_sc_mcu7t5v0__buf_1_5/Z gf180mcu_fd_sc_mcu7t5v0__buf_1_24/Z
+ VDD VSS gf180mcu_fd_sc_mcu7t5v0__and4_1
Xgf180mcu_fd_sc_mcu7t5v0__nand2_1_13 VDD VSS gf180mcu_fd_sc_mcu7t5v0__buf_1_6/I gf180mcu_fd_sc_mcu7t5v0__or4_1_2/A3
+ gf180mcu_fd_sc_mcu7t5v0__or4_1_2/A2 VDD VSS gf180mcu_fd_sc_mcu7t5v0__nand2_1
Xgf180mcu_fd_sc_mcu7t5v0__oai22_1_3 gf180mcu_fd_sc_mcu7t5v0__oai22_1_3/A2 gf180mcu_fd_sc_mcu7t5v0__buf_2_2/Z
+ gf180mcu_fd_sc_mcu7t5v0__oai22_1_3/B2 VDD VSS gf180mcu_fd_sc_mcu7t5v0__dffnq_1_5/D
+ gf180mcu_fd_sc_mcu7t5v0__buf_4_12/Z VDD VSS gf180mcu_fd_sc_mcu7t5v0__oai22_1
Xgf180mcu_fd_sc_mcu7t5v0__buf_1_3 VSS gf180mcu_fd_sc_mcu7t5v0__buf_1_3/Z gf180mcu_fd_sc_mcu7t5v0__buf_1_3/I
+ VDD VDD VSS gf180mcu_fd_sc_mcu7t5v0__buf_1
Xgf180mcu_fd_sc_mcu7t5v0__fillcap_32_80 VDD VSS VDD VSS gf180mcu_fd_sc_mcu7t5v0__fillcap_32
Xgf180mcu_fd_sc_mcu7t5v0__clkinv_1_42 VDD VSS gf180mcu_fd_sc_mcu7t5v0__buf_4_18/I
+ gf180mcu_fd_sc_mcu7t5v0__oai32_1_1/B2 VDD VSS gf180mcu_fd_sc_mcu7t5v0__clkinv_1
Xgf180mcu_fd_sc_mcu7t5v0__clkinv_1_31 VDD VSS gf180mcu_fd_sc_mcu7t5v0__clkinv_1_32/I
+ gf180mcu_fd_sc_mcu7t5v0__clkinv_1_31/ZN VDD VSS gf180mcu_fd_sc_mcu7t5v0__clkinv_1
Xgf180mcu_fd_sc_mcu7t5v0__clkinv_1_20 VDD VSS gf180mcu_fd_sc_mcu7t5v0__clkbuf_8_7/Z
+ gf180mcu_fd_sc_mcu7t5v0__dffnrnq_1_9/RN VDD VSS gf180mcu_fd_sc_mcu7t5v0__clkinv_1
Xgf180mcu_fd_sc_mcu7t5v0__clkbuf_2_17 gf180mcu_fd_sc_mcu7t5v0__clkbuf_2_17/Z VSS VDD
+ gf180mcu_fd_sc_mcu7t5v0__clkbuf_8_2/Z VDD VSS gf180mcu_fd_sc_mcu7t5v0__clkbuf_2
Xgf180mcu_fd_sc_mcu7t5v0__fillcap_64_3 VDD VSS VDD VSS gf180mcu_fd_sc_mcu7t5v0__fillcap_64
Xgf180mcu_fd_sc_mcu7t5v0__fillcap_4_94 VDD VSS VDD VSS gf180mcu_fd_sc_mcu7t5v0__fillcap_4
Xgf180mcu_fd_sc_mcu7t5v0__fillcap_4_50 VDD VSS VDD VSS gf180mcu_fd_sc_mcu7t5v0__fillcap_4
Xgf180mcu_fd_sc_mcu7t5v0__fillcap_4_61 VDD VSS VDD VSS gf180mcu_fd_sc_mcu7t5v0__fillcap_4
Xgf180mcu_fd_sc_mcu7t5v0__fillcap_4_83 VDD VSS VDD VSS gf180mcu_fd_sc_mcu7t5v0__fillcap_4
Xgf180mcu_fd_sc_mcu7t5v0__fillcap_4_72 VDD VSS VDD VSS gf180mcu_fd_sc_mcu7t5v0__fillcap_4
Xgf180mcu_fd_sc_mcu7t5v0__fillcap_4_180 VDD VSS VDD VSS gf180mcu_fd_sc_mcu7t5v0__fillcap_4
Xgf180mcu_fd_sc_mcu7t5v0__fillcap_4_191 VDD VSS VDD VSS gf180mcu_fd_sc_mcu7t5v0__fillcap_4
Xgf180mcu_fd_sc_mcu7t5v0__dlyb_1_1 VDD gf180mcu_fd_sc_mcu7t5v0__dlyb_1_1/I VSS gf180mcu_fd_sc_mcu7t5v0__dlyb_1_1/Z
+ VDD VSS gf180mcu_fd_sc_mcu7t5v0__dlyb_1
Xgf180mcu_fd_sc_mcu7t5v0__fillcap_64_89 VDD VSS VDD VSS gf180mcu_fd_sc_mcu7t5v0__fillcap_64
Xgf180mcu_fd_sc_mcu7t5v0__fillcap_64_34 VDD VSS VDD VSS gf180mcu_fd_sc_mcu7t5v0__fillcap_64
Xgf180mcu_fd_sc_mcu7t5v0__fillcap_64_45 VDD VSS VDD VSS gf180mcu_fd_sc_mcu7t5v0__fillcap_64
Xgf180mcu_fd_sc_mcu7t5v0__fillcap_64_78 VDD VSS VDD VSS gf180mcu_fd_sc_mcu7t5v0__fillcap_64
Xgf180mcu_fd_sc_mcu7t5v0__fillcap_64_56 VDD VSS VDD VSS gf180mcu_fd_sc_mcu7t5v0__fillcap_64
Xgf180mcu_fd_sc_mcu7t5v0__fillcap_64_67 VDD VSS VDD VSS gf180mcu_fd_sc_mcu7t5v0__fillcap_64
Xgf180mcu_fd_sc_mcu7t5v0__fillcap_64_12 VDD VSS VDD VSS gf180mcu_fd_sc_mcu7t5v0__fillcap_64
Xgf180mcu_fd_sc_mcu7t5v0__fillcap_64_23 VDD VSS VDD VSS gf180mcu_fd_sc_mcu7t5v0__fillcap_64
Xgf180mcu_fd_sc_mcu7t5v0__clkbuf_8_16 gf180mcu_fd_sc_mcu7t5v0__clkinv_1_32/I VSS VDD
+ gf180mcu_fd_sc_mcu7t5v0__clkbuf_8_24/I VDD VSS gf180mcu_fd_sc_mcu7t5v0__clkbuf_8
Xgf180mcu_fd_sc_mcu7t5v0__clkbuf_8_27 gf180mcu_fd_sc_mcu7t5v0__clkbuf_2_4/I VSS VDD
+ gf180mcu_fd_sc_mcu7t5v0__clkbuf_8_4/I VDD VSS gf180mcu_fd_sc_mcu7t5v0__clkbuf_8
Xgf180mcu_fd_sc_mcu7t5v0__fillcap_4_5 VDD VSS VDD VSS gf180mcu_fd_sc_mcu7t5v0__fillcap_4
Xgf180mcu_fd_sc_mcu7t5v0__dffnrnq_1_3 gf180mcu_fd_sc_mcu7t5v0__oai31_1_2/ZN VSS gf180mcu_fd_sc_mcu7t5v0__clkbuf_2_3/I
+ gf180mcu_fd_sc_mcu7t5v0__dffnrnq_1_3/RN gf180mcu_fd_sc_mcu7t5v0__buf_4_13/I VDD
+ VDD VSS gf180mcu_fd_sc_mcu7t5v0__dffnrnq_1
Xgf180mcu_fd_sc_mcu7t5v0__nand2_2_0 VDD VSS gf180mcu_fd_sc_mcu7t5v0__buf_4_14/I gf180mcu_fd_sc_mcu7t5v0__or2_4_0/A1
+ gf180mcu_fd_sc_mcu7t5v0__buf_2_7/Z VDD VSS gf180mcu_fd_sc_mcu7t5v0__nand2_2
Xgf180mcu_fd_sc_mcu7t5v0__fillcap_32_1 VDD VSS VDD VSS gf180mcu_fd_sc_mcu7t5v0__fillcap_32
Xgf180mcu_fd_sc_mcu7t5v0__dffnq_1_5 gf180mcu_fd_sc_mcu7t5v0__clkbuf_8_3/Z VDD VSS
+ gf180mcu_fd_sc_mcu7t5v0__dffnq_1_5/D gf180mcu_fd_sc_mcu7t5v0__buf_4_8/I VDD VSS
+ gf180mcu_fd_sc_mcu7t5v0__dffnq_1
Xgf180mcu_fd_sc_mcu7t5v0__clkbuf_2_3 gf180mcu_fd_sc_mcu7t5v0__clkbuf_2_3/Z VSS VDD
+ gf180mcu_fd_sc_mcu7t5v0__clkbuf_2_3/I VDD VSS gf180mcu_fd_sc_mcu7t5v0__clkbuf_2
Xgf180mcu_fd_sc_mcu7t5v0__oai31_1_4 VDD gf180mcu_fd_sc_mcu7t5v0__oai31_1_4/ZN gf180mcu_fd_sc_mcu7t5v0__buf_4_11/I
+ gf180mcu_fd_sc_mcu7t5v0__buf_1_15/Z gf180mcu_fd_sc_mcu7t5v0__oai31_1_5/A2 VSS gf180mcu_fd_sc_mcu7t5v0__buf_1_0/Z
+ VDD VSS gf180mcu_fd_sc_mcu7t5v0__oai31_1
Xgf180mcu_fd_sc_mcu7t5v0__and4_1_2 gf180mcu_fd_sc_mcu7t5v0__buf_1_8/Z gf180mcu_fd_sc_mcu7t5v0__buf_4_22/I
+ VDD VSS gf180mcu_fd_sc_mcu7t5v0__and4_1_2/Z gf180mcu_fd_sc_mcu7t5v0__buf_1_9/Z gf180mcu_fd_sc_mcu7t5v0__buf_1_24/Z
+ VDD VSS gf180mcu_fd_sc_mcu7t5v0__and4_1
Xgf180mcu_fd_sc_mcu7t5v0__nand2_1_14 VDD VSS gf180mcu_fd_sc_mcu7t5v0__nand2_1_14/ZN
+ gf180mcu_fd_sc_mcu7t5v0__or4_1_2/Z gf180mcu_fd_sc_mcu7t5v0__oai31_1_4/ZN VDD VSS
+ gf180mcu_fd_sc_mcu7t5v0__nand2_1
Xgf180mcu_fd_sc_mcu7t5v0__buf_1_4 VSS gf180mcu_fd_sc_mcu7t5v0__buf_1_4/Z gf180mcu_fd_sc_mcu7t5v0__buf_1_4/I
+ VDD VDD VSS gf180mcu_fd_sc_mcu7t5v0__buf_1
Xgf180mcu_fd_sc_mcu7t5v0__oai22_1_4 gf180mcu_fd_sc_mcu7t5v0__oai22_1_4/A2 gf180mcu_fd_sc_mcu7t5v0__buf_2_2/Z
+ gf180mcu_fd_sc_mcu7t5v0__oai22_1_4/B2 VDD VSS gf180mcu_fd_sc_mcu7t5v0__dffnq_1_4/D
+ gf180mcu_fd_sc_mcu7t5v0__buf_4_12/Z VDD VSS gf180mcu_fd_sc_mcu7t5v0__oai22_1
Xgf180mcu_fd_sc_mcu7t5v0__fillcap_32_81 VDD VSS VDD VSS gf180mcu_fd_sc_mcu7t5v0__fillcap_32
Xgf180mcu_fd_sc_mcu7t5v0__fillcap_32_70 VDD VSS VDD VSS gf180mcu_fd_sc_mcu7t5v0__fillcap_32
Xgf180mcu_fd_sc_mcu7t5v0__clkinv_1_43 VDD VSS gf180mcu_fd_sc_mcu7t5v0__clkinv_1_45/I
+ gf180mcu_fd_sc_mcu7t5v0__dffrnq_2_0/RN VDD VSS gf180mcu_fd_sc_mcu7t5v0__clkinv_1
Xgf180mcu_fd_sc_mcu7t5v0__clkinv_1_32 VDD VSS gf180mcu_fd_sc_mcu7t5v0__clkinv_1_32/I
+ gf180mcu_fd_sc_mcu7t5v0__clkinv_1_32/ZN VDD VSS gf180mcu_fd_sc_mcu7t5v0__clkinv_1
Xgf180mcu_fd_sc_mcu7t5v0__clkinv_1_10 VDD VSS gf180mcu_fd_sc_mcu7t5v0__buf_4_9/I gf180mcu_fd_sc_mcu7t5v0__oai22_1_2/A2
+ VDD VSS gf180mcu_fd_sc_mcu7t5v0__clkinv_1
Xgf180mcu_fd_sc_mcu7t5v0__clkinv_1_21 VDD VSS gf180mcu_fd_sc_mcu7t5v0__clkinv_1_37/I
+ gf180mcu_fd_sc_mcu7t5v0__dffnrnq_1_6/RN VDD VSS gf180mcu_fd_sc_mcu7t5v0__clkinv_1
Xgf180mcu_fd_sc_mcu7t5v0__fillcap_4_40 VDD VSS VDD VSS gf180mcu_fd_sc_mcu7t5v0__fillcap_4
Xgf180mcu_fd_sc_mcu7t5v0__fillcap_4_62 VDD VSS VDD VSS gf180mcu_fd_sc_mcu7t5v0__fillcap_4
Xgf180mcu_fd_sc_mcu7t5v0__fillcap_4_51 VDD VSS VDD VSS gf180mcu_fd_sc_mcu7t5v0__fillcap_4
Xgf180mcu_fd_sc_mcu7t5v0__fillcap_4_73 VDD VSS VDD VSS gf180mcu_fd_sc_mcu7t5v0__fillcap_4
Xgf180mcu_fd_sc_mcu7t5v0__fillcap_64_4 VDD VSS VDD VSS gf180mcu_fd_sc_mcu7t5v0__fillcap_64
Xgf180mcu_fd_sc_mcu7t5v0__fillcap_4_95 VDD VSS VDD VSS gf180mcu_fd_sc_mcu7t5v0__fillcap_4
Xgf180mcu_fd_sc_mcu7t5v0__fillcap_4_84 VDD VSS VDD VSS gf180mcu_fd_sc_mcu7t5v0__fillcap_4
Xgf180mcu_fd_sc_mcu7t5v0__fillcap_4_181 VDD VSS VDD VSS gf180mcu_fd_sc_mcu7t5v0__fillcap_4
Xgf180mcu_fd_sc_mcu7t5v0__fillcap_4_192 VDD VSS VDD VSS gf180mcu_fd_sc_mcu7t5v0__fillcap_4
Xgf180mcu_fd_sc_mcu7t5v0__fillcap_4_170 VDD VSS VDD VSS gf180mcu_fd_sc_mcu7t5v0__fillcap_4
Xgf180mcu_fd_sc_mcu7t5v0__fillcap_64_79 VDD VSS VDD VSS gf180mcu_fd_sc_mcu7t5v0__fillcap_64
Xgf180mcu_fd_sc_mcu7t5v0__fillcap_64_35 VDD VSS VDD VSS gf180mcu_fd_sc_mcu7t5v0__fillcap_64
Xgf180mcu_fd_sc_mcu7t5v0__fillcap_64_46 VDD VSS VDD VSS gf180mcu_fd_sc_mcu7t5v0__fillcap_64
Xgf180mcu_fd_sc_mcu7t5v0__fillcap_64_68 VDD VSS VDD VSS gf180mcu_fd_sc_mcu7t5v0__fillcap_64
Xgf180mcu_fd_sc_mcu7t5v0__fillcap_64_57 VDD VSS VDD VSS gf180mcu_fd_sc_mcu7t5v0__fillcap_64
Xgf180mcu_fd_sc_mcu7t5v0__fillcap_64_24 VDD VSS VDD VSS gf180mcu_fd_sc_mcu7t5v0__fillcap_64
Xgf180mcu_fd_sc_mcu7t5v0__fillcap_64_13 VDD VSS VDD VSS gf180mcu_fd_sc_mcu7t5v0__fillcap_64
Xgf180mcu_fd_sc_mcu7t5v0__clkbuf_8_17 gf180mcu_fd_sc_mcu7t5v0__clkbuf_8_17/Z VSS VDD
+ gf180mcu_fd_sc_mcu7t5v0__clkbuf_8_22/I VDD VSS gf180mcu_fd_sc_mcu7t5v0__clkbuf_8
Xgf180mcu_fd_sc_mcu7t5v0__clkbuf_8_28 gf180mcu_fd_sc_mcu7t5v0__clkinv_1_3/I VSS VDD
+ gf180mcu_fd_sc_mcu7t5v0__clkbuf_8_6/I VDD VSS gf180mcu_fd_sc_mcu7t5v0__clkbuf_8
Xgf180mcu_fd_sc_mcu7t5v0__fillcap_4_6 VDD VSS VDD VSS gf180mcu_fd_sc_mcu7t5v0__fillcap_4
Xgf180mcu_fd_sc_mcu7t5v0__dffnrnq_1_4 gf180mcu_fd_sc_mcu7t5v0__oai21_1_1/ZN VSS gf180mcu_fd_sc_mcu7t5v0__clkbuf_2_2/I
+ gf180mcu_fd_sc_mcu7t5v0__dffnrnq_1_4/RN gf180mcu_fd_sc_mcu7t5v0__buf_4_10/I VDD
+ VDD VSS gf180mcu_fd_sc_mcu7t5v0__dffnrnq_1
Xgf180mcu_fd_sc_mcu7t5v0__buf_2_10 VSS gf180mcu_fd_sc_mcu7t5v0__buf_2_10/Z gf180mcu_fd_sc_mcu7t5v0__buf_2_6/Z
+ VDD VDD VSS gf180mcu_fd_sc_mcu7t5v0__buf_2
Xgf180mcu_fd_sc_mcu7t5v0__fillcap_32_2 VDD VSS VDD VSS gf180mcu_fd_sc_mcu7t5v0__fillcap_32
Xgf180mcu_fd_sc_mcu7t5v0__dffnq_1_6 gf180mcu_fd_sc_mcu7t5v0__clkbuf_8_3/Z VDD VSS
+ gf180mcu_fd_sc_mcu7t5v0__dffnq_1_6/D gf180mcu_fd_sc_mcu7t5v0__buf_4_9/I VDD VSS
+ gf180mcu_fd_sc_mcu7t5v0__dffnq_1
Xgf180mcu_fd_sc_mcu7t5v0__clkbuf_2_4 gf180mcu_fd_sc_mcu7t5v0__clkbuf_2_4/Z VSS VDD
+ gf180mcu_fd_sc_mcu7t5v0__clkbuf_2_4/I VDD VSS gf180mcu_fd_sc_mcu7t5v0__clkbuf_2
Xgf180mcu_fd_sc_mcu7t5v0__oai31_1_5 VDD gf180mcu_fd_sc_mcu7t5v0__oai31_1_5/ZN gf180mcu_fd_sc_mcu7t5v0__buf_4_5/I
+ gf180mcu_fd_sc_mcu7t5v0__buf_1_15/Z gf180mcu_fd_sc_mcu7t5v0__oai31_1_5/A2 VSS gf180mcu_fd_sc_mcu7t5v0__buf_1_0/Z
+ VDD VSS gf180mcu_fd_sc_mcu7t5v0__oai31_1
Xgf180mcu_fd_sc_mcu7t5v0__and4_1_3 gf180mcu_fd_sc_mcu7t5v0__buf_1_8/Z gf180mcu_fd_sc_mcu7t5v0__buf_4_19/I
+ VDD VSS gf180mcu_fd_sc_mcu7t5v0__and4_1_3/Z gf180mcu_fd_sc_mcu7t5v0__buf_1_9/Z gf180mcu_fd_sc_mcu7t5v0__buf_1_24/Z
+ VDD VSS gf180mcu_fd_sc_mcu7t5v0__and4_1
Xgf180mcu_fd_sc_mcu7t5v0__nand2_1_15 VDD VSS gf180mcu_fd_sc_mcu7t5v0__oai31_2_1/A3
+ gf180mcu_fd_sc_mcu7t5v0__oai22_1_7/A1 gf180mcu_fd_sc_mcu7t5v0__or4_1_0/A3 VDD VSS
+ gf180mcu_fd_sc_mcu7t5v0__nand2_1
Xgf180mcu_fd_sc_mcu7t5v0__oai22_1_5 gf180mcu_fd_sc_mcu7t5v0__oai22_1_5/A2 gf180mcu_fd_sc_mcu7t5v0__buf_2_0/Z
+ gf180mcu_fd_sc_mcu7t5v0__oai22_1_5/B2 VDD VSS gf180mcu_fd_sc_mcu7t5v0__dffnq_1_7/D
+ gf180mcu_fd_sc_mcu7t5v0__buf_4_24/Z VDD VSS gf180mcu_fd_sc_mcu7t5v0__oai22_1
Xgf180mcu_fd_sc_mcu7t5v0__buf_1_5 VSS gf180mcu_fd_sc_mcu7t5v0__buf_1_5/Z gf180mcu_fd_sc_mcu7t5v0__buf_1_9/I
+ VDD VDD VSS gf180mcu_fd_sc_mcu7t5v0__buf_1
Xgf180mcu_fd_sc_mcu7t5v0__fillcap_32_82 VDD VSS VDD VSS gf180mcu_fd_sc_mcu7t5v0__fillcap_32
Xgf180mcu_fd_sc_mcu7t5v0__fillcap_32_60 VDD VSS VDD VSS gf180mcu_fd_sc_mcu7t5v0__fillcap_32
Xgf180mcu_fd_sc_mcu7t5v0__fillcap_32_71 VDD VSS VDD VSS gf180mcu_fd_sc_mcu7t5v0__fillcap_32
Xgf180mcu_fd_sc_mcu7t5v0__clkinv_1_33 VDD VSS gf180mcu_fd_sc_mcu7t5v0__buf_4_20/I
+ gf180mcu_fd_sc_mcu7t5v0__or4_1_0/A4 VDD VSS gf180mcu_fd_sc_mcu7t5v0__clkinv_1
Xgf180mcu_fd_sc_mcu7t5v0__clkinv_1_44 VDD VSS gf180mcu_fd_sc_mcu7t5v0__clkinv_1_46/I
+ gf180mcu_fd_sc_mcu7t5v0__clkinv_1_44/ZN VDD VSS gf180mcu_fd_sc_mcu7t5v0__clkinv_1
Xgf180mcu_fd_sc_mcu7t5v0__clkinv_1_22 VDD VSS gf180mcu_fd_sc_mcu7t5v0__clkinv_1_22/I
+ gf180mcu_fd_sc_mcu7t5v0__clkinv_1_22/ZN VDD VSS gf180mcu_fd_sc_mcu7t5v0__clkinv_1
Xgf180mcu_fd_sc_mcu7t5v0__clkinv_1_11 VDD VSS gf180mcu_fd_sc_mcu7t5v0__clkbuf_8_9/Z
+ gf180mcu_fd_sc_mcu7t5v0__nand2_1_3/A2 VDD VSS gf180mcu_fd_sc_mcu7t5v0__clkinv_1
Xgf180mcu_fd_sc_mcu7t5v0__fillcap_64_5 VDD VSS VDD VSS gf180mcu_fd_sc_mcu7t5v0__fillcap_64
Xgf180mcu_fd_sc_mcu7t5v0__fillcap_4_96 VDD VSS VDD VSS gf180mcu_fd_sc_mcu7t5v0__fillcap_4
Xgf180mcu_fd_sc_mcu7t5v0__fillcap_4_41 VDD VSS VDD VSS gf180mcu_fd_sc_mcu7t5v0__fillcap_4
Xgf180mcu_fd_sc_mcu7t5v0__fillcap_4_63 VDD VSS VDD VSS gf180mcu_fd_sc_mcu7t5v0__fillcap_4
Xgf180mcu_fd_sc_mcu7t5v0__fillcap_4_52 VDD VSS VDD VSS gf180mcu_fd_sc_mcu7t5v0__fillcap_4
Xgf180mcu_fd_sc_mcu7t5v0__fillcap_4_85 VDD VSS VDD VSS gf180mcu_fd_sc_mcu7t5v0__fillcap_4
Xgf180mcu_fd_sc_mcu7t5v0__fillcap_4_30 VDD VSS VDD VSS gf180mcu_fd_sc_mcu7t5v0__fillcap_4
Xgf180mcu_fd_sc_mcu7t5v0__fillcap_4_74 VDD VSS VDD VSS gf180mcu_fd_sc_mcu7t5v0__fillcap_4
Xgf180mcu_fd_sc_mcu7t5v0__fillcap_4_182 VDD VSS VDD VSS gf180mcu_fd_sc_mcu7t5v0__fillcap_4
Xgf180mcu_fd_sc_mcu7t5v0__fillcap_4_193 VDD VSS VDD VSS gf180mcu_fd_sc_mcu7t5v0__fillcap_4
Xgf180mcu_fd_sc_mcu7t5v0__fillcap_4_160 VDD VSS VDD VSS gf180mcu_fd_sc_mcu7t5v0__fillcap_4
Xgf180mcu_fd_sc_mcu7t5v0__fillcap_4_171 VDD VSS VDD VSS gf180mcu_fd_sc_mcu7t5v0__fillcap_4
Xgf180mcu_fd_sc_mcu7t5v0__fillcap_64_36 VDD VSS VDD VSS gf180mcu_fd_sc_mcu7t5v0__fillcap_64
Xgf180mcu_fd_sc_mcu7t5v0__fillcap_64_14 VDD VSS VDD VSS gf180mcu_fd_sc_mcu7t5v0__fillcap_64
Xgf180mcu_fd_sc_mcu7t5v0__fillcap_64_25 VDD VSS VDD VSS gf180mcu_fd_sc_mcu7t5v0__fillcap_64
Xgf180mcu_fd_sc_mcu7t5v0__fillcap_64_58 VDD VSS VDD VSS gf180mcu_fd_sc_mcu7t5v0__fillcap_64
Xgf180mcu_fd_sc_mcu7t5v0__fillcap_64_47 VDD VSS VDD VSS gf180mcu_fd_sc_mcu7t5v0__fillcap_64
Xgf180mcu_fd_sc_mcu7t5v0__fillcap_64_69 VDD VSS VDD VSS gf180mcu_fd_sc_mcu7t5v0__fillcap_64
Xgf180mcu_fd_sc_mcu7t5v0__clkbuf_8_18 gf180mcu_fd_sc_mcu7t5v0__clkbuf_8_18/Z VSS VDD
+ gf180mcu_fd_sc_mcu7t5v0__clkbuf_8_22/I VDD VSS gf180mcu_fd_sc_mcu7t5v0__clkbuf_8
Xgf180mcu_fd_sc_mcu7t5v0__clkbuf_8_29 gf180mcu_fd_sc_mcu7t5v0__clkinv_1_45/I VSS VDD
+ gf180mcu_fd_sc_mcu7t5v0__clkbuf_8_29/I VDD VSS gf180mcu_fd_sc_mcu7t5v0__clkbuf_8
Xgf180mcu_fd_sc_mcu7t5v0__fillcap_4_7 VDD VSS VDD VSS gf180mcu_fd_sc_mcu7t5v0__fillcap_4
Xgf180mcu_fd_sc_mcu7t5v0__dffnrnq_1_5 gf180mcu_fd_sc_mcu7t5v0__nand2_1_14/ZN VSS gf180mcu_fd_sc_mcu7t5v0__clkbuf_8_8/Z
+ gf180mcu_fd_sc_mcu7t5v0__dffnrnq_1_5/RN gf180mcu_fd_sc_mcu7t5v0__buf_4_11/I VDD
+ VDD VSS gf180mcu_fd_sc_mcu7t5v0__dffnrnq_1
Xgf180mcu_fd_sc_mcu7t5v0__buf_2_11 VSS gf180mcu_fd_sc_mcu7t5v0__buf_2_6/I gf180mcu_fd_sc_mcu7t5v0__buf_1_3/I
+ VDD VDD VSS gf180mcu_fd_sc_mcu7t5v0__buf_2
Xgf180mcu_fd_sc_mcu7t5v0__fillcap_32_3 VDD VSS VDD VSS gf180mcu_fd_sc_mcu7t5v0__fillcap_32
Xgf180mcu_fd_sc_mcu7t5v0__dffnq_1_7 gf180mcu_fd_sc_mcu7t5v0__clkbuf_8_4/Z VDD VSS
+ gf180mcu_fd_sc_mcu7t5v0__dffnq_1_7/D gf180mcu_fd_sc_mcu7t5v0__buf_4_1/I VDD VSS
+ gf180mcu_fd_sc_mcu7t5v0__dffnq_1
Xgf180mcu_fd_sc_mcu7t5v0__clkbuf_2_5 gf180mcu_fd_sc_mcu7t5v0__clkbuf_2_5/Z VSS VDD
+ gf180mcu_fd_sc_mcu7t5v0__clkbuf_8_1/Z VDD VSS gf180mcu_fd_sc_mcu7t5v0__clkbuf_2
Xgf180mcu_fd_sc_mcu7t5v0__oai31_1_6 VDD gf180mcu_fd_sc_mcu7t5v0__oai31_1_1/B gf180mcu_fd_sc_mcu7t5v0__buf_4_25/I
+ gf180mcu_fd_sc_mcu7t5v0__buf_1_2/Z gf180mcu_fd_sc_mcu7t5v0__or4_1_2/A4 VSS gf180mcu_fd_sc_mcu7t5v0__buf_1_6/Z
+ VDD VSS gf180mcu_fd_sc_mcu7t5v0__oai31_1
Xgf180mcu_fd_sc_mcu7t5v0__and4_1_4 gf180mcu_fd_sc_mcu7t5v0__buf_1_13/Z gf180mcu_fd_sc_mcu7t5v0__buf_4_21/I
+ VDD VSS gf180mcu_fd_sc_mcu7t5v0__and4_1_4/Z gf180mcu_fd_sc_mcu7t5v0__or3_2_0/A3
+ gf180mcu_fd_sc_mcu7t5v0__buf_1_17/Z VDD VSS gf180mcu_fd_sc_mcu7t5v0__and4_1
Xgf180mcu_fd_sc_mcu7t5v0__nand2_1_16 VDD VSS gf180mcu_fd_sc_mcu7t5v0__oai22_1_1/B2
+ gf180mcu_fd_sc_mcu7t5v0__and4_1_1/Z gf180mcu_fd_sc_mcu7t5v0__nand2_1_16/A2 VDD VSS
+ gf180mcu_fd_sc_mcu7t5v0__nand2_1
Xgf180mcu_fd_sc_mcu7t5v0__buf_1_6 VSS gf180mcu_fd_sc_mcu7t5v0__buf_1_6/Z gf180mcu_fd_sc_mcu7t5v0__buf_1_6/I
+ VDD VDD VSS gf180mcu_fd_sc_mcu7t5v0__buf_1
Xgf180mcu_fd_sc_mcu7t5v0__oai22_1_6 gf180mcu_fd_sc_mcu7t5v0__oai22_1_6/A2 gf180mcu_fd_sc_mcu7t5v0__buf_2_2/Z
+ gf180mcu_fd_sc_mcu7t5v0__oai22_1_6/B2 VDD VSS gf180mcu_fd_sc_mcu7t5v0__dffnq_1_3/D
+ gf180mcu_fd_sc_mcu7t5v0__buf_4_24/Z VDD VSS gf180mcu_fd_sc_mcu7t5v0__oai22_1
Xgf180mcu_fd_sc_mcu7t5v0__fillcap_16_40 VDD VSS VDD VSS gf180mcu_fd_sc_mcu7t5v0__fillcap_16
Xgf180mcu_fd_sc_mcu7t5v0__fillcap_32_83 VDD VSS VDD VSS gf180mcu_fd_sc_mcu7t5v0__fillcap_32
Xgf180mcu_fd_sc_mcu7t5v0__fillcap_32_61 VDD VSS VDD VSS gf180mcu_fd_sc_mcu7t5v0__fillcap_32
Xgf180mcu_fd_sc_mcu7t5v0__fillcap_32_72 VDD VSS VDD VSS gf180mcu_fd_sc_mcu7t5v0__fillcap_32
Xgf180mcu_fd_sc_mcu7t5v0__fillcap_32_50 VDD VSS VDD VSS gf180mcu_fd_sc_mcu7t5v0__fillcap_32
Xgf180mcu_fd_sc_mcu7t5v0__clkinv_1_45 VDD VSS gf180mcu_fd_sc_mcu7t5v0__clkinv_1_45/I
+ gf180mcu_fd_sc_mcu7t5v0__clkinv_1_45/ZN VDD VSS gf180mcu_fd_sc_mcu7t5v0__clkinv_1
Xgf180mcu_fd_sc_mcu7t5v0__clkinv_1_34 VDD VSS gf180mcu_fd_sc_mcu7t5v0__clkinv_1_36/I
+ gf180mcu_fd_sc_mcu7t5v0__clkinv_1_34/ZN VDD VSS gf180mcu_fd_sc_mcu7t5v0__clkinv_1
Xgf180mcu_fd_sc_mcu7t5v0__clkinv_1_23 VDD VSS gf180mcu_fd_sc_mcu7t5v0__or3_2_0/A2
+ gf180mcu_fd_sc_mcu7t5v0__buf_1_30/I VDD VSS gf180mcu_fd_sc_mcu7t5v0__clkinv_1
Xgf180mcu_fd_sc_mcu7t5v0__clkinv_1_12 VDD VSS gf180mcu_fd_sc_mcu7t5v0__buf_4_8/I gf180mcu_fd_sc_mcu7t5v0__oai22_1_3/A2
+ VDD VSS gf180mcu_fd_sc_mcu7t5v0__clkinv_1
Xgf180mcu_fd_sc_mcu7t5v0__fillcap_64_6 VDD VSS VDD VSS gf180mcu_fd_sc_mcu7t5v0__fillcap_64
Xgf180mcu_fd_sc_mcu7t5v0__fillcap_4_42 VDD VSS VDD VSS gf180mcu_fd_sc_mcu7t5v0__fillcap_4
Xgf180mcu_fd_sc_mcu7t5v0__fillcap_4_97 VDD VSS VDD VSS gf180mcu_fd_sc_mcu7t5v0__fillcap_4
Xgf180mcu_fd_sc_mcu7t5v0__fillcap_4_64 VDD VSS VDD VSS gf180mcu_fd_sc_mcu7t5v0__fillcap_4
Xgf180mcu_fd_sc_mcu7t5v0__fillcap_4_53 VDD VSS VDD VSS gf180mcu_fd_sc_mcu7t5v0__fillcap_4
Xgf180mcu_fd_sc_mcu7t5v0__fillcap_4_75 VDD VSS VDD VSS gf180mcu_fd_sc_mcu7t5v0__fillcap_4
Xgf180mcu_fd_sc_mcu7t5v0__fillcap_4_86 VDD VSS VDD VSS gf180mcu_fd_sc_mcu7t5v0__fillcap_4
Xgf180mcu_fd_sc_mcu7t5v0__fillcap_4_20 VDD VSS VDD VSS gf180mcu_fd_sc_mcu7t5v0__fillcap_4
Xgf180mcu_fd_sc_mcu7t5v0__fillcap_4_31 VDD VSS VDD VSS gf180mcu_fd_sc_mcu7t5v0__fillcap_4
Xgf180mcu_fd_sc_mcu7t5v0__fillcap_4_183 VDD VSS VDD VSS gf180mcu_fd_sc_mcu7t5v0__fillcap_4
Xgf180mcu_fd_sc_mcu7t5v0__fillcap_4_161 VDD VSS VDD VSS gf180mcu_fd_sc_mcu7t5v0__fillcap_4
Xgf180mcu_fd_sc_mcu7t5v0__fillcap_4_172 VDD VSS VDD VSS gf180mcu_fd_sc_mcu7t5v0__fillcap_4
Xgf180mcu_fd_sc_mcu7t5v0__fillcap_4_150 VDD VSS VDD VSS gf180mcu_fd_sc_mcu7t5v0__fillcap_4
Xgf180mcu_fd_sc_mcu7t5v0__fillcap_4_194 VDD VSS VDD VSS gf180mcu_fd_sc_mcu7t5v0__fillcap_4
Xgf180mcu_fd_sc_mcu7t5v0__fillcap_64_59 VDD VSS VDD VSS gf180mcu_fd_sc_mcu7t5v0__fillcap_64
Xgf180mcu_fd_sc_mcu7t5v0__fillcap_64_37 VDD VSS VDD VSS gf180mcu_fd_sc_mcu7t5v0__fillcap_64
Xgf180mcu_fd_sc_mcu7t5v0__fillcap_64_48 VDD VSS VDD VSS gf180mcu_fd_sc_mcu7t5v0__fillcap_64
Xgf180mcu_fd_sc_mcu7t5v0__fillcap_64_26 VDD VSS VDD VSS gf180mcu_fd_sc_mcu7t5v0__fillcap_64
Xgf180mcu_fd_sc_mcu7t5v0__fillcap_64_15 VDD VSS VDD VSS gf180mcu_fd_sc_mcu7t5v0__fillcap_64
Xgf180mcu_fd_sc_mcu7t5v0__clkbuf_8_19 gf180mcu_fd_sc_mcu7t5v0__clkbuf_8_19/Z VSS VDD
+ gf180mcu_fd_sc_mcu7t5v0__clkbuf_8_8/I VDD VSS gf180mcu_fd_sc_mcu7t5v0__clkbuf_8
Xgf180mcu_fd_sc_mcu7t5v0__fillcap_4_8 VDD VSS VDD VSS gf180mcu_fd_sc_mcu7t5v0__fillcap_4
Xgf180mcu_fd_sc_mcu7t5v0__dffnrnq_1_6 gf180mcu_fd_sc_mcu7t5v0__aoi21_1_0/ZN VSS gf180mcu_fd_sc_mcu7t5v0__clkbuf_2_3/I
+ gf180mcu_fd_sc_mcu7t5v0__dffnrnq_1_6/RN gf180mcu_fd_sc_mcu7t5v0__buf_1_10/I VDD
+ VDD VSS gf180mcu_fd_sc_mcu7t5v0__dffnrnq_1
Xgf180mcu_fd_sc_mcu7t5v0__fillcap_32_4 VDD VSS VDD VSS gf180mcu_fd_sc_mcu7t5v0__fillcap_32
Xgf180mcu_fd_sc_mcu7t5v0__buf_2_12 VSS gf180mcu_fd_sc_mcu7t5v0__or2_1_0/A2 gf180mcu_fd_sc_mcu7t5v0__buf_2_12/I
+ VDD VDD VSS gf180mcu_fd_sc_mcu7t5v0__buf_2
Xgf180mcu_fd_sc_mcu7t5v0__clkbuf_2_6 gf180mcu_fd_sc_mcu7t5v0__oai31_1_3/A1 VSS VDD
+ gf180mcu_fd_sc_mcu7t5v0__buf_1_16/Z VDD VSS gf180mcu_fd_sc_mcu7t5v0__clkbuf_2
Xgf180mcu_fd_sc_mcu7t5v0__oai31_1_7 VDD gf180mcu_fd_sc_mcu7t5v0__oai31_1_7/ZN gf180mcu_fd_sc_mcu7t5v0__buf_4_19/I
+ gf180mcu_fd_sc_mcu7t5v0__buf_1_37/Z gf180mcu_fd_sc_mcu7t5v0__buf_1_34/Z VSS gf180mcu_fd_sc_mcu7t5v0__oai31_2_1/A3
+ VDD VSS gf180mcu_fd_sc_mcu7t5v0__oai31_1
Xgf180mcu_fd_sc_mcu7t5v0__nand2_1_17 VDD VSS gf180mcu_fd_sc_mcu7t5v0__aoi21_1_3/A1
+ gf180mcu_fd_sc_mcu7t5v0__buf_4_15/Z gf180mcu_fd_sc_mcu7t5v0__buf_4_14/Z VDD VSS
+ gf180mcu_fd_sc_mcu7t5v0__nand2_1
Xgf180mcu_fd_sc_mcu7t5v0__and4_1_5 gf180mcu_fd_sc_mcu7t5v0__buf_1_8/I gf180mcu_fd_sc_mcu7t5v0__buf_4_3/I
+ VDD VSS gf180mcu_fd_sc_mcu7t5v0__and4_1_5/Z gf180mcu_fd_sc_mcu7t5v0__buf_1_5/Z gf180mcu_fd_sc_mcu7t5v0__buf_1_24/I
+ VDD VSS gf180mcu_fd_sc_mcu7t5v0__and4_1
Xgf180mcu_fd_sc_mcu7t5v0__buf_1_7 VSS gf180mcu_fd_sc_mcu7t5v0__buf_1_7/Z gf180mcu_fd_sc_mcu7t5v0__buf_1_7/I
+ VDD VDD VSS gf180mcu_fd_sc_mcu7t5v0__buf_1
Xgf180mcu_fd_sc_mcu7t5v0__oai22_1_7 gf180mcu_fd_sc_mcu7t5v0__aoi21_1_0/B gf180mcu_fd_sc_mcu7t5v0__buf_2_13/Z
+ gf180mcu_fd_sc_mcu7t5v0__buf_1_15/Z VDD VSS gf180mcu_fd_sc_mcu7t5v0__oai22_1_7/ZN
+ gf180mcu_fd_sc_mcu7t5v0__oai22_1_7/A1 VDD VSS gf180mcu_fd_sc_mcu7t5v0__oai22_1
Xgf180mcu_fd_sc_mcu7t5v0__fillcap_16_30 VDD VSS VDD VSS gf180mcu_fd_sc_mcu7t5v0__fillcap_16
Xgf180mcu_fd_sc_mcu7t5v0__fillcap_16_41 VDD VSS VDD VSS gf180mcu_fd_sc_mcu7t5v0__fillcap_16
Xgf180mcu_fd_sc_mcu7t5v0__fillcap_32_62 VDD VSS VDD VSS gf180mcu_fd_sc_mcu7t5v0__fillcap_32
Xgf180mcu_fd_sc_mcu7t5v0__fillcap_32_84 VDD VSS VDD VSS gf180mcu_fd_sc_mcu7t5v0__fillcap_32
Xgf180mcu_fd_sc_mcu7t5v0__fillcap_32_51 VDD VSS VDD VSS gf180mcu_fd_sc_mcu7t5v0__fillcap_32
Xgf180mcu_fd_sc_mcu7t5v0__fillcap_32_73 VDD VSS VDD VSS gf180mcu_fd_sc_mcu7t5v0__fillcap_32
Xgf180mcu_fd_sc_mcu7t5v0__fillcap_32_40 VDD VSS VDD VSS gf180mcu_fd_sc_mcu7t5v0__fillcap_32
Xgf180mcu_fd_sc_mcu7t5v0__clkinv_1_46 VDD VSS gf180mcu_fd_sc_mcu7t5v0__clkinv_1_46/I
+ gf180mcu_fd_sc_mcu7t5v0__dffrnq_2_1/RN VDD VSS gf180mcu_fd_sc_mcu7t5v0__clkinv_1
Xgf180mcu_fd_sc_mcu7t5v0__clkinv_1_35 VDD VSS gf180mcu_fd_sc_mcu7t5v0__buf_1_26/I
+ gf180mcu_fd_sc_mcu7t5v0__dffrnq_2_0/D VDD VSS gf180mcu_fd_sc_mcu7t5v0__clkinv_1
Xgf180mcu_fd_sc_mcu7t5v0__clkinv_1_24 VDD VSS gf180mcu_fd_sc_mcu7t5v0__or3_2_0/A3
+ gf180mcu_fd_sc_mcu7t5v0__oai21_1_8/B VDD VSS gf180mcu_fd_sc_mcu7t5v0__clkinv_1
Xgf180mcu_fd_sc_mcu7t5v0__clkinv_1_13 VDD VSS gf180mcu_fd_sc_mcu7t5v0__buf_4_6/I gf180mcu_fd_sc_mcu7t5v0__oai22_1_4/A2
+ VDD VSS gf180mcu_fd_sc_mcu7t5v0__clkinv_1
Xgf180mcu_fd_sc_mcu7t5v0__fillcap_4_10 VDD VSS VDD VSS gf180mcu_fd_sc_mcu7t5v0__fillcap_4
Xgf180mcu_fd_sc_mcu7t5v0__fillcap_64_7 VDD VSS VDD VSS gf180mcu_fd_sc_mcu7t5v0__fillcap_64
Xgf180mcu_fd_sc_mcu7t5v0__fillcap_4_21 VDD VSS VDD VSS gf180mcu_fd_sc_mcu7t5v0__fillcap_4
Xgf180mcu_fd_sc_mcu7t5v0__fillcap_4_98 VDD VSS VDD VSS gf180mcu_fd_sc_mcu7t5v0__fillcap_4
Xgf180mcu_fd_sc_mcu7t5v0__fillcap_4_54 VDD VSS VDD VSS gf180mcu_fd_sc_mcu7t5v0__fillcap_4
Xgf180mcu_fd_sc_mcu7t5v0__fillcap_4_65 VDD VSS VDD VSS gf180mcu_fd_sc_mcu7t5v0__fillcap_4
Xgf180mcu_fd_sc_mcu7t5v0__fillcap_4_87 VDD VSS VDD VSS gf180mcu_fd_sc_mcu7t5v0__fillcap_4
Xgf180mcu_fd_sc_mcu7t5v0__fillcap_4_76 VDD VSS VDD VSS gf180mcu_fd_sc_mcu7t5v0__fillcap_4
Xgf180mcu_fd_sc_mcu7t5v0__fillcap_4_32 VDD VSS VDD VSS gf180mcu_fd_sc_mcu7t5v0__fillcap_4
Xgf180mcu_fd_sc_mcu7t5v0__fillcap_4_43 VDD VSS VDD VSS gf180mcu_fd_sc_mcu7t5v0__fillcap_4
Xgf180mcu_fd_sc_mcu7t5v0__fillcap_4_195 VDD VSS VDD VSS gf180mcu_fd_sc_mcu7t5v0__fillcap_4
Xgf180mcu_fd_sc_mcu7t5v0__fillcap_4_173 VDD VSS VDD VSS gf180mcu_fd_sc_mcu7t5v0__fillcap_4
Xgf180mcu_fd_sc_mcu7t5v0__fillcap_4_140 VDD VSS VDD VSS gf180mcu_fd_sc_mcu7t5v0__fillcap_4
Xgf180mcu_fd_sc_mcu7t5v0__fillcap_4_184 VDD VSS VDD VSS gf180mcu_fd_sc_mcu7t5v0__fillcap_4
Xgf180mcu_fd_sc_mcu7t5v0__fillcap_4_162 VDD VSS VDD VSS gf180mcu_fd_sc_mcu7t5v0__fillcap_4
Xgf180mcu_fd_sc_mcu7t5v0__fillcap_4_151 VDD VSS VDD VSS gf180mcu_fd_sc_mcu7t5v0__fillcap_4
Xgf180mcu_fd_sc_mcu7t5v0__fillcap_64_38 VDD VSS VDD VSS gf180mcu_fd_sc_mcu7t5v0__fillcap_64
Xgf180mcu_fd_sc_mcu7t5v0__fillcap_64_49 VDD VSS VDD VSS gf180mcu_fd_sc_mcu7t5v0__fillcap_64
Xgf180mcu_fd_sc_mcu7t5v0__fillcap_64_16 VDD VSS VDD VSS gf180mcu_fd_sc_mcu7t5v0__fillcap_64
Xgf180mcu_fd_sc_mcu7t5v0__fillcap_64_27 VDD VSS VDD VSS gf180mcu_fd_sc_mcu7t5v0__fillcap_64
Xgf180mcu_fd_sc_mcu7t5v0__fillcap_4_9 VDD VSS VDD VSS gf180mcu_fd_sc_mcu7t5v0__fillcap_4
Xgf180mcu_fd_sc_mcu7t5v0__dffnrnq_1_7 gf180mcu_fd_sc_mcu7t5v0__oai21_1_3/ZN VSS gf180mcu_fd_sc_mcu7t5v0__clkbuf_2_8/I
+ gf180mcu_fd_sc_mcu7t5v0__dffnrnq_1_7/RN gf180mcu_fd_sc_mcu7t5v0__buf_1_44/I VDD
+ VDD VSS gf180mcu_fd_sc_mcu7t5v0__dffnrnq_1
Xgf180mcu_fd_sc_mcu7t5v0__fillcap_32_5 VDD VSS VDD VSS gf180mcu_fd_sc_mcu7t5v0__fillcap_32
Xgf180mcu_fd_sc_mcu7t5v0__buf_2_13 VSS gf180mcu_fd_sc_mcu7t5v0__buf_2_13/Z gf180mcu_fd_sc_mcu7t5v0__buf_2_4/Z
+ VDD VDD VSS gf180mcu_fd_sc_mcu7t5v0__buf_2
Xgf180mcu_fd_sc_mcu7t5v0__clkbuf_2_7 gf180mcu_fd_sc_mcu7t5v0__clkbuf_2_7/Z VSS VDD
+ gf180mcu_fd_sc_mcu7t5v0__nor3_1_0/A1 VDD VSS gf180mcu_fd_sc_mcu7t5v0__clkbuf_2
Xgf180mcu_fd_sc_mcu7t5v0__oai31_1_8 VDD gf180mcu_fd_sc_mcu7t5v0__oai31_1_8/ZN gf180mcu_fd_sc_mcu7t5v0__oai31_1_8/B
+ gf180mcu_fd_sc_mcu7t5v0__buf_1_32/Z gf180mcu_fd_sc_mcu7t5v0__buf_2_6/Z VSS gf180mcu_fd_sc_mcu7t5v0__buf_1_31/Z
+ VDD VSS gf180mcu_fd_sc_mcu7t5v0__oai31_1
Xgf180mcu_fd_sc_mcu7t5v0__nand2_1_18 VDD VSS gf180mcu_fd_sc_mcu7t5v0__buf_1_38/I gf180mcu_fd_sc_mcu7t5v0__oai21_1_8/B
+ gf180mcu_fd_sc_mcu7t5v0__buf_1_30/Z VDD VSS gf180mcu_fd_sc_mcu7t5v0__nand2_1
Xgf180mcu_fd_sc_mcu7t5v0__oai22_1_8 gf180mcu_fd_sc_mcu7t5v0__buf_2_7/I gf180mcu_fd_sc_mcu7t5v0__buf_1_42/Z
+ gf180mcu_fd_sc_mcu7t5v0__or2_1_0/A2 VDD VSS gf180mcu_fd_sc_mcu7t5v0__oai22_1_8/ZN
+ gf180mcu_fd_sc_mcu7t5v0__buf_1_40/Z VDD VSS gf180mcu_fd_sc_mcu7t5v0__oai22_1
Xgf180mcu_fd_sc_mcu7t5v0__buf_1_8 VSS gf180mcu_fd_sc_mcu7t5v0__buf_1_8/Z gf180mcu_fd_sc_mcu7t5v0__buf_1_8/I
+ VDD VDD VSS gf180mcu_fd_sc_mcu7t5v0__buf_1
Xgf180mcu_fd_sc_mcu7t5v0__fillcap_16_0 VDD VSS VDD VSS gf180mcu_fd_sc_mcu7t5v0__fillcap_16
Xgf180mcu_fd_sc_mcu7t5v0__fillcap_16_31 VDD VSS VDD VSS gf180mcu_fd_sc_mcu7t5v0__fillcap_16
Xgf180mcu_fd_sc_mcu7t5v0__fillcap_16_42 VDD VSS VDD VSS gf180mcu_fd_sc_mcu7t5v0__fillcap_16
Xgf180mcu_fd_sc_mcu7t5v0__fillcap_16_20 VDD VSS VDD VSS gf180mcu_fd_sc_mcu7t5v0__fillcap_16
Xgf180mcu_fd_sc_mcu7t5v0__fillcap_32_63 VDD VSS VDD VSS gf180mcu_fd_sc_mcu7t5v0__fillcap_32
Xgf180mcu_fd_sc_mcu7t5v0__fillcap_32_52 VDD VSS VDD VSS gf180mcu_fd_sc_mcu7t5v0__fillcap_32
Xgf180mcu_fd_sc_mcu7t5v0__fillcap_32_30 VDD VSS VDD VSS gf180mcu_fd_sc_mcu7t5v0__fillcap_32
Xgf180mcu_fd_sc_mcu7t5v0__fillcap_32_41 VDD VSS VDD VSS gf180mcu_fd_sc_mcu7t5v0__fillcap_32
Xgf180mcu_fd_sc_mcu7t5v0__fillcap_32_74 VDD VSS VDD VSS gf180mcu_fd_sc_mcu7t5v0__fillcap_32
Xgf180mcu_fd_sc_mcu7t5v0__fillcap_32_85 VDD VSS VDD VSS gf180mcu_fd_sc_mcu7t5v0__fillcap_32
Xgf180mcu_fd_sc_mcu7t5v0__clkinv_1_25 VDD VSS gf180mcu_fd_sc_mcu7t5v0__buf_1_12/Z
+ gf180mcu_fd_sc_mcu7t5v0__buf_1_20/I VDD VSS gf180mcu_fd_sc_mcu7t5v0__clkinv_1
Xgf180mcu_fd_sc_mcu7t5v0__clkinv_1_14 VDD VSS gf180mcu_fd_sc_mcu7t5v0__buf_4_7/I gf180mcu_fd_sc_mcu7t5v0__oai22_1_6/A2
+ VDD VSS gf180mcu_fd_sc_mcu7t5v0__clkinv_1
Xgf180mcu_fd_sc_mcu7t5v0__clkinv_1_47 VDD VSS gf180mcu_fd_sc_mcu7t5v0__buf_2_12/I
+ gf180mcu_fd_sc_mcu7t5v0__dffrnq_2_1/D VDD VSS gf180mcu_fd_sc_mcu7t5v0__clkinv_1
Xgf180mcu_fd_sc_mcu7t5v0__clkinv_1_36 VDD VSS gf180mcu_fd_sc_mcu7t5v0__clkinv_1_36/I
+ gf180mcu_fd_sc_mcu7t5v0__clkinv_1_36/ZN VDD VSS gf180mcu_fd_sc_mcu7t5v0__clkinv_1
Xgf180mcu_fd_sc_mcu7t5v0__fillcap_4_44 VDD VSS VDD VSS gf180mcu_fd_sc_mcu7t5v0__fillcap_4
Xgf180mcu_fd_sc_mcu7t5v0__fillcap_4_22 VDD VSS VDD VSS gf180mcu_fd_sc_mcu7t5v0__fillcap_4
Xgf180mcu_fd_sc_mcu7t5v0__fillcap_64_8 VDD VSS VDD VSS gf180mcu_fd_sc_mcu7t5v0__fillcap_64
Xgf180mcu_fd_sc_mcu7t5v0__fillcap_4_55 VDD VSS VDD VSS gf180mcu_fd_sc_mcu7t5v0__fillcap_4
Xgf180mcu_fd_sc_mcu7t5v0__fillcap_4_11 VDD VSS VDD VSS gf180mcu_fd_sc_mcu7t5v0__fillcap_4
Xgf180mcu_fd_sc_mcu7t5v0__fillcap_4_33 VDD VSS VDD VSS gf180mcu_fd_sc_mcu7t5v0__fillcap_4
Xgf180mcu_fd_sc_mcu7t5v0__fillcap_4_66 VDD VSS VDD VSS gf180mcu_fd_sc_mcu7t5v0__fillcap_4
Xgf180mcu_fd_sc_mcu7t5v0__fillcap_4_99 VDD VSS VDD VSS gf180mcu_fd_sc_mcu7t5v0__fillcap_4
Xgf180mcu_fd_sc_mcu7t5v0__fillcap_4_88 VDD VSS VDD VSS gf180mcu_fd_sc_mcu7t5v0__fillcap_4
Xgf180mcu_fd_sc_mcu7t5v0__fillcap_4_77 VDD VSS VDD VSS gf180mcu_fd_sc_mcu7t5v0__fillcap_4
Xgf180mcu_fd_sc_mcu7t5v0__fillcap_4_174 VDD VSS VDD VSS gf180mcu_fd_sc_mcu7t5v0__fillcap_4
Xgf180mcu_fd_sc_mcu7t5v0__fillcap_4_196 VDD VSS VDD VSS gf180mcu_fd_sc_mcu7t5v0__fillcap_4
Xgf180mcu_fd_sc_mcu7t5v0__fillcap_4_141 VDD VSS VDD VSS gf180mcu_fd_sc_mcu7t5v0__fillcap_4
Xgf180mcu_fd_sc_mcu7t5v0__fillcap_4_130 VDD VSS VDD VSS gf180mcu_fd_sc_mcu7t5v0__fillcap_4
Xgf180mcu_fd_sc_mcu7t5v0__fillcap_4_185 VDD VSS VDD VSS gf180mcu_fd_sc_mcu7t5v0__fillcap_4
Xgf180mcu_fd_sc_mcu7t5v0__fillcap_4_163 VDD VSS VDD VSS gf180mcu_fd_sc_mcu7t5v0__fillcap_4
Xgf180mcu_fd_sc_mcu7t5v0__fillcap_4_152 VDD VSS VDD VSS gf180mcu_fd_sc_mcu7t5v0__fillcap_4
Xgf180mcu_fd_sc_mcu7t5v0__fillcap_64_39 VDD VSS VDD VSS gf180mcu_fd_sc_mcu7t5v0__fillcap_64
Xgf180mcu_fd_sc_mcu7t5v0__fillcap_64_17 VDD VSS VDD VSS gf180mcu_fd_sc_mcu7t5v0__fillcap_64
Xgf180mcu_fd_sc_mcu7t5v0__fillcap_64_28 VDD VSS VDD VSS gf180mcu_fd_sc_mcu7t5v0__fillcap_64
Xgf180mcu_fd_sc_mcu7t5v0__dffnrnq_1_8 gf180mcu_fd_sc_mcu7t5v0__oai21_1_8/ZN VSS gf180mcu_fd_sc_mcu7t5v0__clkbuf_8_8/Z
+ gf180mcu_fd_sc_mcu7t5v0__dffnrnq_1_8/RN gf180mcu_fd_sc_mcu7t5v0__buf_1_29/I VDD
+ VDD VSS gf180mcu_fd_sc_mcu7t5v0__dffnrnq_1
Xgf180mcu_fd_sc_mcu7t5v0__fillcap_32_6 VDD VSS VDD VSS gf180mcu_fd_sc_mcu7t5v0__fillcap_32
Xgf180mcu_fd_sc_mcu7t5v0__buf_2_14 VSS gf180mcu_fd_sc_mcu7t5v0__buf_2_14/Z gf180mcu_fd_sc_mcu7t5v0__or2_1_0/Z
+ VDD VDD VSS gf180mcu_fd_sc_mcu7t5v0__buf_2
Xgf180mcu_fd_sc_mcu7t5v0__clkbuf_2_8 gf180mcu_fd_sc_mcu7t5v0__clkbuf_2_8/Z VSS VDD
+ gf180mcu_fd_sc_mcu7t5v0__clkbuf_2_8/I VDD VSS gf180mcu_fd_sc_mcu7t5v0__clkbuf_2
Xgf180mcu_fd_sc_mcu7t5v0__oai31_1_9 VDD gf180mcu_fd_sc_mcu7t5v0__oai31_1_8/B gf180mcu_fd_sc_mcu7t5v0__buf_4_22/I
+ gf180mcu_fd_sc_mcu7t5v0__buf_2_5/Z gf180mcu_fd_sc_mcu7t5v0__buf_1_32/Z VSS gf180mcu_fd_sc_mcu7t5v0__buf_1_31/Z
+ VDD VSS gf180mcu_fd_sc_mcu7t5v0__oai31_1
Xgf180mcu_fd_sc_mcu7t5v0__nand2_1_19 VDD VSS gf180mcu_fd_sc_mcu7t5v0__aoi21_1_3/A2
+ gf180mcu_fd_sc_mcu7t5v0__buf_2_14/Z gf180mcu_fd_sc_mcu7t5v0__buf_2_8/Z VDD VSS gf180mcu_fd_sc_mcu7t5v0__nand2_1
Xgf180mcu_fd_sc_mcu7t5v0__buf_1_9 VSS gf180mcu_fd_sc_mcu7t5v0__buf_1_9/Z gf180mcu_fd_sc_mcu7t5v0__buf_1_9/I
+ VDD VDD VSS gf180mcu_fd_sc_mcu7t5v0__buf_1
Xgf180mcu_fd_sc_mcu7t5v0__fillcap_16_1 VDD VSS VDD VSS gf180mcu_fd_sc_mcu7t5v0__fillcap_16
Xgf180mcu_fd_sc_mcu7t5v0__fillcap_16_32 VDD VSS VDD VSS gf180mcu_fd_sc_mcu7t5v0__fillcap_16
Xgf180mcu_fd_sc_mcu7t5v0__fillcap_16_43 VDD VSS VDD VSS gf180mcu_fd_sc_mcu7t5v0__fillcap_16
Xgf180mcu_fd_sc_mcu7t5v0__fillcap_16_21 VDD VSS VDD VSS gf180mcu_fd_sc_mcu7t5v0__fillcap_16
Xgf180mcu_fd_sc_mcu7t5v0__fillcap_16_10 VDD VSS VDD VSS gf180mcu_fd_sc_mcu7t5v0__fillcap_16
Xgf180mcu_fd_sc_mcu7t5v0__fillcap_32_75 VDD VSS VDD VSS gf180mcu_fd_sc_mcu7t5v0__fillcap_32
Xgf180mcu_fd_sc_mcu7t5v0__fillcap_32_86 VDD VSS VDD VSS gf180mcu_fd_sc_mcu7t5v0__fillcap_32
Xgf180mcu_fd_sc_mcu7t5v0__fillcap_32_53 VDD VSS VDD VSS gf180mcu_fd_sc_mcu7t5v0__fillcap_32
Xgf180mcu_fd_sc_mcu7t5v0__fillcap_32_64 VDD VSS VDD VSS gf180mcu_fd_sc_mcu7t5v0__fillcap_32
Xgf180mcu_fd_sc_mcu7t5v0__fillcap_32_31 VDD VSS VDD VSS gf180mcu_fd_sc_mcu7t5v0__fillcap_32
Xgf180mcu_fd_sc_mcu7t5v0__fillcap_32_42 VDD VSS VDD VSS gf180mcu_fd_sc_mcu7t5v0__fillcap_32
Xgf180mcu_fd_sc_mcu7t5v0__fillcap_32_20 VDD VSS VDD VSS gf180mcu_fd_sc_mcu7t5v0__fillcap_32
Xgf180mcu_fd_sc_mcu7t5v0__clkinv_1_37 VDD VSS gf180mcu_fd_sc_mcu7t5v0__clkinv_1_37/I
+ gf180mcu_fd_sc_mcu7t5v0__dffnrnq_1_7/RN VDD VSS gf180mcu_fd_sc_mcu7t5v0__clkinv_1
Xgf180mcu_fd_sc_mcu7t5v0__clkinv_1_48 VDD VSS gf180mcu_fd_sc_mcu7t5v0__clkinv_1_48/I
+ gf180mcu_fd_sc_mcu7t5v0__dffnrnq_1_8/RN VDD VSS gf180mcu_fd_sc_mcu7t5v0__clkinv_1
Xgf180mcu_fd_sc_mcu7t5v0__clkinv_1_26 VDD VSS gf180mcu_fd_sc_mcu7t5v0__buf_1_0/I gf180mcu_fd_sc_mcu7t5v0__dlyb_1_0/I
+ VDD VSS gf180mcu_fd_sc_mcu7t5v0__clkinv_1
Xgf180mcu_fd_sc_mcu7t5v0__clkinv_1_15 VDD VSS gf180mcu_fd_sc_mcu7t5v0__clkbuf_8_7/Z
+ gf180mcu_fd_sc_mcu7t5v0__dffnrnq_1_3/RN VDD VSS gf180mcu_fd_sc_mcu7t5v0__clkinv_1
Xgf180mcu_fd_sc_mcu7t5v0__fillcap_64_9 VDD VSS VDD VSS gf180mcu_fd_sc_mcu7t5v0__fillcap_64
Xgf180mcu_fd_sc_mcu7t5v0__fillcap_4_23 VDD VSS VDD VSS gf180mcu_fd_sc_mcu7t5v0__fillcap_4
Xgf180mcu_fd_sc_mcu7t5v0__fillcap_4_78 VDD VSS VDD VSS gf180mcu_fd_sc_mcu7t5v0__fillcap_4
Xgf180mcu_fd_sc_mcu7t5v0__fillcap_4_12 VDD VSS VDD VSS gf180mcu_fd_sc_mcu7t5v0__fillcap_4
Xgf180mcu_fd_sc_mcu7t5v0__fillcap_4_56 VDD VSS VDD VSS gf180mcu_fd_sc_mcu7t5v0__fillcap_4
Xgf180mcu_fd_sc_mcu7t5v0__fillcap_4_67 VDD VSS VDD VSS gf180mcu_fd_sc_mcu7t5v0__fillcap_4
Xgf180mcu_fd_sc_mcu7t5v0__fillcap_4_45 VDD VSS VDD VSS gf180mcu_fd_sc_mcu7t5v0__fillcap_4
Xgf180mcu_fd_sc_mcu7t5v0__fillcap_4_34 VDD VSS VDD VSS gf180mcu_fd_sc_mcu7t5v0__fillcap_4
Xgf180mcu_fd_sc_mcu7t5v0__fillcap_4_89 VDD VSS VDD VSS gf180mcu_fd_sc_mcu7t5v0__fillcap_4
Xgf180mcu_fd_sc_mcu7t5v0__fillcap_4_131 VDD VSS VDD VSS gf180mcu_fd_sc_mcu7t5v0__fillcap_4
Xgf180mcu_fd_sc_mcu7t5v0__fillcap_4_120 VDD VSS VDD VSS gf180mcu_fd_sc_mcu7t5v0__fillcap_4
Xgf180mcu_fd_sc_mcu7t5v0__fillcap_4_142 VDD VSS VDD VSS gf180mcu_fd_sc_mcu7t5v0__fillcap_4
Xgf180mcu_fd_sc_mcu7t5v0__fillcap_4_197 VDD VSS VDD VSS gf180mcu_fd_sc_mcu7t5v0__fillcap_4
Xgf180mcu_fd_sc_mcu7t5v0__fillcap_4_186 VDD VSS VDD VSS gf180mcu_fd_sc_mcu7t5v0__fillcap_4
Xgf180mcu_fd_sc_mcu7t5v0__fillcap_4_175 VDD VSS VDD VSS gf180mcu_fd_sc_mcu7t5v0__fillcap_4
Xgf180mcu_fd_sc_mcu7t5v0__fillcap_4_164 VDD VSS VDD VSS gf180mcu_fd_sc_mcu7t5v0__fillcap_4
Xgf180mcu_fd_sc_mcu7t5v0__fillcap_4_153 VDD VSS VDD VSS gf180mcu_fd_sc_mcu7t5v0__fillcap_4
Xgf180mcu_fd_sc_mcu7t5v0__fillcap_64_29 VDD VSS VDD VSS gf180mcu_fd_sc_mcu7t5v0__fillcap_64
Xgf180mcu_fd_sc_mcu7t5v0__fillcap_64_18 VDD VSS VDD VSS gf180mcu_fd_sc_mcu7t5v0__fillcap_64
Xgf180mcu_fd_sc_mcu7t5v0__dffnrnq_1_9 gf180mcu_fd_sc_mcu7t5v0__oai22_1_7/ZN VSS gf180mcu_fd_sc_mcu7t5v0__clkbuf_2_2/I
+ gf180mcu_fd_sc_mcu7t5v0__dffnrnq_1_9/RN gf180mcu_fd_sc_mcu7t5v0__buf_1_18/I VDD
+ VDD VSS gf180mcu_fd_sc_mcu7t5v0__dffnrnq_1
Xgf180mcu_fd_sc_mcu7t5v0__buf_2_15 VSS gf180mcu_fd_sc_mcu7t5v0__buf_2_15/Z gf180mcu_fd_sc_mcu7t5v0__buf_4_14/I
+ VDD VDD VSS gf180mcu_fd_sc_mcu7t5v0__buf_2
Xgf180mcu_fd_sc_mcu7t5v0__fillcap_32_7 VDD VSS VDD VSS gf180mcu_fd_sc_mcu7t5v0__fillcap_32
Xgf180mcu_fd_sc_mcu7t5v0__clkbuf_2_9 gf180mcu_fd_sc_mcu7t5v0__clkbuf_2_9/Z VSS VDD
+ gf180mcu_fd_sc_mcu7t5v0__clkbuf_8_5/Z VDD VSS gf180mcu_fd_sc_mcu7t5v0__clkbuf_2
Xgf180mcu_fd_sc_mcu7t5v0__fillcap_16_2 VDD VSS VDD VSS gf180mcu_fd_sc_mcu7t5v0__fillcap_16
Xgf180mcu_fd_sc_mcu7t5v0__fillcap_16_33 VDD VSS VDD VSS gf180mcu_fd_sc_mcu7t5v0__fillcap_16
Xgf180mcu_fd_sc_mcu7t5v0__fillcap_16_44 VDD VSS VDD VSS gf180mcu_fd_sc_mcu7t5v0__fillcap_16
Xgf180mcu_fd_sc_mcu7t5v0__fillcap_16_22 VDD VSS VDD VSS gf180mcu_fd_sc_mcu7t5v0__fillcap_16
Xgf180mcu_fd_sc_mcu7t5v0__fillcap_16_11 VDD VSS VDD VSS gf180mcu_fd_sc_mcu7t5v0__fillcap_16
Xgf180mcu_fd_sc_mcu7t5v0__fillcap_32_87 VDD VSS VDD VSS gf180mcu_fd_sc_mcu7t5v0__fillcap_32
Xgf180mcu_fd_sc_mcu7t5v0__fillcap_32_65 VDD VSS VDD VSS gf180mcu_fd_sc_mcu7t5v0__fillcap_32
Xgf180mcu_fd_sc_mcu7t5v0__fillcap_32_54 VDD VSS VDD VSS gf180mcu_fd_sc_mcu7t5v0__fillcap_32
Xgf180mcu_fd_sc_mcu7t5v0__fillcap_32_76 VDD VSS VDD VSS gf180mcu_fd_sc_mcu7t5v0__fillcap_32
Xgf180mcu_fd_sc_mcu7t5v0__fillcap_32_32 VDD VSS VDD VSS gf180mcu_fd_sc_mcu7t5v0__fillcap_32
Xgf180mcu_fd_sc_mcu7t5v0__fillcap_32_21 VDD VSS VDD VSS gf180mcu_fd_sc_mcu7t5v0__fillcap_32
Xgf180mcu_fd_sc_mcu7t5v0__fillcap_32_43 VDD VSS VDD VSS gf180mcu_fd_sc_mcu7t5v0__fillcap_32
Xgf180mcu_fd_sc_mcu7t5v0__fillcap_32_10 VDD VSS VDD VSS gf180mcu_fd_sc_mcu7t5v0__fillcap_32
Xgf180mcu_fd_sc_mcu7t5v0__clkinv_1_38 VDD VSS gf180mcu_fd_sc_mcu7t5v0__clkinv_1_48/I
+ gf180mcu_fd_sc_mcu7t5v0__clkinv_1_38/ZN VDD VSS gf180mcu_fd_sc_mcu7t5v0__clkinv_1
Xgf180mcu_fd_sc_mcu7t5v0__dffnrnq_1_10 gf180mcu_fd_sc_mcu7t5v0__oai31_1_12/ZN VSS
+ gf180mcu_fd_sc_mcu7t5v0__clkbuf_8_22/Z gf180mcu_fd_sc_mcu7t5v0__clkinv_1_22/ZN gf180mcu_fd_sc_mcu7t5v0__buf_4_21/I
+ VDD VDD VSS gf180mcu_fd_sc_mcu7t5v0__dffnrnq_1
Xgf180mcu_fd_sc_mcu7t5v0__clkinv_1_27 VDD VSS gf180mcu_fd_sc_mcu7t5v0__clkinv_1_8/I
+ gf180mcu_fd_sc_mcu7t5v0__oai211_1_0/C VDD VSS gf180mcu_fd_sc_mcu7t5v0__clkinv_1
Xgf180mcu_fd_sc_mcu7t5v0__clkinv_1_16 VDD VSS gf180mcu_fd_sc_mcu7t5v0__clkinv_1_22/I
+ gf180mcu_fd_sc_mcu7t5v0__dffnrnq_1_4/RN VDD VSS gf180mcu_fd_sc_mcu7t5v0__clkinv_1
Xgf180mcu_fd_sc_mcu7t5v0__fillcap_4_24 VDD VSS VDD VSS gf180mcu_fd_sc_mcu7t5v0__fillcap_4
Xgf180mcu_fd_sc_mcu7t5v0__fillcap_4_57 VDD VSS VDD VSS gf180mcu_fd_sc_mcu7t5v0__fillcap_4
Xgf180mcu_fd_sc_mcu7t5v0__fillcap_4_68 VDD VSS VDD VSS gf180mcu_fd_sc_mcu7t5v0__fillcap_4
Xgf180mcu_fd_sc_mcu7t5v0__fillcap_4_13 VDD VSS VDD VSS gf180mcu_fd_sc_mcu7t5v0__fillcap_4
Xgf180mcu_fd_sc_mcu7t5v0__fillcap_4_46 VDD VSS VDD VSS gf180mcu_fd_sc_mcu7t5v0__fillcap_4
Xgf180mcu_fd_sc_mcu7t5v0__fillcap_4_35 VDD VSS VDD VSS gf180mcu_fd_sc_mcu7t5v0__fillcap_4
Xgf180mcu_fd_sc_mcu7t5v0__fillcap_4_79 VDD VSS VDD VSS gf180mcu_fd_sc_mcu7t5v0__fillcap_4
Xgf180mcu_fd_sc_mcu7t5v0__fillcap_4_143 VDD VSS VDD VSS gf180mcu_fd_sc_mcu7t5v0__fillcap_4
Xgf180mcu_fd_sc_mcu7t5v0__fillcap_4_132 VDD VSS VDD VSS gf180mcu_fd_sc_mcu7t5v0__fillcap_4
Xgf180mcu_fd_sc_mcu7t5v0__fillcap_4_110 VDD VSS VDD VSS gf180mcu_fd_sc_mcu7t5v0__fillcap_4
Xgf180mcu_fd_sc_mcu7t5v0__fillcap_4_165 VDD VSS VDD VSS gf180mcu_fd_sc_mcu7t5v0__fillcap_4
Xgf180mcu_fd_sc_mcu7t5v0__fillcap_4_121 VDD VSS VDD VSS gf180mcu_fd_sc_mcu7t5v0__fillcap_4
Xgf180mcu_fd_sc_mcu7t5v0__fillcap_4_154 VDD VSS VDD VSS gf180mcu_fd_sc_mcu7t5v0__fillcap_4
Xgf180mcu_fd_sc_mcu7t5v0__fillcap_4_198 VDD VSS VDD VSS gf180mcu_fd_sc_mcu7t5v0__fillcap_4
Xgf180mcu_fd_sc_mcu7t5v0__fillcap_4_176 VDD VSS VDD VSS gf180mcu_fd_sc_mcu7t5v0__fillcap_4
Xgf180mcu_fd_sc_mcu7t5v0__fillcap_4_187 VDD VSS VDD VSS gf180mcu_fd_sc_mcu7t5v0__fillcap_4
Xgf180mcu_fd_sc_mcu7t5v0__fillcap_64_19 VDD VSS VDD VSS gf180mcu_fd_sc_mcu7t5v0__fillcap_64
Xgf180mcu_fd_sc_mcu7t5v0__fillcap_32_8 VDD VSS VDD VSS gf180mcu_fd_sc_mcu7t5v0__fillcap_32
Xgf180mcu_fd_sc_mcu7t5v0__buf_2_16 VSS gf180mcu_fd_sc_mcu7t5v0__buf_2_1/I gf180mcu_fd_sc_mcu7t5v0__buf_2_16/I
+ VDD VDD VSS gf180mcu_fd_sc_mcu7t5v0__buf_2
Xgf180mcu_fd_sc_mcu7t5v0__fillcap_16_3 VDD VSS VDD VSS gf180mcu_fd_sc_mcu7t5v0__fillcap_16
Xgf180mcu_fd_sc_mcu7t5v0__oai21_1_0 VDD gf180mcu_fd_sc_mcu7t5v0__buf_4_10/I gf180mcu_fd_sc_mcu7t5v0__oai21_1_7/A2
+ gf180mcu_fd_sc_mcu7t5v0__oai21_1_1/B gf180mcu_fd_sc_mcu7t5v0__oai31_1_3/A1 VSS VDD
+ VSS gf180mcu_fd_sc_mcu7t5v0__oai21_1
Xgf180mcu_fd_sc_mcu7t5v0__fillcap_16_45 VDD VSS VDD VSS gf180mcu_fd_sc_mcu7t5v0__fillcap_16
Xgf180mcu_fd_sc_mcu7t5v0__fillcap_16_34 VDD VSS VDD VSS gf180mcu_fd_sc_mcu7t5v0__fillcap_16
Xgf180mcu_fd_sc_mcu7t5v0__fillcap_32_11 VDD VSS VDD VSS gf180mcu_fd_sc_mcu7t5v0__fillcap_32
Xgf180mcu_fd_sc_mcu7t5v0__fillcap_16_23 VDD VSS VDD VSS gf180mcu_fd_sc_mcu7t5v0__fillcap_16
Xgf180mcu_fd_sc_mcu7t5v0__fillcap_16_12 VDD VSS VDD VSS gf180mcu_fd_sc_mcu7t5v0__fillcap_16
Xgf180mcu_fd_sc_mcu7t5v0__fillcap_32_77 VDD VSS VDD VSS gf180mcu_fd_sc_mcu7t5v0__fillcap_32
Xgf180mcu_fd_sc_mcu7t5v0__fillcap_32_55 VDD VSS VDD VSS gf180mcu_fd_sc_mcu7t5v0__fillcap_32
Xgf180mcu_fd_sc_mcu7t5v0__fillcap_32_66 VDD VSS VDD VSS gf180mcu_fd_sc_mcu7t5v0__fillcap_32
Xgf180mcu_fd_sc_mcu7t5v0__fillcap_32_44 VDD VSS VDD VSS gf180mcu_fd_sc_mcu7t5v0__fillcap_32
Xgf180mcu_fd_sc_mcu7t5v0__fillcap_32_33 VDD VSS VDD VSS gf180mcu_fd_sc_mcu7t5v0__fillcap_32
Xgf180mcu_fd_sc_mcu7t5v0__fillcap_32_22 VDD VSS VDD VSS gf180mcu_fd_sc_mcu7t5v0__fillcap_32
Xgf180mcu_fd_sc_mcu7t5v0__fillcap_32_88 VDD VSS VDD VSS gf180mcu_fd_sc_mcu7t5v0__fillcap_32
Xgf180mcu_fd_sc_mcu7t5v0__clkinv_1_39 VDD VSS gf180mcu_fd_sc_mcu7t5v0__clkinv_1_39/I
+ gf180mcu_fd_sc_mcu7t5v0__clkinv_1_39/ZN VDD VSS gf180mcu_fd_sc_mcu7t5v0__clkinv_1
Xgf180mcu_fd_sc_mcu7t5v0__dffnrnq_1_11 gf180mcu_fd_sc_mcu7t5v0__oai31_1_1/ZN VSS gf180mcu_fd_sc_mcu7t5v0__clkbuf_8_5/Z
+ gf180mcu_fd_sc_mcu7t5v0__clkinv_1_19/ZN gf180mcu_fd_sc_mcu7t5v0__buf_4_25/I VDD
+ VDD VSS gf180mcu_fd_sc_mcu7t5v0__dffnrnq_1
Xgf180mcu_fd_sc_mcu7t5v0__clkinv_1_17 VDD VSS gf180mcu_fd_sc_mcu7t5v0__clkinv_1_4/I
+ gf180mcu_fd_sc_mcu7t5v0__nand2_1_4/A2 VDD VSS gf180mcu_fd_sc_mcu7t5v0__clkinv_1
Xgf180mcu_fd_sc_mcu7t5v0__clkinv_1_28 VDD VSS gf180mcu_fd_sc_mcu7t5v0__or4_1_2/A2
+ gf180mcu_fd_sc_mcu7t5v0__oai22_1_7/A1 VDD VSS gf180mcu_fd_sc_mcu7t5v0__clkinv_1
Xgf180mcu_fd_sc_mcu7t5v0__fillcap_4_36 VDD VSS VDD VSS gf180mcu_fd_sc_mcu7t5v0__fillcap_4
Xgf180mcu_fd_sc_mcu7t5v0__fillcap_4_25 VDD VSS VDD VSS gf180mcu_fd_sc_mcu7t5v0__fillcap_4
Xgf180mcu_fd_sc_mcu7t5v0__fillcap_4_14 VDD VSS VDD VSS gf180mcu_fd_sc_mcu7t5v0__fillcap_4
Xgf180mcu_fd_sc_mcu7t5v0__fillcap_4_69 VDD VSS VDD VSS gf180mcu_fd_sc_mcu7t5v0__fillcap_4
Xgf180mcu_fd_sc_mcu7t5v0__fillcap_4_58 VDD VSS VDD VSS gf180mcu_fd_sc_mcu7t5v0__fillcap_4
Xgf180mcu_fd_sc_mcu7t5v0__fillcap_4_47 VDD VSS VDD VSS gf180mcu_fd_sc_mcu7t5v0__fillcap_4
Xgf180mcu_fd_sc_mcu7t5v0__fillcap_4_144 VDD VSS VDD VSS gf180mcu_fd_sc_mcu7t5v0__fillcap_4
Xgf180mcu_fd_sc_mcu7t5v0__fillcap_4_199 VDD VSS VDD VSS gf180mcu_fd_sc_mcu7t5v0__fillcap_4
Xgf180mcu_fd_sc_mcu7t5v0__fillcap_4_177 VDD VSS VDD VSS gf180mcu_fd_sc_mcu7t5v0__fillcap_4
Xgf180mcu_fd_sc_mcu7t5v0__fillcap_4_188 VDD VSS VDD VSS gf180mcu_fd_sc_mcu7t5v0__fillcap_4
Xgf180mcu_fd_sc_mcu7t5v0__fillcap_4_133 VDD VSS VDD VSS gf180mcu_fd_sc_mcu7t5v0__fillcap_4
Xgf180mcu_fd_sc_mcu7t5v0__fillcap_4_111 VDD VSS VDD VSS gf180mcu_fd_sc_mcu7t5v0__fillcap_4
Xgf180mcu_fd_sc_mcu7t5v0__fillcap_4_166 VDD VSS VDD VSS gf180mcu_fd_sc_mcu7t5v0__fillcap_4
Xgf180mcu_fd_sc_mcu7t5v0__fillcap_4_122 VDD VSS VDD VSS gf180mcu_fd_sc_mcu7t5v0__fillcap_4
Xgf180mcu_fd_sc_mcu7t5v0__fillcap_4_100 VDD VSS VDD VSS gf180mcu_fd_sc_mcu7t5v0__fillcap_4
Xgf180mcu_fd_sc_mcu7t5v0__fillcap_4_155 VDD VSS VDD VSS gf180mcu_fd_sc_mcu7t5v0__fillcap_4
Xgf180mcu_fd_sc_mcu7t5v0__nor3_1_0 gf180mcu_fd_sc_mcu7t5v0__dlyb_1_0/Z VDD VSS gf180mcu_fd_sc_mcu7t5v0__nor3_1_0/ZN
+ gf180mcu_fd_sc_mcu7t5v0__nor3_1_0/A1 gf180mcu_fd_sc_mcu7t5v0__nor3_1_0/A2 VDD VSS
+ gf180mcu_fd_sc_mcu7t5v0__nor3_1
Xgf180mcu_fd_sc_mcu7t5v0__fillcap_32_9 VDD VSS VDD VSS gf180mcu_fd_sc_mcu7t5v0__fillcap_32
Xgf180mcu_fd_sc_mcu7t5v0__fillcap_16_4 VDD VSS VDD VSS gf180mcu_fd_sc_mcu7t5v0__fillcap_16
Xgf180mcu_fd_sc_mcu7t5v0__antenna_0 VSS CLKS VDD VDD VSS gf180mcu_fd_sc_mcu7t5v0__antenna
Xgf180mcu_fd_sc_mcu7t5v0__oai21_1_1 VDD gf180mcu_fd_sc_mcu7t5v0__oai21_1_1/B gf180mcu_fd_sc_mcu7t5v0__oai21_1_7/A2
+ gf180mcu_fd_sc_mcu7t5v0__oai21_1_1/ZN gf180mcu_fd_sc_mcu7t5v0__buf_2_3/Z VSS VDD
+ VSS gf180mcu_fd_sc_mcu7t5v0__oai21_1
Xgf180mcu_fd_sc_mcu7t5v0__fillcap_16_24 VDD VSS VDD VSS gf180mcu_fd_sc_mcu7t5v0__fillcap_16
Xgf180mcu_fd_sc_mcu7t5v0__fillcap_16_13 VDD VSS VDD VSS gf180mcu_fd_sc_mcu7t5v0__fillcap_16
Xgf180mcu_fd_sc_mcu7t5v0__fillcap_16_46 VDD VSS VDD VSS gf180mcu_fd_sc_mcu7t5v0__fillcap_16
Xgf180mcu_fd_sc_mcu7t5v0__fillcap_32_45 VDD VSS VDD VSS gf180mcu_fd_sc_mcu7t5v0__fillcap_32
Xgf180mcu_fd_sc_mcu7t5v0__fillcap_16_35 VDD VSS VDD VSS gf180mcu_fd_sc_mcu7t5v0__fillcap_16
Xgf180mcu_fd_sc_mcu7t5v0__fillcap_32_12 VDD VSS VDD VSS gf180mcu_fd_sc_mcu7t5v0__fillcap_32
Xgf180mcu_fd_sc_mcu7t5v0__fillcap_32_23 VDD VSS VDD VSS gf180mcu_fd_sc_mcu7t5v0__fillcap_32
Xgf180mcu_fd_sc_mcu7t5v0__fillcap_32_34 VDD VSS VDD VSS gf180mcu_fd_sc_mcu7t5v0__fillcap_32
Xgf180mcu_fd_sc_mcu7t5v0__fillcap_32_78 VDD VSS VDD VSS gf180mcu_fd_sc_mcu7t5v0__fillcap_32
Xgf180mcu_fd_sc_mcu7t5v0__fillcap_32_56 VDD VSS VDD VSS gf180mcu_fd_sc_mcu7t5v0__fillcap_32
Xgf180mcu_fd_sc_mcu7t5v0__fillcap_32_67 VDD VSS VDD VSS gf180mcu_fd_sc_mcu7t5v0__fillcap_32
Xgf180mcu_fd_sc_mcu7t5v0__fillcap_32_89 VDD VSS VDD VSS gf180mcu_fd_sc_mcu7t5v0__fillcap_32
Xgf180mcu_fd_sc_mcu7t5v0__dffnrnq_1_12 gf180mcu_fd_sc_mcu7t5v0__oai32_1_0/ZN VSS gf180mcu_fd_sc_mcu7t5v0__clkbuf_8_17/Z
+ gf180mcu_fd_sc_mcu7t5v0__clkinv_1_31/ZN gf180mcu_fd_sc_mcu7t5v0__buf_4_20/I VDD
+ VDD VSS gf180mcu_fd_sc_mcu7t5v0__dffnrnq_1
Xgf180mcu_fd_sc_mcu7t5v0__clkinv_1_29 VDD VSS gf180mcu_fd_sc_mcu7t5v0__clkbuf_8_9/Z
+ gf180mcu_fd_sc_mcu7t5v0__nand2_1_2/A2 VDD VSS gf180mcu_fd_sc_mcu7t5v0__clkinv_1
Xgf180mcu_fd_sc_mcu7t5v0__clkinv_1_18 VDD VSS gf180mcu_fd_sc_mcu7t5v0__clkbuf_8_6/Z
+ gf180mcu_fd_sc_mcu7t5v0__dffnrnq_1_5/RN VDD VSS gf180mcu_fd_sc_mcu7t5v0__clkinv_1
Xgf180mcu_fd_sc_mcu7t5v0__fillcap_4_37 VDD VSS VDD VSS gf180mcu_fd_sc_mcu7t5v0__fillcap_4
Xgf180mcu_fd_sc_mcu7t5v0__fillcap_4_15 VDD VSS VDD VSS gf180mcu_fd_sc_mcu7t5v0__fillcap_4
Xgf180mcu_fd_sc_mcu7t5v0__fillcap_4_26 VDD VSS VDD VSS gf180mcu_fd_sc_mcu7t5v0__fillcap_4
Xgf180mcu_fd_sc_mcu7t5v0__fillcap_4_59 VDD VSS VDD VSS gf180mcu_fd_sc_mcu7t5v0__fillcap_4
Xgf180mcu_fd_sc_mcu7t5v0__fillcap_4_48 VDD VSS VDD VSS gf180mcu_fd_sc_mcu7t5v0__fillcap_4
Xgf180mcu_fd_sc_mcu7t5v0__fillcap_4_145 VDD VSS VDD VSS gf180mcu_fd_sc_mcu7t5v0__fillcap_4
Xgf180mcu_fd_sc_mcu7t5v0__fillcap_4_178 VDD VSS VDD VSS gf180mcu_fd_sc_mcu7t5v0__fillcap_4
Xgf180mcu_fd_sc_mcu7t5v0__fillcap_4_189 VDD VSS VDD VSS gf180mcu_fd_sc_mcu7t5v0__fillcap_4
Xgf180mcu_fd_sc_mcu7t5v0__fillcap_4_134 VDD VSS VDD VSS gf180mcu_fd_sc_mcu7t5v0__fillcap_4
Xgf180mcu_fd_sc_mcu7t5v0__fillcap_4_112 VDD VSS VDD VSS gf180mcu_fd_sc_mcu7t5v0__fillcap_4
Xgf180mcu_fd_sc_mcu7t5v0__fillcap_4_123 VDD VSS VDD VSS gf180mcu_fd_sc_mcu7t5v0__fillcap_4
Xgf180mcu_fd_sc_mcu7t5v0__fillcap_4_167 VDD VSS VDD VSS gf180mcu_fd_sc_mcu7t5v0__fillcap_4
Xgf180mcu_fd_sc_mcu7t5v0__fillcap_4_101 VDD VSS VDD VSS gf180mcu_fd_sc_mcu7t5v0__fillcap_4
Xgf180mcu_fd_sc_mcu7t5v0__fillcap_4_156 VDD VSS VDD VSS gf180mcu_fd_sc_mcu7t5v0__fillcap_4
Xgf180mcu_fd_sc_mcu7t5v0__nand3_1_0 gf180mcu_fd_sc_mcu7t5v0__buf_1_13/Z VDD VSS gf180mcu_fd_sc_mcu7t5v0__nor4_1_0/A1
+ gf180mcu_fd_sc_mcu7t5v0__buf_1_22/Z gf180mcu_fd_sc_mcu7t5v0__buf_1_23/I VDD VSS
+ gf180mcu_fd_sc_mcu7t5v0__nand3_1
Xgf180mcu_fd_sc_mcu7t5v0__fillcap_16_5 VDD VSS VDD VSS gf180mcu_fd_sc_mcu7t5v0__fillcap_16
Xgf180mcu_fd_sc_mcu7t5v0__antenna_1 VSS DCMPP VDD VDD VSS gf180mcu_fd_sc_mcu7t5v0__antenna
Xgf180mcu_fd_sc_mcu7t5v0__oai21_1_2 VDD gf180mcu_fd_sc_mcu7t5v0__buf_4_3/I gf180mcu_fd_sc_mcu7t5v0__oai21_1_7/A2
+ gf180mcu_fd_sc_mcu7t5v0__oai21_1_7/B gf180mcu_fd_sc_mcu7t5v0__buf_1_2/Z VSS VDD
+ VSS gf180mcu_fd_sc_mcu7t5v0__oai21_1
Xgf180mcu_fd_sc_mcu7t5v0__fillcap_16_47 VDD VSS VDD VSS gf180mcu_fd_sc_mcu7t5v0__fillcap_16
Xgf180mcu_fd_sc_mcu7t5v0__fillcap_16_36 VDD VSS VDD VSS gf180mcu_fd_sc_mcu7t5v0__fillcap_16
Xgf180mcu_fd_sc_mcu7t5v0__fillcap_16_14 VDD VSS VDD VSS gf180mcu_fd_sc_mcu7t5v0__fillcap_16
Xgf180mcu_fd_sc_mcu7t5v0__fillcap_16_25 VDD VSS VDD VSS gf180mcu_fd_sc_mcu7t5v0__fillcap_16
Xgf180mcu_fd_sc_mcu7t5v0__fillcap_32_79 VDD VSS VDD VSS gf180mcu_fd_sc_mcu7t5v0__fillcap_32
Xgf180mcu_fd_sc_mcu7t5v0__fillcap_32_57 VDD VSS VDD VSS gf180mcu_fd_sc_mcu7t5v0__fillcap_32
Xgf180mcu_fd_sc_mcu7t5v0__fillcap_32_68 VDD VSS VDD VSS gf180mcu_fd_sc_mcu7t5v0__fillcap_32
Xgf180mcu_fd_sc_mcu7t5v0__fillcap_32_46 VDD VSS VDD VSS gf180mcu_fd_sc_mcu7t5v0__fillcap_32
Xgf180mcu_fd_sc_mcu7t5v0__fillcap_32_24 VDD VSS VDD VSS gf180mcu_fd_sc_mcu7t5v0__fillcap_32
Xgf180mcu_fd_sc_mcu7t5v0__fillcap_32_35 VDD VSS VDD VSS gf180mcu_fd_sc_mcu7t5v0__fillcap_32
Xgf180mcu_fd_sc_mcu7t5v0__fillcap_32_13 VDD VSS VDD VSS gf180mcu_fd_sc_mcu7t5v0__fillcap_32
Xgf180mcu_fd_sc_mcu7t5v0__clkinv_1_19 VDD VSS gf180mcu_fd_sc_mcu7t5v0__clkbuf_8_6/Z
+ gf180mcu_fd_sc_mcu7t5v0__clkinv_1_19/ZN VDD VSS gf180mcu_fd_sc_mcu7t5v0__clkinv_1
Xgf180mcu_fd_sc_mcu7t5v0__dffnrnq_1_13 gf180mcu_fd_sc_mcu7t5v0__nor2_1_0/ZN VSS gf180mcu_fd_sc_mcu7t5v0__clkbuf_8_19/Z
+ gf180mcu_fd_sc_mcu7t5v0__clkinv_1_34/ZN gf180mcu_fd_sc_mcu7t5v0__buf_1_40/I VDD
+ VDD VSS gf180mcu_fd_sc_mcu7t5v0__dffnrnq_1
Xgf180mcu_fd_sc_mcu7t5v0__buf_4_0 DOUT[1] gf180mcu_fd_sc_mcu7t5v0__buf_4_0/I VDD VSS
+ VDD VSS gf180mcu_fd_sc_mcu7t5v0__buf_4
Xgf180mcu_fd_sc_mcu7t5v0__fillcap_4_16 VDD VSS VDD VSS gf180mcu_fd_sc_mcu7t5v0__fillcap_4
Xgf180mcu_fd_sc_mcu7t5v0__fillcap_4_49 VDD VSS VDD VSS gf180mcu_fd_sc_mcu7t5v0__fillcap_4
Xgf180mcu_fd_sc_mcu7t5v0__fillcap_4_27 VDD VSS VDD VSS gf180mcu_fd_sc_mcu7t5v0__fillcap_4
Xgf180mcu_fd_sc_mcu7t5v0__fillcap_4_38 VDD VSS VDD VSS gf180mcu_fd_sc_mcu7t5v0__fillcap_4
Xgf180mcu_fd_sc_mcu7t5v0__fillcap_4_113 VDD VSS VDD VSS gf180mcu_fd_sc_mcu7t5v0__fillcap_4
Xgf180mcu_fd_sc_mcu7t5v0__fillcap_4_102 VDD VSS VDD VSS gf180mcu_fd_sc_mcu7t5v0__fillcap_4
Xgf180mcu_fd_sc_mcu7t5v0__fillcap_4_146 VDD VSS VDD VSS gf180mcu_fd_sc_mcu7t5v0__fillcap_4
Xgf180mcu_fd_sc_mcu7t5v0__fillcap_4_179 VDD VSS VDD VSS gf180mcu_fd_sc_mcu7t5v0__fillcap_4
Xgf180mcu_fd_sc_mcu7t5v0__fillcap_4_135 VDD VSS VDD VSS gf180mcu_fd_sc_mcu7t5v0__fillcap_4
Xgf180mcu_fd_sc_mcu7t5v0__fillcap_4_124 VDD VSS VDD VSS gf180mcu_fd_sc_mcu7t5v0__fillcap_4
Xgf180mcu_fd_sc_mcu7t5v0__fillcap_4_157 VDD VSS VDD VSS gf180mcu_fd_sc_mcu7t5v0__fillcap_4
Xgf180mcu_fd_sc_mcu7t5v0__fillcap_4_168 VDD VSS VDD VSS gf180mcu_fd_sc_mcu7t5v0__fillcap_4
Xgf180mcu_fd_sc_mcu7t5v0__aoi21_1_0 gf180mcu_fd_sc_mcu7t5v0__aoi21_1_0/B VDD VSS gf180mcu_fd_sc_mcu7t5v0__aoi21_1_0/ZN
+ gf180mcu_fd_sc_mcu7t5v0__or4_1_0/A3 gf180mcu_fd_sc_mcu7t5v0__buf_1_28/Z VDD VSS
+ gf180mcu_fd_sc_mcu7t5v0__aoi21_1
Xgf180mcu_fd_sc_mcu7t5v0__fillcap_16_6 VDD VSS VDD VSS gf180mcu_fd_sc_mcu7t5v0__fillcap_16
Xgf180mcu_fd_sc_mcu7t5v0__oai211_1_0 gf180mcu_fd_sc_mcu7t5v0__buf_1_1/Z gf180mcu_fd_sc_mcu7t5v0__oai211_1_0/C
+ VDD VSS gf180mcu_fd_sc_mcu7t5v0__nor3_4_0/A1 gf180mcu_fd_sc_mcu7t5v0__oai22_1_8/ZN
+ gf180mcu_fd_sc_mcu7t5v0__oai211_1_1/A2 VDD VSS gf180mcu_fd_sc_mcu7t5v0__oai211_1
Xgf180mcu_fd_sc_mcu7t5v0__antenna_2 VSS DCMPP VDD VDD VSS gf180mcu_fd_sc_mcu7t5v0__antenna
Xgf180mcu_fd_sc_mcu7t5v0__oai21_1_3 VDD gf180mcu_fd_sc_mcu7t5v0__buf_1_30/Z gf180mcu_fd_sc_mcu7t5v0__nor4_1_0/A1
+ gf180mcu_fd_sc_mcu7t5v0__oai21_1_3/ZN gf180mcu_fd_sc_mcu7t5v0__buf_1_28/Z VSS VDD
+ VSS gf180mcu_fd_sc_mcu7t5v0__oai21_1
Xgf180mcu_fd_sc_mcu7t5v0__fillcap_16_48 VDD VSS VDD VSS gf180mcu_fd_sc_mcu7t5v0__fillcap_16
Xgf180mcu_fd_sc_mcu7t5v0__fillcap_16_37 VDD VSS VDD VSS gf180mcu_fd_sc_mcu7t5v0__fillcap_16
Xgf180mcu_fd_sc_mcu7t5v0__fillcap_16_15 VDD VSS VDD VSS gf180mcu_fd_sc_mcu7t5v0__fillcap_16
Xgf180mcu_fd_sc_mcu7t5v0__fillcap_16_26 VDD VSS VDD VSS gf180mcu_fd_sc_mcu7t5v0__fillcap_16
Xgf180mcu_fd_sc_mcu7t5v0__fillcap_32_58 VDD VSS VDD VSS gf180mcu_fd_sc_mcu7t5v0__fillcap_32
Xgf180mcu_fd_sc_mcu7t5v0__fillcap_32_47 VDD VSS VDD VSS gf180mcu_fd_sc_mcu7t5v0__fillcap_32
Xgf180mcu_fd_sc_mcu7t5v0__fillcap_32_69 VDD VSS VDD VSS gf180mcu_fd_sc_mcu7t5v0__fillcap_32
Xgf180mcu_fd_sc_mcu7t5v0__fillcap_32_14 VDD VSS VDD VSS gf180mcu_fd_sc_mcu7t5v0__fillcap_32
Xgf180mcu_fd_sc_mcu7t5v0__fillcap_32_25 VDD VSS VDD VSS gf180mcu_fd_sc_mcu7t5v0__fillcap_32
Xgf180mcu_fd_sc_mcu7t5v0__fillcap_32_36 VDD VSS VDD VSS gf180mcu_fd_sc_mcu7t5v0__fillcap_32
Xgf180mcu_fd_sc_mcu7t5v0__dffnrnq_1_14 gf180mcu_fd_sc_mcu7t5v0__oai31_1_8/ZN VSS gf180mcu_fd_sc_mcu7t5v0__clkbuf_8_19/Z
+ gf180mcu_fd_sc_mcu7t5v0__clkinv_1_36/ZN gf180mcu_fd_sc_mcu7t5v0__buf_4_22/I VDD
+ VDD VSS gf180mcu_fd_sc_mcu7t5v0__dffnrnq_1
Xgf180mcu_fd_sc_mcu7t5v0__buf_4_1 DOUT[3] gf180mcu_fd_sc_mcu7t5v0__buf_4_1/I VDD VSS
+ VDD VSS gf180mcu_fd_sc_mcu7t5v0__buf_4
Xgf180mcu_fd_sc_mcu7t5v0__fillcap_4_39 VDD VSS VDD VSS gf180mcu_fd_sc_mcu7t5v0__fillcap_4
Xgf180mcu_fd_sc_mcu7t5v0__fillcap_4_17 VDD VSS VDD VSS gf180mcu_fd_sc_mcu7t5v0__fillcap_4
Xgf180mcu_fd_sc_mcu7t5v0__fillcap_4_28 VDD VSS VDD VSS gf180mcu_fd_sc_mcu7t5v0__fillcap_4
Xgf180mcu_fd_sc_mcu7t5v0__fillcap_4_147 VDD VSS VDD VSS gf180mcu_fd_sc_mcu7t5v0__fillcap_4
Xgf180mcu_fd_sc_mcu7t5v0__fillcap_4_136 VDD VSS VDD VSS gf180mcu_fd_sc_mcu7t5v0__fillcap_4
Xgf180mcu_fd_sc_mcu7t5v0__fillcap_4_114 VDD VSS VDD VSS gf180mcu_fd_sc_mcu7t5v0__fillcap_4
Xgf180mcu_fd_sc_mcu7t5v0__fillcap_4_125 VDD VSS VDD VSS gf180mcu_fd_sc_mcu7t5v0__fillcap_4
Xgf180mcu_fd_sc_mcu7t5v0__fillcap_4_103 VDD VSS VDD VSS gf180mcu_fd_sc_mcu7t5v0__fillcap_4
Xgf180mcu_fd_sc_mcu7t5v0__fillcap_4_158 VDD VSS VDD VSS gf180mcu_fd_sc_mcu7t5v0__fillcap_4
Xgf180mcu_fd_sc_mcu7t5v0__fillcap_4_169 VDD VSS VDD VSS gf180mcu_fd_sc_mcu7t5v0__fillcap_4
Xgf180mcu_fd_sc_mcu7t5v0__aoi21_1_1 gf180mcu_fd_sc_mcu7t5v0__buf_1_42/Z VDD VSS gf180mcu_fd_sc_mcu7t5v0__nor2_1_1/A1
+ gf180mcu_fd_sc_mcu7t5v0__aoi21_1_3/ZN gf180mcu_fd_sc_mcu7t5v0__buf_2_16/I VDD VSS
+ gf180mcu_fd_sc_mcu7t5v0__aoi21_1
Xgf180mcu_fd_sc_mcu7t5v0__oai211_1_1 gf180mcu_fd_sc_mcu7t5v0__buf_1_22/Z gf180mcu_fd_sc_mcu7t5v0__buf_1_1/Z
+ VDD VSS gf180mcu_fd_sc_mcu7t5v0__oai31_1_5/A2 gf180mcu_fd_sc_mcu7t5v0__oai22_1_8/ZN
+ gf180mcu_fd_sc_mcu7t5v0__oai211_1_1/A2 VDD VSS gf180mcu_fd_sc_mcu7t5v0__oai211_1
Xgf180mcu_fd_sc_mcu7t5v0__fillcap_16_7 VDD VSS VDD VSS gf180mcu_fd_sc_mcu7t5v0__fillcap_16
Xgf180mcu_fd_sc_mcu7t5v0__antenna_3 VSS DCMPN VDD VDD VSS gf180mcu_fd_sc_mcu7t5v0__antenna
Xgf180mcu_fd_sc_mcu7t5v0__oai21_1_4 VDD gf180mcu_fd_sc_mcu7t5v0__oai21_1_4/B gf180mcu_fd_sc_mcu7t5v0__buf_1_43/Z
+ gf180mcu_fd_sc_mcu7t5v0__oai21_1_4/ZN gf180mcu_fd_sc_mcu7t5v0__or3_2_0/Z VSS VDD
+ VSS gf180mcu_fd_sc_mcu7t5v0__oai21_1
Xgf180mcu_fd_sc_mcu7t5v0__or2_1_0 VDD VSS gf180mcu_fd_sc_mcu7t5v0__or2_1_0/Z gf180mcu_fd_sc_mcu7t5v0__or2_1_0/A1
+ gf180mcu_fd_sc_mcu7t5v0__or2_1_0/A2 VDD VSS gf180mcu_fd_sc_mcu7t5v0__or2_1
Xgf180mcu_fd_sc_mcu7t5v0__fillcap_16_38 VDD VSS VDD VSS gf180mcu_fd_sc_mcu7t5v0__fillcap_16
Xgf180mcu_fd_sc_mcu7t5v0__fillcap_16_16 VDD VSS VDD VSS gf180mcu_fd_sc_mcu7t5v0__fillcap_16
Xgf180mcu_fd_sc_mcu7t5v0__fillcap_16_27 VDD VSS VDD VSS gf180mcu_fd_sc_mcu7t5v0__fillcap_16
Xgf180mcu_fd_sc_mcu7t5v0__fillcap_32_59 VDD VSS VDD VSS gf180mcu_fd_sc_mcu7t5v0__fillcap_32
Xgf180mcu_fd_sc_mcu7t5v0__fillcap_32_48 VDD VSS VDD VSS gf180mcu_fd_sc_mcu7t5v0__fillcap_32
Xgf180mcu_fd_sc_mcu7t5v0__fillcap_32_15 VDD VSS VDD VSS gf180mcu_fd_sc_mcu7t5v0__fillcap_32
Xgf180mcu_fd_sc_mcu7t5v0__fillcap_32_37 VDD VSS VDD VSS gf180mcu_fd_sc_mcu7t5v0__fillcap_32
Xgf180mcu_fd_sc_mcu7t5v0__fillcap_32_26 VDD VSS VDD VSS gf180mcu_fd_sc_mcu7t5v0__fillcap_32
Xgf180mcu_fd_sc_mcu7t5v0__dffnrnq_1_15 gf180mcu_fd_sc_mcu7t5v0__oai21_1_4/ZN VSS gf180mcu_fd_sc_mcu7t5v0__clkbuf_8_21/Z
+ gf180mcu_fd_sc_mcu7t5v0__clkinv_1_39/ZN gf180mcu_fd_sc_mcu7t5v0__buf_4_23/I VDD
+ VDD VSS gf180mcu_fd_sc_mcu7t5v0__dffnrnq_1
Xgf180mcu_fd_sc_mcu7t5v0__and4_4_0 gf180mcu_fd_sc_mcu7t5v0__buf_1_1/Z gf180mcu_fd_sc_mcu7t5v0__and4_4_0/A3
+ gf180mcu_fd_sc_mcu7t5v0__nor3_1_0/ZN VDD VSS CMPCK gf180mcu_fd_sc_mcu7t5v0__and4_4_0/A1
+ VDD VSS gf180mcu_fd_sc_mcu7t5v0__and4_4
Xgf180mcu_fd_sc_mcu7t5v0__fillcap_8_60 VDD VSS VDD VSS gf180mcu_fd_sc_mcu7t5v0__fillcap_8
Xgf180mcu_fd_sc_mcu7t5v0__buf_4_2 DOUT[2] gf180mcu_fd_sc_mcu7t5v0__buf_4_2/I VDD VSS
+ VDD VSS gf180mcu_fd_sc_mcu7t5v0__buf_4
Xgf180mcu_fd_sc_mcu7t5v0__fillcap_4_18 VDD VSS VDD VSS gf180mcu_fd_sc_mcu7t5v0__fillcap_4
Xgf180mcu_fd_sc_mcu7t5v0__fillcap_4_29 VDD VSS VDD VSS gf180mcu_fd_sc_mcu7t5v0__fillcap_4
Xgf180mcu_fd_sc_mcu7t5v0__fillcap_4_148 VDD VSS VDD VSS gf180mcu_fd_sc_mcu7t5v0__fillcap_4
Xgf180mcu_fd_sc_mcu7t5v0__fillcap_4_126 VDD VSS VDD VSS gf180mcu_fd_sc_mcu7t5v0__fillcap_4
Xgf180mcu_fd_sc_mcu7t5v0__fillcap_4_137 VDD VSS VDD VSS gf180mcu_fd_sc_mcu7t5v0__fillcap_4
Xgf180mcu_fd_sc_mcu7t5v0__fillcap_4_159 VDD VSS VDD VSS gf180mcu_fd_sc_mcu7t5v0__fillcap_4
Xgf180mcu_fd_sc_mcu7t5v0__fillcap_4_104 VDD VSS VDD VSS gf180mcu_fd_sc_mcu7t5v0__fillcap_4
Xgf180mcu_fd_sc_mcu7t5v0__fillcap_4_115 VDD VSS VDD VSS gf180mcu_fd_sc_mcu7t5v0__fillcap_4
Xgf180mcu_fd_sc_mcu7t5v0__aoi21_1_2 gf180mcu_fd_sc_mcu7t5v0__buf_1_40/Z VDD VSS gf180mcu_fd_sc_mcu7t5v0__nor2_1_0/A1
+ gf180mcu_fd_sc_mcu7t5v0__aoi21_1_3/ZN gf180mcu_fd_sc_mcu7t5v0__buf_2_1/Z VDD VSS
+ gf180mcu_fd_sc_mcu7t5v0__aoi21_1
Xgf180mcu_fd_sc_mcu7t5v0__fillcap_16_8 VDD VSS VDD VSS gf180mcu_fd_sc_mcu7t5v0__fillcap_16
Xgf180mcu_fd_sc_mcu7t5v0__antenna_4 VSS DCMPN VDD VDD VSS gf180mcu_fd_sc_mcu7t5v0__antenna
Xgf180mcu_fd_sc_mcu7t5v0__oai21_1_5 VDD gf180mcu_fd_sc_mcu7t5v0__oai21_1_5/B gf180mcu_fd_sc_mcu7t5v0__oai31_2_1/A3
+ gf180mcu_fd_sc_mcu7t5v0__oai21_1_5/ZN gf180mcu_fd_sc_mcu7t5v0__or3_2_0/Z VSS VDD
+ VSS gf180mcu_fd_sc_mcu7t5v0__oai21_1
Xgf180mcu_fd_sc_mcu7t5v0__or2_1_1 VDD VSS gf180mcu_fd_sc_mcu7t5v0__or2_1_1/Z gf180mcu_fd_sc_mcu7t5v0__or2_1_1/A1
+ gf180mcu_fd_sc_mcu7t5v0__or2_1_1/A2 VDD VSS gf180mcu_fd_sc_mcu7t5v0__or2_1
Xgf180mcu_fd_sc_mcu7t5v0__fillcap_16_28 VDD VSS VDD VSS gf180mcu_fd_sc_mcu7t5v0__fillcap_16
Xgf180mcu_fd_sc_mcu7t5v0__fillcap_16_39 VDD VSS VDD VSS gf180mcu_fd_sc_mcu7t5v0__fillcap_16
Xgf180mcu_fd_sc_mcu7t5v0__fillcap_16_17 VDD VSS VDD VSS gf180mcu_fd_sc_mcu7t5v0__fillcap_16
Xgf180mcu_fd_sc_mcu7t5v0__fillcap_32_27 VDD VSS VDD VSS gf180mcu_fd_sc_mcu7t5v0__fillcap_32
Xgf180mcu_fd_sc_mcu7t5v0__fillcap_32_16 VDD VSS VDD VSS gf180mcu_fd_sc_mcu7t5v0__fillcap_32
Xgf180mcu_fd_sc_mcu7t5v0__fillcap_32_49 VDD VSS VDD VSS gf180mcu_fd_sc_mcu7t5v0__fillcap_32
Xgf180mcu_fd_sc_mcu7t5v0__fillcap_32_38 VDD VSS VDD VSS gf180mcu_fd_sc_mcu7t5v0__fillcap_32
Xgf180mcu_fd_sc_mcu7t5v0__dffnrnq_1_16 gf180mcu_fd_sc_mcu7t5v0__oai32_1_1/ZN VSS gf180mcu_fd_sc_mcu7t5v0__clkbuf_8_17/Z
+ gf180mcu_fd_sc_mcu7t5v0__clkinv_1_41/ZN gf180mcu_fd_sc_mcu7t5v0__buf_4_18/I VDD
+ VDD VSS gf180mcu_fd_sc_mcu7t5v0__dffnrnq_1
Xgf180mcu_fd_sc_mcu7t5v0__fillcap_8_61 VDD VSS VDD VSS gf180mcu_fd_sc_mcu7t5v0__fillcap_8
Xgf180mcu_fd_sc_mcu7t5v0__fillcap_8_50 VDD VSS VDD VSS gf180mcu_fd_sc_mcu7t5v0__fillcap_8
Xgf180mcu_fd_sc_mcu7t5v0__buf_4_3 DCTRLP[3] gf180mcu_fd_sc_mcu7t5v0__buf_4_3/I VDD
+ VSS VDD VSS gf180mcu_fd_sc_mcu7t5v0__buf_4
Xgf180mcu_fd_sc_mcu7t5v0__aoi211_2_0 gf180mcu_fd_sc_mcu7t5v0__aoi211_2_0/B gf180mcu_fd_sc_mcu7t5v0__or3_2_0/A2
+ VDD VSS gf180mcu_fd_sc_mcu7t5v0__aoi21_1_0/B gf180mcu_fd_sc_mcu7t5v0__buf_2_3/Z
+ gf180mcu_fd_sc_mcu7t5v0__oai31_1_3/A1 VDD VSS gf180mcu_fd_sc_mcu7t5v0__aoi211_2
Xgf180mcu_fd_sc_mcu7t5v0__fillcap_4_19 VDD VSS VDD VSS gf180mcu_fd_sc_mcu7t5v0__fillcap_4
Xgf180mcu_fd_sc_mcu7t5v0__fillcap_4_127 VDD VSS VDD VSS gf180mcu_fd_sc_mcu7t5v0__fillcap_4
Xgf180mcu_fd_sc_mcu7t5v0__fillcap_4_138 VDD VSS VDD VSS gf180mcu_fd_sc_mcu7t5v0__fillcap_4
Xgf180mcu_fd_sc_mcu7t5v0__fillcap_4_149 VDD VSS VDD VSS gf180mcu_fd_sc_mcu7t5v0__fillcap_4
Xgf180mcu_fd_sc_mcu7t5v0__fillcap_4_105 VDD VSS VDD VSS gf180mcu_fd_sc_mcu7t5v0__fillcap_4
Xgf180mcu_fd_sc_mcu7t5v0__fillcap_4_116 VDD VSS VDD VSS gf180mcu_fd_sc_mcu7t5v0__fillcap_4
Xgf180mcu_fd_sc_mcu7t5v0__oai31_2_0 gf180mcu_fd_sc_mcu7t5v0__buf_2_10/Z gf180mcu_fd_sc_mcu7t5v0__buf_1_31/Z
+ gf180mcu_fd_sc_mcu7t5v0__buf_4_17/I VDD VSS gf180mcu_fd_sc_mcu7t5v0__oai21_1_6/B
+ gf180mcu_fd_sc_mcu7t5v0__buf_1_4/Z VDD VSS gf180mcu_fd_sc_mcu7t5v0__oai31_2
Xgf180mcu_fd_sc_mcu7t5v0__buf_2_0 VSS gf180mcu_fd_sc_mcu7t5v0__buf_2_0/Z gf180mcu_fd_sc_mcu7t5v0__buf_2_4/Z
+ VDD VDD VSS gf180mcu_fd_sc_mcu7t5v0__buf_2
Xgf180mcu_fd_sc_mcu7t5v0__aoi21_1_3 gf180mcu_fd_sc_mcu7t5v0__or3_2_0/A2 VDD VSS gf180mcu_fd_sc_mcu7t5v0__aoi21_1_3/ZN
+ gf180mcu_fd_sc_mcu7t5v0__aoi21_1_3/A1 gf180mcu_fd_sc_mcu7t5v0__aoi21_1_3/A2 VDD
+ VSS gf180mcu_fd_sc_mcu7t5v0__aoi21_1
Xgf180mcu_fd_sc_mcu7t5v0__fillcap_16_9 VDD VSS VDD VSS gf180mcu_fd_sc_mcu7t5v0__fillcap_16
Xgf180mcu_fd_sc_mcu7t5v0__oai21_1_6 VDD gf180mcu_fd_sc_mcu7t5v0__oai21_1_6/B gf180mcu_fd_sc_mcu7t5v0__buf_1_31/Z
+ gf180mcu_fd_sc_mcu7t5v0__oai21_1_6/ZN gf180mcu_fd_sc_mcu7t5v0__or3_2_0/Z VSS VDD
+ VSS gf180mcu_fd_sc_mcu7t5v0__oai21_1
Xgf180mcu_fd_sc_mcu7t5v0__antenna_5 VSS CLKS VDD VDD VSS gf180mcu_fd_sc_mcu7t5v0__antenna
Xgf180mcu_fd_sc_mcu7t5v0__fillcap_16_29 VDD VSS VDD VSS gf180mcu_fd_sc_mcu7t5v0__fillcap_16
Xgf180mcu_fd_sc_mcu7t5v0__fillcap_16_18 VDD VSS VDD VSS gf180mcu_fd_sc_mcu7t5v0__fillcap_16
Xgf180mcu_fd_sc_mcu7t5v0__fillcap_32_39 VDD VSS VDD VSS gf180mcu_fd_sc_mcu7t5v0__fillcap_32
Xgf180mcu_fd_sc_mcu7t5v0__fillcap_32_28 VDD VSS VDD VSS gf180mcu_fd_sc_mcu7t5v0__fillcap_32
Xgf180mcu_fd_sc_mcu7t5v0__fillcap_32_17 VDD VSS VDD VSS gf180mcu_fd_sc_mcu7t5v0__fillcap_32
Xgf180mcu_fd_sc_mcu7t5v0__dffnrnq_1_17 gf180mcu_fd_sc_mcu7t5v0__oai21_1_6/ZN VSS gf180mcu_fd_sc_mcu7t5v0__clkbuf_8_21/Z
+ gf180mcu_fd_sc_mcu7t5v0__clkinv_1_30/ZN gf180mcu_fd_sc_mcu7t5v0__buf_4_17/I VDD
+ VDD VSS gf180mcu_fd_sc_mcu7t5v0__dffnrnq_1
Xgf180mcu_fd_sc_mcu7t5v0__fillcap_8_62 VDD VSS VDD VSS gf180mcu_fd_sc_mcu7t5v0__fillcap_8
Xgf180mcu_fd_sc_mcu7t5v0__fillcap_8_40 VDD VSS VDD VSS gf180mcu_fd_sc_mcu7t5v0__fillcap_8
Xgf180mcu_fd_sc_mcu7t5v0__fillcap_8_51 VDD VSS VDD VSS gf180mcu_fd_sc_mcu7t5v0__fillcap_8
Xgf180mcu_fd_sc_mcu7t5v0__buf_4_4 DOUT[0] gf180mcu_fd_sc_mcu7t5v0__buf_4_4/I VDD VSS
+ VDD VSS gf180mcu_fd_sc_mcu7t5v0__buf_4
Xgf180mcu_fd_sc_mcu7t5v0__aoi211_2_1 gf180mcu_fd_sc_mcu7t5v0__buf_1_35/Z gf180mcu_fd_sc_mcu7t5v0__buf_1_15/Z
+ VDD VSS gf180mcu_fd_sc_mcu7t5v0__oai32_1_1/B1 gf180mcu_fd_sc_mcu7t5v0__buf_2_5/Z
+ gf180mcu_fd_sc_mcu7t5v0__buf_2_10/Z VDD VSS gf180mcu_fd_sc_mcu7t5v0__aoi211_2
Xgf180mcu_fd_sc_mcu7t5v0__fillcap_4_139 VDD VSS VDD VSS gf180mcu_fd_sc_mcu7t5v0__fillcap_4
Xgf180mcu_fd_sc_mcu7t5v0__fillcap_4_128 VDD VSS VDD VSS gf180mcu_fd_sc_mcu7t5v0__fillcap_4
Xgf180mcu_fd_sc_mcu7t5v0__fillcap_4_106 VDD VSS VDD VSS gf180mcu_fd_sc_mcu7t5v0__fillcap_4
Xgf180mcu_fd_sc_mcu7t5v0__fillcap_4_117 VDD VSS VDD VSS gf180mcu_fd_sc_mcu7t5v0__fillcap_4
Xgf180mcu_fd_sc_mcu7t5v0__oai31_2_1 gf180mcu_fd_sc_mcu7t5v0__buf_2_10/Z gf180mcu_fd_sc_mcu7t5v0__oai31_2_1/A3
+ gf180mcu_fd_sc_mcu7t5v0__buf_4_16/I VDD VSS gf180mcu_fd_sc_mcu7t5v0__oai21_1_5/B
+ gf180mcu_fd_sc_mcu7t5v0__buf_1_35/Z VDD VSS gf180mcu_fd_sc_mcu7t5v0__oai31_2
Xgf180mcu_fd_sc_mcu7t5v0__buf_2_1 VSS gf180mcu_fd_sc_mcu7t5v0__buf_2_1/Z gf180mcu_fd_sc_mcu7t5v0__buf_2_1/I
+ VDD VDD VSS gf180mcu_fd_sc_mcu7t5v0__buf_2
Xgf180mcu_fd_sc_mcu7t5v0__nand4_2_0 gf180mcu_fd_sc_mcu7t5v0__buf_2_14/Z gf180mcu_fd_sc_mcu7t5v0__buf_1_25/Z
+ VDD VSS gf180mcu_fd_sc_mcu7t5v0__buf_2_16/I gf180mcu_fd_sc_mcu7t5v0__buf_4_15/Z
+ gf180mcu_fd_sc_mcu7t5v0__buf_2_15/Z VDD VSS gf180mcu_fd_sc_mcu7t5v0__nand4_2
Xgf180mcu_fd_sc_mcu7t5v0__oai21_1_7 VDD gf180mcu_fd_sc_mcu7t5v0__oai21_1_7/B gf180mcu_fd_sc_mcu7t5v0__oai21_1_7/A2
+ gf180mcu_fd_sc_mcu7t5v0__oai21_1_7/ZN gf180mcu_fd_sc_mcu7t5v0__buf_1_3/Z VSS VDD
+ VSS gf180mcu_fd_sc_mcu7t5v0__oai21_1
Xgf180mcu_fd_sc_mcu7t5v0__fillcap_16_19 VDD VSS VDD VSS gf180mcu_fd_sc_mcu7t5v0__fillcap_16
Xgf180mcu_fd_sc_mcu7t5v0__fillcap_32_29 VDD VSS VDD VSS gf180mcu_fd_sc_mcu7t5v0__fillcap_32
Xgf180mcu_fd_sc_mcu7t5v0__fillcap_32_18 VDD VSS VDD VSS gf180mcu_fd_sc_mcu7t5v0__fillcap_32
Xgf180mcu_fd_sc_mcu7t5v0__dffnrnq_1_18 gf180mcu_fd_sc_mcu7t5v0__nor2_1_1/ZN VSS gf180mcu_fd_sc_mcu7t5v0__clkbuf_8_15/Z
+ gf180mcu_fd_sc_mcu7t5v0__clkinv_1_45/ZN gf180mcu_fd_sc_mcu7t5v0__buf_1_42/I VDD
+ VDD VSS gf180mcu_fd_sc_mcu7t5v0__dffnrnq_1
Xgf180mcu_fd_sc_mcu7t5v0__fillcap_8_30 VDD VSS VDD VSS gf180mcu_fd_sc_mcu7t5v0__fillcap_8
Xgf180mcu_fd_sc_mcu7t5v0__fillcap_8_63 VDD VSS VDD VSS gf180mcu_fd_sc_mcu7t5v0__fillcap_8
Xgf180mcu_fd_sc_mcu7t5v0__fillcap_8_52 VDD VSS VDD VSS gf180mcu_fd_sc_mcu7t5v0__fillcap_8
Xgf180mcu_fd_sc_mcu7t5v0__fillcap_8_41 VDD VSS VDD VSS gf180mcu_fd_sc_mcu7t5v0__fillcap_8
Xgf180mcu_fd_sc_mcu7t5v0__buf_4_5 DCTRLP[2] gf180mcu_fd_sc_mcu7t5v0__buf_4_5/I VDD
+ VSS VDD VSS gf180mcu_fd_sc_mcu7t5v0__buf_4
Xgf180mcu_fd_sc_mcu7t5v0__fillcap_4_129 VDD VSS VDD VSS gf180mcu_fd_sc_mcu7t5v0__fillcap_4
Xgf180mcu_fd_sc_mcu7t5v0__fillcap_4_107 VDD VSS VDD VSS gf180mcu_fd_sc_mcu7t5v0__fillcap_4
Xgf180mcu_fd_sc_mcu7t5v0__fillcap_4_118 VDD VSS VDD VSS gf180mcu_fd_sc_mcu7t5v0__fillcap_4
Xgf180mcu_fd_sc_mcu7t5v0__buf_2_2 VSS gf180mcu_fd_sc_mcu7t5v0__buf_2_2/Z gf180mcu_fd_sc_mcu7t5v0__buf_2_4/Z
+ VDD VDD VSS gf180mcu_fd_sc_mcu7t5v0__buf_2
Xgf180mcu_fd_sc_mcu7t5v0__oai21_1_8 VDD gf180mcu_fd_sc_mcu7t5v0__oai21_1_8/B gf180mcu_fd_sc_mcu7t5v0__buf_1_43/I
+ gf180mcu_fd_sc_mcu7t5v0__oai21_1_8/ZN gf180mcu_fd_sc_mcu7t5v0__buf_2_13/Z VSS VDD
+ VSS gf180mcu_fd_sc_mcu7t5v0__oai21_1
Xgf180mcu_fd_sc_mcu7t5v0__fillcap_32_19 VDD VSS VDD VSS gf180mcu_fd_sc_mcu7t5v0__fillcap_32
Xgf180mcu_fd_sc_mcu7t5v0__fillcap_8_53 VDD VSS VDD VSS gf180mcu_fd_sc_mcu7t5v0__fillcap_8
Xgf180mcu_fd_sc_mcu7t5v0__fillcap_8_42 VDD VSS VDD VSS gf180mcu_fd_sc_mcu7t5v0__fillcap_8
Xgf180mcu_fd_sc_mcu7t5v0__fillcap_8_64 VDD VSS VDD VSS gf180mcu_fd_sc_mcu7t5v0__fillcap_8
Xgf180mcu_fd_sc_mcu7t5v0__fillcap_8_31 VDD VSS VDD VSS gf180mcu_fd_sc_mcu7t5v0__fillcap_8
Xgf180mcu_fd_sc_mcu7t5v0__fillcap_8_20 VDD VSS VDD VSS gf180mcu_fd_sc_mcu7t5v0__fillcap_8
Xgf180mcu_fd_sc_mcu7t5v0__buf_4_6 DOUT[5] gf180mcu_fd_sc_mcu7t5v0__buf_4_6/I VDD VSS
+ VDD VSS gf180mcu_fd_sc_mcu7t5v0__buf_4
Xgf180mcu_fd_sc_mcu7t5v0__aoi22_2_0 gf180mcu_fd_sc_mcu7t5v0__buf_2_14/Z gf180mcu_fd_sc_mcu7t5v0__buf_2_8/Z
+ VDD VSS gf180mcu_fd_sc_mcu7t5v0__buf_1_0/I gf180mcu_fd_sc_mcu7t5v0__buf_4_15/Z gf180mcu_fd_sc_mcu7t5v0__buf_4_14/Z
+ VDD VSS gf180mcu_fd_sc_mcu7t5v0__aoi22_2
Xgf180mcu_fd_sc_mcu7t5v0__fillcap_4_108 VDD VSS VDD VSS gf180mcu_fd_sc_mcu7t5v0__fillcap_4
Xgf180mcu_fd_sc_mcu7t5v0__fillcap_4_119 VDD VSS VDD VSS gf180mcu_fd_sc_mcu7t5v0__fillcap_4
Xgf180mcu_fd_sc_mcu7t5v0__buf_2_3 VSS gf180mcu_fd_sc_mcu7t5v0__buf_2_3/Z gf180mcu_fd_sc_mcu7t5v0__buf_2_9/I
+ VDD VDD VSS gf180mcu_fd_sc_mcu7t5v0__buf_2
Xgf180mcu_fd_sc_mcu7t5v0__fillcap_8_54 VDD VSS VDD VSS gf180mcu_fd_sc_mcu7t5v0__fillcap_8
Xgf180mcu_fd_sc_mcu7t5v0__fillcap_8_43 VDD VSS VDD VSS gf180mcu_fd_sc_mcu7t5v0__fillcap_8
Xgf180mcu_fd_sc_mcu7t5v0__fillcap_8_65 VDD VSS VDD VSS gf180mcu_fd_sc_mcu7t5v0__fillcap_8
Xgf180mcu_fd_sc_mcu7t5v0__fillcap_8_21 VDD VSS VDD VSS gf180mcu_fd_sc_mcu7t5v0__fillcap_8
Xgf180mcu_fd_sc_mcu7t5v0__fillcap_8_32 VDD VSS VDD VSS gf180mcu_fd_sc_mcu7t5v0__fillcap_8
Xgf180mcu_fd_sc_mcu7t5v0__fillcap_8_10 VDD VSS VDD VSS gf180mcu_fd_sc_mcu7t5v0__fillcap_8
Xgf180mcu_fd_sc_mcu7t5v0__buf_4_7 DOUT[4] gf180mcu_fd_sc_mcu7t5v0__buf_4_7/I VDD VSS
+ VDD VSS gf180mcu_fd_sc_mcu7t5v0__buf_4
Xgf180mcu_fd_sc_mcu7t5v0__fillcap_4_109 VDD VSS VDD VSS gf180mcu_fd_sc_mcu7t5v0__fillcap_4
Xgf180mcu_fd_sc_mcu7t5v0__buf_2_4 VSS gf180mcu_fd_sc_mcu7t5v0__buf_2_4/Z gf180mcu_fd_sc_mcu7t5v0__buf_2_4/I
+ VDD VDD VSS gf180mcu_fd_sc_mcu7t5v0__buf_2
Xgf180mcu_fd_sc_mcu7t5v0__or3_2_0 gf180mcu_fd_sc_mcu7t5v0__or3_2_0/A3 VDD VSS gf180mcu_fd_sc_mcu7t5v0__or3_2_0/Z
+ gf180mcu_fd_sc_mcu7t5v0__buf_2_5/Z gf180mcu_fd_sc_mcu7t5v0__or3_2_0/A2 VDD VSS gf180mcu_fd_sc_mcu7t5v0__or3_2
Xgf180mcu_fd_sc_mcu7t5v0__clkinv_1_0 VDD VSS gf180mcu_fd_sc_mcu7t5v0__buf_4_2/I gf180mcu_fd_sc_mcu7t5v0__oai22_1_1/A2
+ VDD VSS gf180mcu_fd_sc_mcu7t5v0__clkinv_1
Xgf180mcu_fd_sc_mcu7t5v0__dffrnq_2_0 gf180mcu_fd_sc_mcu7t5v0__dffrnq_2_0/D gf180mcu_fd_sc_mcu7t5v0__buf_1_26/I
+ gf180mcu_fd_sc_mcu7t5v0__dffrnq_2_0/RN VDD VSS gf180mcu_fd_sc_mcu7t5v0__clkbuf_16_6/Z
+ VDD VSS gf180mcu_fd_sc_mcu7t5v0__dffrnq_2
Xgf180mcu_fd_sc_mcu7t5v0__fillcap_8_55 VDD VSS VDD VSS gf180mcu_fd_sc_mcu7t5v0__fillcap_8
Xgf180mcu_fd_sc_mcu7t5v0__fillcap_8_44 VDD VSS VDD VSS gf180mcu_fd_sc_mcu7t5v0__fillcap_8
Xgf180mcu_fd_sc_mcu7t5v0__fillcap_8_66 VDD VSS VDD VSS gf180mcu_fd_sc_mcu7t5v0__fillcap_8
Xgf180mcu_fd_sc_mcu7t5v0__fillcap_8_22 VDD VSS VDD VSS gf180mcu_fd_sc_mcu7t5v0__fillcap_8
Xgf180mcu_fd_sc_mcu7t5v0__buf_4_8 DOUT[7] gf180mcu_fd_sc_mcu7t5v0__buf_4_8/I VDD VSS
+ VDD VSS gf180mcu_fd_sc_mcu7t5v0__buf_4
Xgf180mcu_fd_sc_mcu7t5v0__fillcap_8_33 VDD VSS VDD VSS gf180mcu_fd_sc_mcu7t5v0__fillcap_8
Xgf180mcu_fd_sc_mcu7t5v0__fillcap_8_11 VDD VSS VDD VSS gf180mcu_fd_sc_mcu7t5v0__fillcap_8
Xgf180mcu_fd_sc_mcu7t5v0__clkbuf_16_0 VDD VSS gf180mcu_fd_sc_mcu7t5v0__clkbuf_8_5/I
+ gf180mcu_fd_sc_mcu7t5v0__clkbuf_16_5/I VDD VSS gf180mcu_fd_sc_mcu7t5v0__clkbuf_16
Xgf180mcu_fd_sc_mcu7t5v0__buf_2_5 VSS gf180mcu_fd_sc_mcu7t5v0__buf_2_5/Z gf180mcu_fd_sc_mcu7t5v0__buf_2_9/Z
+ VDD VDD VSS gf180mcu_fd_sc_mcu7t5v0__buf_2
Xgf180mcu_fd_sc_mcu7t5v0__clkinv_1_1 VDD VSS gf180mcu_fd_sc_mcu7t5v0__buf_4_0/I gf180mcu_fd_sc_mcu7t5v0__oai22_1_0/A2
+ VDD VSS gf180mcu_fd_sc_mcu7t5v0__clkinv_1
Xgf180mcu_fd_sc_mcu7t5v0__dffrnq_2_1 gf180mcu_fd_sc_mcu7t5v0__dffrnq_2_1/D gf180mcu_fd_sc_mcu7t5v0__buf_2_12/I
+ gf180mcu_fd_sc_mcu7t5v0__dffrnq_2_1/RN VDD VSS gf180mcu_fd_sc_mcu7t5v0__dffrnq_2_1/CLK
+ VDD VSS gf180mcu_fd_sc_mcu7t5v0__dffrnq_2
Xgf180mcu_fd_sc_mcu7t5v0__fillcap_8_12 VDD VSS VDD VSS gf180mcu_fd_sc_mcu7t5v0__fillcap_8
Xgf180mcu_fd_sc_mcu7t5v0__fillcap_8_56 VDD VSS VDD VSS gf180mcu_fd_sc_mcu7t5v0__fillcap_8
Xgf180mcu_fd_sc_mcu7t5v0__fillcap_8_45 VDD VSS VDD VSS gf180mcu_fd_sc_mcu7t5v0__fillcap_8
Xgf180mcu_fd_sc_mcu7t5v0__fillcap_8_67 VDD VSS VDD VSS gf180mcu_fd_sc_mcu7t5v0__fillcap_8
Xgf180mcu_fd_sc_mcu7t5v0__fillcap_8_34 VDD VSS VDD VSS gf180mcu_fd_sc_mcu7t5v0__fillcap_8
Xgf180mcu_fd_sc_mcu7t5v0__buf_4_9 DOUT[6] gf180mcu_fd_sc_mcu7t5v0__buf_4_9/I VDD VSS
+ VDD VSS gf180mcu_fd_sc_mcu7t5v0__buf_4
Xgf180mcu_fd_sc_mcu7t5v0__fillcap_8_23 VDD VSS VDD VSS gf180mcu_fd_sc_mcu7t5v0__fillcap_8
Xgf180mcu_fd_sc_mcu7t5v0__clkbuf_16_1 VDD VSS gf180mcu_fd_sc_mcu7t5v0__clkbuf_8_9/I
+ gf180mcu_fd_sc_mcu7t5v0__clkbuf_16_7/I VDD VSS gf180mcu_fd_sc_mcu7t5v0__clkbuf_16
Xgf180mcu_fd_sc_mcu7t5v0__buf_2_6 VSS gf180mcu_fd_sc_mcu7t5v0__buf_2_6/Z gf180mcu_fd_sc_mcu7t5v0__buf_2_6/I
+ VDD VDD VSS gf180mcu_fd_sc_mcu7t5v0__buf_2
Xgf180mcu_fd_sc_mcu7t5v0__clkinv_1_2 VDD VSS gf180mcu_fd_sc_mcu7t5v0__clkinv_1_3/I
+ gf180mcu_fd_sc_mcu7t5v0__nand2_1_21/A2 VDD VSS gf180mcu_fd_sc_mcu7t5v0__clkinv_1
Xgf180mcu_fd_sc_mcu7t5v0__nor2_1_0 VDD VSS gf180mcu_fd_sc_mcu7t5v0__nor2_1_0/ZN gf180mcu_fd_sc_mcu7t5v0__nor2_1_0/A1
+ gf180mcu_fd_sc_mcu7t5v0__nor2_1_0/A2 VDD VSS gf180mcu_fd_sc_mcu7t5v0__nor2_1
Xgf180mcu_fd_sc_mcu7t5v0__fillcap_8_46 VDD VSS VDD VSS gf180mcu_fd_sc_mcu7t5v0__fillcap_8
Xgf180mcu_fd_sc_mcu7t5v0__fillcap_8_35 VDD VSS VDD VSS gf180mcu_fd_sc_mcu7t5v0__fillcap_8
Xgf180mcu_fd_sc_mcu7t5v0__fillcap_8_13 VDD VSS VDD VSS gf180mcu_fd_sc_mcu7t5v0__fillcap_8
Xgf180mcu_fd_sc_mcu7t5v0__fillcap_8_24 VDD VSS VDD VSS gf180mcu_fd_sc_mcu7t5v0__fillcap_8
Xgf180mcu_fd_sc_mcu7t5v0__fillcap_8_57 VDD VSS VDD VSS gf180mcu_fd_sc_mcu7t5v0__fillcap_8
Xgf180mcu_fd_sc_mcu7t5v0__fillcap_8_68 VDD VSS VDD VSS gf180mcu_fd_sc_mcu7t5v0__fillcap_8
Xgf180mcu_fd_sc_mcu7t5v0__clkbuf_16_20 VDD VSS gf180mcu_fd_sc_mcu7t5v0__nor3_1_0/A1
+ gf180mcu_fd_sc_mcu7t5v0__clkbuf_16_2/I VDD VSS gf180mcu_fd_sc_mcu7t5v0__clkbuf_16
Xgf180mcu_fd_sc_mcu7t5v0__clkbuf_16_2 VDD VSS gf180mcu_fd_sc_mcu7t5v0__or4_1_0/A1
+ gf180mcu_fd_sc_mcu7t5v0__clkbuf_16_2/I VDD VSS gf180mcu_fd_sc_mcu7t5v0__clkbuf_16
Xgf180mcu_fd_sc_mcu7t5v0__buf_2_7 VSS gf180mcu_fd_sc_mcu7t5v0__buf_2_7/Z gf180mcu_fd_sc_mcu7t5v0__buf_2_7/I
+ VDD VDD VSS gf180mcu_fd_sc_mcu7t5v0__buf_2
Xgf180mcu_fd_sc_mcu7t5v0__nand2_1_0 VDD VSS gf180mcu_fd_sc_mcu7t5v0__dffnq_1_2/D gf180mcu_fd_sc_mcu7t5v0__oai31_1_0/ZN
+ gf180mcu_fd_sc_mcu7t5v0__nand4_1_0/ZN VDD VSS gf180mcu_fd_sc_mcu7t5v0__nand2_1
Xgf180mcu_fd_sc_mcu7t5v0__clkinv_1_3 VDD VSS gf180mcu_fd_sc_mcu7t5v0__clkinv_1_3/I
+ gf180mcu_fd_sc_mcu7t5v0__nand2_1_16/A2 VDD VSS gf180mcu_fd_sc_mcu7t5v0__clkinv_1
Xgf180mcu_fd_sc_mcu7t5v0__nor2_1_1 VDD VSS gf180mcu_fd_sc_mcu7t5v0__nor2_1_1/ZN gf180mcu_fd_sc_mcu7t5v0__nor2_1_1/A1
+ gf180mcu_fd_sc_mcu7t5v0__nor2_1_1/A2 VDD VSS gf180mcu_fd_sc_mcu7t5v0__nor2_1
Xgf180mcu_fd_sc_mcu7t5v0__and2_1_0 VDD VSS gf180mcu_fd_sc_mcu7t5v0__and2_1_0/Z gf180mcu_fd_sc_mcu7t5v0__or2_1_0/A1
+ gf180mcu_fd_sc_mcu7t5v0__buf_2_12/I VDD VSS gf180mcu_fd_sc_mcu7t5v0__and2_1
Xgf180mcu_fd_sc_mcu7t5v0__fillcap_8_69 VDD VSS VDD VSS gf180mcu_fd_sc_mcu7t5v0__fillcap_8
Xgf180mcu_fd_sc_mcu7t5v0__fillcap_8_47 VDD VSS VDD VSS gf180mcu_fd_sc_mcu7t5v0__fillcap_8
Xgf180mcu_fd_sc_mcu7t5v0__fillcap_8_36 VDD VSS VDD VSS gf180mcu_fd_sc_mcu7t5v0__fillcap_8
Xgf180mcu_fd_sc_mcu7t5v0__fillcap_8_58 VDD VSS VDD VSS gf180mcu_fd_sc_mcu7t5v0__fillcap_8
Xgf180mcu_fd_sc_mcu7t5v0__fillcap_8_14 VDD VSS VDD VSS gf180mcu_fd_sc_mcu7t5v0__fillcap_8
Xgf180mcu_fd_sc_mcu7t5v0__fillcap_8_25 VDD VSS VDD VSS gf180mcu_fd_sc_mcu7t5v0__fillcap_8
Xgf180mcu_fd_sc_mcu7t5v0__clkbuf_16_10 VDD VSS gf180mcu_fd_sc_mcu7t5v0__aoi221_1_0/C
+ gf180mcu_fd_sc_mcu7t5v0__clkbuf_16_16/I VDD VSS gf180mcu_fd_sc_mcu7t5v0__clkbuf_16
Xgf180mcu_fd_sc_mcu7t5v0__clkbuf_16_21 VDD VSS gf180mcu_fd_sc_mcu7t5v0__clkbuf_8_8/I
+ gf180mcu_fd_sc_mcu7t5v0__clkbuf_16_5/I VDD VSS gf180mcu_fd_sc_mcu7t5v0__clkbuf_16
Xgf180mcu_fd_sc_mcu7t5v0__clkbuf_16_3 VDD VSS gf180mcu_fd_sc_mcu7t5v0__clkbuf_16_5/I
+ gf180mcu_fd_sc_mcu7t5v0__dlyb_1_1/Z VDD VSS gf180mcu_fd_sc_mcu7t5v0__clkbuf_16
Xgf180mcu_fd_sc_mcu7t5v0__buf_2_8 VSS gf180mcu_fd_sc_mcu7t5v0__buf_2_8/Z gf180mcu_fd_sc_mcu7t5v0__buf_2_8/I
+ VDD VDD VSS gf180mcu_fd_sc_mcu7t5v0__buf_2
Xgf180mcu_fd_sc_mcu7t5v0__nand2_1_1 VDD VSS gf180mcu_fd_sc_mcu7t5v0__nand2_1_1/ZN
+ gf180mcu_fd_sc_mcu7t5v0__and4_4_0/A3 gf180mcu_fd_sc_mcu7t5v0__buf_2_1/Z VDD VSS
+ gf180mcu_fd_sc_mcu7t5v0__nand2_1
Xgf180mcu_fd_sc_mcu7t5v0__clkinv_1_4 VDD VSS gf180mcu_fd_sc_mcu7t5v0__clkinv_1_4/I
+ gf180mcu_fd_sc_mcu7t5v0__nand2_1_5/A2 VDD VSS gf180mcu_fd_sc_mcu7t5v0__clkinv_1
Xgf180mcu_fd_sc_mcu7t5v0__aoi221_1_0 gf180mcu_fd_sc_mcu7t5v0__buf_1_25/Z gf180mcu_fd_sc_mcu7t5v0__aoi221_1_0/C
+ VDD VSS gf180mcu_fd_sc_mcu7t5v0__and4_4_0/A1 gf180mcu_fd_sc_mcu7t5v0__buf_4_15/Z
+ gf180mcu_fd_sc_mcu7t5v0__buf_2_15/Z gf180mcu_fd_sc_mcu7t5v0__or2_1_0/Z VDD VSS gf180mcu_fd_sc_mcu7t5v0__aoi221_1
Xgf180mcu_fd_sc_mcu7t5v0__nor2_1_2 VDD VSS gf180mcu_fd_sc_mcu7t5v0__nor2_1_2/ZN gf180mcu_fd_sc_mcu7t5v0__buf_1_42/Z
+ gf180mcu_fd_sc_mcu7t5v0__or2_1_0/A2 VDD VSS gf180mcu_fd_sc_mcu7t5v0__nor2_1
Xgf180mcu_fd_sc_mcu7t5v0__oai32_1_0 gf180mcu_fd_sc_mcu7t5v0__buf_2_10/Z gf180mcu_fd_sc_mcu7t5v0__oai32_1_1/B1
+ gf180mcu_fd_sc_mcu7t5v0__or4_1_0/A4 VDD VSS gf180mcu_fd_sc_mcu7t5v0__oai32_1_0/ZN
+ gf180mcu_fd_sc_mcu7t5v0__buf_1_36/Z gf180mcu_fd_sc_mcu7t5v0__buf_1_35/Z VDD VSS
+ gf180mcu_fd_sc_mcu7t5v0__oai32_1
Xgf180mcu_fd_sc_mcu7t5v0__nor3_4_0 gf180mcu_fd_sc_mcu7t5v0__nor4_1_0/A1 VDD VSS gf180mcu_fd_sc_mcu7t5v0__buf_4_24/I
+ gf180mcu_fd_sc_mcu7t5v0__nor3_4_0/A1 gf180mcu_fd_sc_mcu7t5v0__buf_1_0/Z VDD VSS
+ gf180mcu_fd_sc_mcu7t5v0__nor3_4
Xgf180mcu_fd_sc_mcu7t5v0__and2_1_1 VDD VSS gf180mcu_fd_sc_mcu7t5v0__and2_1_1/Z gf180mcu_fd_sc_mcu7t5v0__or2_4_0/A1
+ gf180mcu_fd_sc_mcu7t5v0__buf_2_7/Z VDD VSS gf180mcu_fd_sc_mcu7t5v0__and2_1
Xgf180mcu_fd_sc_mcu7t5v0__fillcap_8_37 VDD VSS VDD VSS gf180mcu_fd_sc_mcu7t5v0__fillcap_8
Xgf180mcu_fd_sc_mcu7t5v0__fillcap_8_48 VDD VSS VDD VSS gf180mcu_fd_sc_mcu7t5v0__fillcap_8
Xgf180mcu_fd_sc_mcu7t5v0__fillcap_8_59 VDD VSS VDD VSS gf180mcu_fd_sc_mcu7t5v0__fillcap_8
Xgf180mcu_fd_sc_mcu7t5v0__fillcap_8_15 VDD VSS VDD VSS gf180mcu_fd_sc_mcu7t5v0__fillcap_8
Xgf180mcu_fd_sc_mcu7t5v0__fillcap_8_26 VDD VSS VDD VSS gf180mcu_fd_sc_mcu7t5v0__fillcap_8
Xgf180mcu_fd_sc_mcu7t5v0__clkbuf_16_11 VDD VSS gf180mcu_fd_sc_mcu7t5v0__clkbuf_16_18/I
+ gf180mcu_fd_sc_mcu7t5v0__dlyb_1_1/Z VDD VSS gf180mcu_fd_sc_mcu7t5v0__clkbuf_16
Xgf180mcu_fd_sc_mcu7t5v0__clkbuf_16_22 VDD VSS gf180mcu_fd_sc_mcu7t5v0__clkbuf_16_2/I
+ CLKS VDD VSS gf180mcu_fd_sc_mcu7t5v0__clkbuf_16
Xgf180mcu_fd_sc_mcu7t5v0__buf_2_9 VSS gf180mcu_fd_sc_mcu7t5v0__buf_2_9/Z gf180mcu_fd_sc_mcu7t5v0__buf_2_9/I
+ VDD VDD VSS gf180mcu_fd_sc_mcu7t5v0__buf_2
Xgf180mcu_fd_sc_mcu7t5v0__clkbuf_16_4 VDD VSS gf180mcu_fd_sc_mcu7t5v0__clkbuf_16_7/I
+ CLKS VDD VSS gf180mcu_fd_sc_mcu7t5v0__clkbuf_16
Xgf180mcu_fd_sc_mcu7t5v0__nand2_1_2 VDD VSS gf180mcu_fd_sc_mcu7t5v0__oai22_1_3/B2
+ gf180mcu_fd_sc_mcu7t5v0__and4_1_3/Z gf180mcu_fd_sc_mcu7t5v0__nand2_1_2/A2 VDD VSS
+ gf180mcu_fd_sc_mcu7t5v0__nand2_1
Xgf180mcu_fd_sc_mcu7t5v0__clkinv_1_5 VDD VSS gf180mcu_fd_sc_mcu7t5v0__buf_4_1/I gf180mcu_fd_sc_mcu7t5v0__oai22_1_5/A2
+ VDD VSS gf180mcu_fd_sc_mcu7t5v0__clkinv_1
Xgf180mcu_fd_sc_mcu7t5v0__buf_1_40 VSS gf180mcu_fd_sc_mcu7t5v0__buf_1_40/Z gf180mcu_fd_sc_mcu7t5v0__buf_1_40/I
+ VDD VDD VSS gf180mcu_fd_sc_mcu7t5v0__buf_1
Xgf180mcu_fd_sc_mcu7t5v0__nor2_1_3 VDD VSS gf180mcu_fd_sc_mcu7t5v0__nor4_1_0/A3 gf180mcu_fd_sc_mcu7t5v0__or2_4_0/A1
+ gf180mcu_fd_sc_mcu7t5v0__buf_2_7/Z VDD VSS gf180mcu_fd_sc_mcu7t5v0__nor2_1
Xgf180mcu_fd_sc_mcu7t5v0__oai32_1_1 gf180mcu_fd_sc_mcu7t5v0__buf_1_35/Z gf180mcu_fd_sc_mcu7t5v0__oai32_1_1/B1
+ gf180mcu_fd_sc_mcu7t5v0__oai32_1_1/B2 VDD VSS gf180mcu_fd_sc_mcu7t5v0__oai32_1_1/ZN
+ gf180mcu_fd_sc_mcu7t5v0__buf_1_36/Z gf180mcu_fd_sc_mcu7t5v0__buf_1_37/Z VDD VSS
+ gf180mcu_fd_sc_mcu7t5v0__oai32_1
Xgf180mcu_fd_sc_mcu7t5v0__fillcap_8_49 VDD VSS VDD VSS gf180mcu_fd_sc_mcu7t5v0__fillcap_8
Xgf180mcu_fd_sc_mcu7t5v0__fillcap_8_38 VDD VSS VDD VSS gf180mcu_fd_sc_mcu7t5v0__fillcap_8
Xgf180mcu_fd_sc_mcu7t5v0__fillcap_8_16 VDD VSS VDD VSS gf180mcu_fd_sc_mcu7t5v0__fillcap_8
Xgf180mcu_fd_sc_mcu7t5v0__fillcap_8_27 VDD VSS VDD VSS gf180mcu_fd_sc_mcu7t5v0__fillcap_8
Xgf180mcu_fd_sc_mcu7t5v0__clkbuf_16_23 VDD VSS gf180mcu_fd_sc_mcu7t5v0__or2_1_1/A1
+ gf180mcu_fd_sc_mcu7t5v0__clkbuf_16_9/Z VDD VSS gf180mcu_fd_sc_mcu7t5v0__clkbuf_16
Xgf180mcu_fd_sc_mcu7t5v0__clkbuf_16_12 VDD VSS gf180mcu_fd_sc_mcu7t5v0__clkbuf_16_8/I
+ DCMPP VDD VSS gf180mcu_fd_sc_mcu7t5v0__clkbuf_16
Xgf180mcu_fd_sc_mcu7t5v0__clkbuf_16_5 VDD VSS gf180mcu_fd_sc_mcu7t5v0__clkbuf_8_22/I
+ gf180mcu_fd_sc_mcu7t5v0__clkbuf_16_5/I VDD VSS gf180mcu_fd_sc_mcu7t5v0__clkbuf_16
Xgf180mcu_fd_sc_mcu7t5v0__nand2_1_3 VDD VSS gf180mcu_fd_sc_mcu7t5v0__oai22_1_4/B2
+ gf180mcu_fd_sc_mcu7t5v0__and4_1_2/Z gf180mcu_fd_sc_mcu7t5v0__nand2_1_3/A2 VDD VSS
+ gf180mcu_fd_sc_mcu7t5v0__nand2_1
Xgf180mcu_fd_sc_mcu7t5v0__clkinv_1_6 VDD VSS gf180mcu_fd_sc_mcu7t5v0__clkinv_1_7/I
+ gf180mcu_fd_sc_mcu7t5v0__clkinv_1_6/ZN VDD VSS gf180mcu_fd_sc_mcu7t5v0__clkinv_1
Xgf180mcu_fd_sc_mcu7t5v0__buf_1_41 VSS gf180mcu_fd_sc_mcu7t5v0__or2_1_0/A1 gf180mcu_fd_sc_mcu7t5v0__buf_1_42/I
+ VDD VDD VSS gf180mcu_fd_sc_mcu7t5v0__buf_1
Xgf180mcu_fd_sc_mcu7t5v0__buf_1_30 VSS gf180mcu_fd_sc_mcu7t5v0__buf_1_30/Z gf180mcu_fd_sc_mcu7t5v0__buf_1_30/I
+ VDD VDD VSS gf180mcu_fd_sc_mcu7t5v0__buf_1
Xgf180mcu_fd_sc_mcu7t5v0__fillcap_4_210 VDD VSS VDD VSS gf180mcu_fd_sc_mcu7t5v0__fillcap_4
Xgf180mcu_fd_sc_mcu7t5v0__fillcap_8_17 VDD VSS VDD VSS gf180mcu_fd_sc_mcu7t5v0__fillcap_8
Xgf180mcu_fd_sc_mcu7t5v0__fillcap_8_39 VDD VSS VDD VSS gf180mcu_fd_sc_mcu7t5v0__fillcap_8
Xgf180mcu_fd_sc_mcu7t5v0__fillcap_8_28 VDD VSS VDD VSS gf180mcu_fd_sc_mcu7t5v0__fillcap_8
Xgf180mcu_fd_sc_mcu7t5v0__oai211_4_0 gf180mcu_fd_sc_mcu7t5v0__or2_4_0/Z gf180mcu_fd_sc_mcu7t5v0__buf_4_14/Z
+ VDD VSS gf180mcu_fd_sc_mcu7t5v0__buf_1_3/I gf180mcu_fd_sc_mcu7t5v0__nor2_1_2/ZN
+ gf180mcu_fd_sc_mcu7t5v0__and2_1_0/Z VDD VSS gf180mcu_fd_sc_mcu7t5v0__oai211_4
Xgf180mcu_fd_sc_mcu7t5v0__clkbuf_8_0 gf180mcu_fd_sc_mcu7t5v0__clkinv_1_7/I VSS VDD
+ gf180mcu_fd_sc_mcu7t5v0__clkbuf_8_6/I VDD VSS gf180mcu_fd_sc_mcu7t5v0__clkbuf_8
Xgf180mcu_fd_sc_mcu7t5v0__clkbuf_16_24 VDD VSS gf180mcu_fd_sc_mcu7t5v0__dffrnq_2_1/CLK
+ gf180mcu_fd_sc_mcu7t5v0__clkbuf_16_26/Z VDD VSS gf180mcu_fd_sc_mcu7t5v0__clkbuf_16
Xgf180mcu_fd_sc_mcu7t5v0__clkbuf_16_13 VDD VSS gf180mcu_fd_sc_mcu7t5v0__clkbuf_16_16/I
+ gf180mcu_fd_sc_mcu7t5v0__or2_1_1/Z VDD VSS gf180mcu_fd_sc_mcu7t5v0__clkbuf_16
Xgf180mcu_fd_sc_mcu7t5v0__clkbuf_16_6 VDD VSS gf180mcu_fd_sc_mcu7t5v0__clkbuf_16_6/Z
+ gf180mcu_fd_sc_mcu7t5v0__clkbuf_16_6/I VDD VSS gf180mcu_fd_sc_mcu7t5v0__clkbuf_16
Xgf180mcu_fd_sc_mcu7t5v0__nand2_1_4 VDD VSS gf180mcu_fd_sc_mcu7t5v0__oai22_1_6/B2
+ gf180mcu_fd_sc_mcu7t5v0__and4_1_4/Z gf180mcu_fd_sc_mcu7t5v0__nand2_1_4/A2 VDD VSS
+ gf180mcu_fd_sc_mcu7t5v0__nand2_1
Xgf180mcu_fd_sc_mcu7t5v0__clkinv_1_7 VDD VSS gf180mcu_fd_sc_mcu7t5v0__clkinv_1_7/I
+ gf180mcu_fd_sc_mcu7t5v0__clkinv_1_7/ZN VDD VSS gf180mcu_fd_sc_mcu7t5v0__clkinv_1
Xgf180mcu_fd_sc_mcu7t5v0__buf_1_31 VSS gf180mcu_fd_sc_mcu7t5v0__buf_1_31/Z gf180mcu_fd_sc_mcu7t5v0__buf_1_6/I
+ VDD VDD VSS gf180mcu_fd_sc_mcu7t5v0__buf_1
Xgf180mcu_fd_sc_mcu7t5v0__buf_1_20 VSS gf180mcu_fd_sc_mcu7t5v0__or4_1_2/A3 gf180mcu_fd_sc_mcu7t5v0__buf_1_20/I
+ VDD VDD VSS gf180mcu_fd_sc_mcu7t5v0__buf_1
Xgf180mcu_fd_sc_mcu7t5v0__buf_1_42 VSS gf180mcu_fd_sc_mcu7t5v0__buf_1_42/Z gf180mcu_fd_sc_mcu7t5v0__buf_1_42/I
+ VDD VDD VSS gf180mcu_fd_sc_mcu7t5v0__buf_1
Xgf180mcu_fd_sc_mcu7t5v0__fillcap_4_200 VDD VSS VDD VSS gf180mcu_fd_sc_mcu7t5v0__fillcap_4
Xgf180mcu_fd_sc_mcu7t5v0__fillcap_4_211 VDD VSS VDD VSS gf180mcu_fd_sc_mcu7t5v0__fillcap_4
Xgf180mcu_fd_sc_mcu7t5v0__fillcap_8_18 VDD VSS VDD VSS gf180mcu_fd_sc_mcu7t5v0__fillcap_8
Xgf180mcu_fd_sc_mcu7t5v0__fillcap_8_29 VDD VSS VDD VSS gf180mcu_fd_sc_mcu7t5v0__fillcap_8
Xgf180mcu_fd_sc_mcu7t5v0__buf_4_20 DCTRLP[6] gf180mcu_fd_sc_mcu7t5v0__buf_4_20/I VDD
+ VSS VDD VSS gf180mcu_fd_sc_mcu7t5v0__buf_4
Xgf180mcu_fd_sc_mcu7t5v0__or2_4_0 VDD VSS gf180mcu_fd_sc_mcu7t5v0__or2_4_0/Z gf180mcu_fd_sc_mcu7t5v0__or2_4_0/A1
+ gf180mcu_fd_sc_mcu7t5v0__buf_2_7/Z VDD VSS gf180mcu_fd_sc_mcu7t5v0__or2_4
Xgf180mcu_fd_sc_mcu7t5v0__clkbuf_8_1 gf180mcu_fd_sc_mcu7t5v0__clkbuf_8_1/Z VSS VDD
+ gf180mcu_fd_sc_mcu7t5v0__clkbuf_8_4/I VDD VSS gf180mcu_fd_sc_mcu7t5v0__clkbuf_8
Xgf180mcu_fd_sc_mcu7t5v0__clkbuf_16_14 VDD VSS gf180mcu_fd_sc_mcu7t5v0__clkbuf_16_15/I
+ DCMPN VDD VSS gf180mcu_fd_sc_mcu7t5v0__clkbuf_16
Xgf180mcu_fd_sc_mcu7t5v0__clkbuf_16_25 VDD VSS gf180mcu_fd_sc_mcu7t5v0__clkbuf_16_6/I
+ gf180mcu_fd_sc_mcu7t5v0__clkbuf_16_25/I VDD VSS gf180mcu_fd_sc_mcu7t5v0__clkbuf_16
Xgf180mcu_fd_sc_mcu7t5v0__clkbuf_16_7 VDD VSS gf180mcu_fd_sc_mcu7t5v0__clkbuf_8_24/I
+ gf180mcu_fd_sc_mcu7t5v0__clkbuf_16_7/I VDD VSS gf180mcu_fd_sc_mcu7t5v0__clkbuf_16
Xgf180mcu_fd_sc_mcu7t5v0__nand2_1_5 VDD VSS gf180mcu_fd_sc_mcu7t5v0__oai22_1_5/B2
+ gf180mcu_fd_sc_mcu7t5v0__and4_1_5/Z gf180mcu_fd_sc_mcu7t5v0__nand2_1_5/A2 VDD VSS
+ gf180mcu_fd_sc_mcu7t5v0__nand2_1
Xgf180mcu_fd_sc_mcu7t5v0__fillcap_8_0 VDD VSS VDD VSS gf180mcu_fd_sc_mcu7t5v0__fillcap_8
Xgf180mcu_fd_sc_mcu7t5v0__clkinv_1_8 VDD VSS gf180mcu_fd_sc_mcu7t5v0__clkinv_1_8/I
+ gf180mcu_fd_sc_mcu7t5v0__clkinv_1_8/ZN VDD VSS gf180mcu_fd_sc_mcu7t5v0__clkinv_1
Xgf180mcu_fd_sc_mcu7t5v0__buf_1_32 VSS gf180mcu_fd_sc_mcu7t5v0__buf_1_32/Z gf180mcu_fd_sc_mcu7t5v0__buf_1_4/I
+ VDD VDD VSS gf180mcu_fd_sc_mcu7t5v0__buf_1
Xgf180mcu_fd_sc_mcu7t5v0__buf_1_43 VSS gf180mcu_fd_sc_mcu7t5v0__buf_1_43/Z gf180mcu_fd_sc_mcu7t5v0__buf_1_43/I
+ VDD VDD VSS gf180mcu_fd_sc_mcu7t5v0__buf_1
Xgf180mcu_fd_sc_mcu7t5v0__buf_1_10 VSS gf180mcu_fd_sc_mcu7t5v0__buf_1_8/I gf180mcu_fd_sc_mcu7t5v0__buf_1_10/I
+ VDD VDD VSS gf180mcu_fd_sc_mcu7t5v0__buf_1
Xgf180mcu_fd_sc_mcu7t5v0__buf_1_21 VSS gf180mcu_fd_sc_mcu7t5v0__or4_1_2/A4 gf180mcu_fd_sc_mcu7t5v0__buf_1_7/I
+ VDD VDD VSS gf180mcu_fd_sc_mcu7t5v0__buf_1
Xgf180mcu_fd_sc_mcu7t5v0__fillcap_4_201 VDD VSS VDD VSS gf180mcu_fd_sc_mcu7t5v0__fillcap_4
Xgf180mcu_fd_sc_mcu7t5v0__fillcap_4_212 VDD VSS VDD VSS gf180mcu_fd_sc_mcu7t5v0__fillcap_4
Xgf180mcu_fd_sc_mcu7t5v0__nand3_2_0 gf180mcu_fd_sc_mcu7t5v0__buf_2_1/I VDD VSS gf180mcu_fd_sc_mcu7t5v0__buf_2_4/I
+ gf180mcu_fd_sc_mcu7t5v0__buf_1_1/Z gf180mcu_fd_sc_mcu7t5v0__dlyb_1_0/I VDD VSS gf180mcu_fd_sc_mcu7t5v0__nand3_2
Xgf180mcu_fd_sc_mcu7t5v0__or4_1_0 gf180mcu_fd_sc_mcu7t5v0__or4_1_0/A3 gf180mcu_fd_sc_mcu7t5v0__or4_1_0/A4
+ VDD VSS gf180mcu_fd_sc_mcu7t5v0__or4_1_0/Z gf180mcu_fd_sc_mcu7t5v0__or4_1_0/A1 gf180mcu_fd_sc_mcu7t5v0__or4_1_0/A2
+ VDD VSS gf180mcu_fd_sc_mcu7t5v0__or4_1
Xgf180mcu_fd_sc_mcu7t5v0__fillcap_8_19 VDD VSS VDD VSS gf180mcu_fd_sc_mcu7t5v0__fillcap_8
Xgf180mcu_fd_sc_mcu7t5v0__buf_4_21 DCTRLP[4] gf180mcu_fd_sc_mcu7t5v0__buf_4_21/I VDD
+ VSS VDD VSS gf180mcu_fd_sc_mcu7t5v0__buf_4
Xgf180mcu_fd_sc_mcu7t5v0__buf_4_10 DCTRLN[3] gf180mcu_fd_sc_mcu7t5v0__buf_4_10/I VDD
+ VSS VDD VSS gf180mcu_fd_sc_mcu7t5v0__buf_4
Xgf180mcu_fd_sc_mcu7t5v0__clkbuf_8_2 gf180mcu_fd_sc_mcu7t5v0__clkbuf_8_2/Z VSS VDD
+ gf180mcu_fd_sc_mcu7t5v0__clkbuf_8_4/I VDD VSS gf180mcu_fd_sc_mcu7t5v0__clkbuf_8
Xgf180mcu_fd_sc_mcu7t5v0__clkbuf_16_15 VDD VSS gf180mcu_fd_sc_mcu7t5v0__clkbuf_16_9/I
+ gf180mcu_fd_sc_mcu7t5v0__clkbuf_16_15/I VDD VSS gf180mcu_fd_sc_mcu7t5v0__clkbuf_16
Xgf180mcu_fd_sc_mcu7t5v0__clkbuf_16_26 VDD VSS gf180mcu_fd_sc_mcu7t5v0__clkbuf_16_26/Z
+ gf180mcu_fd_sc_mcu7t5v0__clkbuf_16_26/I VDD VSS gf180mcu_fd_sc_mcu7t5v0__clkbuf_16
Xgf180mcu_fd_sc_mcu7t5v0__clkbuf_16_8 VDD VSS gf180mcu_fd_sc_mcu7t5v0__or2_1_1/A2
+ gf180mcu_fd_sc_mcu7t5v0__clkbuf_16_8/I VDD VSS gf180mcu_fd_sc_mcu7t5v0__clkbuf_16
Xgf180mcu_fd_sc_mcu7t5v0__fillcap_8_1 VDD VSS VDD VSS gf180mcu_fd_sc_mcu7t5v0__fillcap_8
Xgf180mcu_fd_sc_mcu7t5v0__nand2_1_6 VDD VSS gf180mcu_fd_sc_mcu7t5v0__nand2_1_6/ZN
+ gf180mcu_fd_sc_mcu7t5v0__or4_1_1/Z gf180mcu_fd_sc_mcu7t5v0__oai31_1_5/ZN VDD VSS
+ gf180mcu_fd_sc_mcu7t5v0__nand2_1
Xgf180mcu_fd_sc_mcu7t5v0__fillcap_64_90 VDD VSS VDD VSS gf180mcu_fd_sc_mcu7t5v0__fillcap_64
Xgf180mcu_fd_sc_mcu7t5v0__clkinv_1_9 VDD VSS gf180mcu_fd_sc_mcu7t5v0__clkinv_1_9/I
+ gf180mcu_fd_sc_mcu7t5v0__and4_4_0/A3 VDD VSS gf180mcu_fd_sc_mcu7t5v0__clkinv_1
Xgf180mcu_fd_sc_mcu7t5v0__buf_1_33 VSS gf180mcu_fd_sc_mcu7t5v0__or3_2_0/A3 gf180mcu_fd_sc_mcu7t5v0__buf_1_9/I
+ VDD VDD VSS gf180mcu_fd_sc_mcu7t5v0__buf_1
Xgf180mcu_fd_sc_mcu7t5v0__buf_1_44 VSS gf180mcu_fd_sc_mcu7t5v0__or3_2_0/A2 gf180mcu_fd_sc_mcu7t5v0__buf_1_44/I
+ VDD VDD VSS gf180mcu_fd_sc_mcu7t5v0__buf_1
Xgf180mcu_fd_sc_mcu7t5v0__buf_1_22 VSS gf180mcu_fd_sc_mcu7t5v0__buf_1_22/Z gf180mcu_fd_sc_mcu7t5v0__buf_1_9/I
+ VDD VDD VSS gf180mcu_fd_sc_mcu7t5v0__buf_1
Xgf180mcu_fd_sc_mcu7t5v0__buf_1_11 VSS gf180mcu_fd_sc_mcu7t5v0__or4_1_0/A3 gf180mcu_fd_sc_mcu7t5v0__buf_1_20/I
+ VDD VDD VSS gf180mcu_fd_sc_mcu7t5v0__buf_1
Xgf180mcu_fd_sc_mcu7t5v0__fillcap_4_202 VDD VSS VDD VSS gf180mcu_fd_sc_mcu7t5v0__fillcap_4
Xgf180mcu_fd_sc_mcu7t5v0__fillcap_4_213 VDD VSS VDD VSS gf180mcu_fd_sc_mcu7t5v0__fillcap_4
Xgf180mcu_fd_sc_mcu7t5v0__or4_1_1 gf180mcu_fd_sc_mcu7t5v0__or4_1_2/A3 gf180mcu_fd_sc_mcu7t5v0__buf_1_7/Z
+ VDD VSS gf180mcu_fd_sc_mcu7t5v0__or4_1_1/Z gf180mcu_fd_sc_mcu7t5v0__buf_1_3/Z gf180mcu_fd_sc_mcu7t5v0__or4_1_2/A2
+ VDD VSS gf180mcu_fd_sc_mcu7t5v0__or4_1
Xgf180mcu_fd_sc_mcu7t5v0__buf_4_22 DCTRLP[5] gf180mcu_fd_sc_mcu7t5v0__buf_4_22/I VDD
+ VSS VDD VSS gf180mcu_fd_sc_mcu7t5v0__buf_4
Xgf180mcu_fd_sc_mcu7t5v0__buf_4_11 DCTRLN[2] gf180mcu_fd_sc_mcu7t5v0__buf_4_11/I VDD
+ VSS VDD VSS gf180mcu_fd_sc_mcu7t5v0__buf_4
Xgf180mcu_fd_sc_mcu7t5v0__clkbuf_8_3 gf180mcu_fd_sc_mcu7t5v0__clkbuf_8_3/Z VSS VDD
+ gf180mcu_fd_sc_mcu7t5v0__clkbuf_8_5/I VDD VSS gf180mcu_fd_sc_mcu7t5v0__clkbuf_8
Xgf180mcu_fd_sc_mcu7t5v0__clkbuf_16_16 VDD VSS gf180mcu_fd_sc_mcu7t5v0__dlyb_1_1/I
+ gf180mcu_fd_sc_mcu7t5v0__clkbuf_16_16/I VDD VSS gf180mcu_fd_sc_mcu7t5v0__clkbuf_16
Xgf180mcu_fd_sc_mcu7t5v0__clkbuf_16_27 VDD VSS gf180mcu_fd_sc_mcu7t5v0__clkbuf_8_4/I
+ gf180mcu_fd_sc_mcu7t5v0__clkbuf_16_5/I VDD VSS gf180mcu_fd_sc_mcu7t5v0__clkbuf_16
Xgf180mcu_fd_sc_mcu7t5v0__clkbuf_16_9 VDD VSS gf180mcu_fd_sc_mcu7t5v0__clkbuf_16_9/Z
+ gf180mcu_fd_sc_mcu7t5v0__clkbuf_16_9/I VDD VSS gf180mcu_fd_sc_mcu7t5v0__clkbuf_16
Xgf180mcu_fd_sc_mcu7t5v0__fillcap_8_2 VDD VSS VDD VSS gf180mcu_fd_sc_mcu7t5v0__fillcap_8
Xgf180mcu_fd_sc_mcu7t5v0__oai211_2_0 gf180mcu_fd_sc_mcu7t5v0__and2_1_1/Z gf180mcu_fd_sc_mcu7t5v0__buf_2_9/I
+ gf180mcu_fd_sc_mcu7t5v0__nor4_1_0/A3 gf180mcu_fd_sc_mcu7t5v0__buf_2_14/Z gf180mcu_fd_sc_mcu7t5v0__buf_2_8/Z
+ VDD VSS VDD VSS gf180mcu_fd_sc_mcu7t5v0__oai211_2
Xgf180mcu_fd_sc_mcu7t5v0__nand2_1_7 VDD VSS gf180mcu_fd_sc_mcu7t5v0__buf_1_36/I gf180mcu_fd_sc_mcu7t5v0__oai22_1_7/A1
+ gf180mcu_fd_sc_mcu7t5v0__buf_1_12/Z VDD VSS gf180mcu_fd_sc_mcu7t5v0__nand2_1
Xgf180mcu_fd_sc_mcu7t5v0__fillcap_64_80 VDD VSS VDD VSS gf180mcu_fd_sc_mcu7t5v0__fillcap_64
Xgf180mcu_fd_sc_mcu7t5v0__fillcap_64_91 VDD VSS VDD VSS gf180mcu_fd_sc_mcu7t5v0__fillcap_64
Xgf180mcu_fd_sc_mcu7t5v0__buf_1_34 VSS gf180mcu_fd_sc_mcu7t5v0__buf_1_34/Z gf180mcu_fd_sc_mcu7t5v0__buf_1_4/I
+ VDD VDD VSS gf180mcu_fd_sc_mcu7t5v0__buf_1
Xgf180mcu_fd_sc_mcu7t5v0__buf_1_23 VSS gf180mcu_fd_sc_mcu7t5v0__or4_1_2/A2 gf180mcu_fd_sc_mcu7t5v0__buf_1_23/I
+ VDD VDD VSS gf180mcu_fd_sc_mcu7t5v0__buf_1
Xgf180mcu_fd_sc_mcu7t5v0__buf_1_12 VSS gf180mcu_fd_sc_mcu7t5v0__buf_1_12/Z gf180mcu_fd_sc_mcu7t5v0__buf_1_13/Z
+ VDD VDD VSS gf180mcu_fd_sc_mcu7t5v0__buf_1
Xgf180mcu_fd_sc_mcu7t5v0__fillcap_4_203 VDD VSS VDD VSS gf180mcu_fd_sc_mcu7t5v0__fillcap_4
Xgf180mcu_fd_sc_mcu7t5v0__fillcap_4_214 VDD VSS VDD VSS gf180mcu_fd_sc_mcu7t5v0__fillcap_4
Xgf180mcu_fd_sc_mcu7t5v0__oai31_1_10 VDD gf180mcu_fd_sc_mcu7t5v0__oai31_1_10/ZN gf180mcu_fd_sc_mcu7t5v0__oai31_1_7/ZN
+ gf180mcu_fd_sc_mcu7t5v0__buf_1_34/Z gf180mcu_fd_sc_mcu7t5v0__buf_2_6/I VSS gf180mcu_fd_sc_mcu7t5v0__oai31_2_1/A3
+ VDD VSS gf180mcu_fd_sc_mcu7t5v0__oai31_1
Xgf180mcu_fd_sc_mcu7t5v0__or4_1_2 gf180mcu_fd_sc_mcu7t5v0__or4_1_2/A3 gf180mcu_fd_sc_mcu7t5v0__or4_1_2/A4
+ VDD VSS gf180mcu_fd_sc_mcu7t5v0__or4_1_2/Z gf180mcu_fd_sc_mcu7t5v0__buf_2_3/Z gf180mcu_fd_sc_mcu7t5v0__or4_1_2/A2
+ VDD VSS gf180mcu_fd_sc_mcu7t5v0__or4_1
Xgf180mcu_fd_sc_mcu7t5v0__buf_4_23 DCTRLN[4] gf180mcu_fd_sc_mcu7t5v0__buf_4_23/I VDD
+ VSS VDD VSS gf180mcu_fd_sc_mcu7t5v0__buf_4
Xgf180mcu_fd_sc_mcu7t5v0__buf_4_12 gf180mcu_fd_sc_mcu7t5v0__buf_4_12/Z gf180mcu_fd_sc_mcu7t5v0__buf_4_24/I
+ VDD VSS VDD VSS gf180mcu_fd_sc_mcu7t5v0__buf_4
Xgf180mcu_fd_sc_mcu7t5v0__clkbuf_8_4 gf180mcu_fd_sc_mcu7t5v0__clkbuf_8_4/Z VSS VDD
+ gf180mcu_fd_sc_mcu7t5v0__clkbuf_8_4/I VDD VSS gf180mcu_fd_sc_mcu7t5v0__clkbuf_8
Xgf180mcu_fd_sc_mcu7t5v0__clkbuf_16_17 VDD VSS gf180mcu_fd_sc_mcu7t5v0__clkbuf_16_26/I
+ DCMPN VDD VSS gf180mcu_fd_sc_mcu7t5v0__clkbuf_16
Xgf180mcu_fd_sc_mcu7t5v0__clkbuf_16_28 VDD VSS gf180mcu_fd_sc_mcu7t5v0__clkbuf_8_29/I
+ gf180mcu_fd_sc_mcu7t5v0__clkbuf_16_7/I VDD VSS gf180mcu_fd_sc_mcu7t5v0__clkbuf_16
Xgf180mcu_fd_sc_mcu7t5v0__fillcap_8_3 VDD VSS VDD VSS gf180mcu_fd_sc_mcu7t5v0__fillcap_8
Xgf180mcu_fd_sc_mcu7t5v0__nand2_1_8 VDD VSS gf180mcu_fd_sc_mcu7t5v0__buf_1_7/I gf180mcu_fd_sc_mcu7t5v0__buf_1_30/Z
+ gf180mcu_fd_sc_mcu7t5v0__buf_1_9/Z VDD VSS gf180mcu_fd_sc_mcu7t5v0__nand2_1
Xgf180mcu_fd_sc_mcu7t5v0__fillcap_64_81 VDD VSS VDD VSS gf180mcu_fd_sc_mcu7t5v0__fillcap_64
Xgf180mcu_fd_sc_mcu7t5v0__fillcap_64_92 VDD VSS VDD VSS gf180mcu_fd_sc_mcu7t5v0__fillcap_64
Xgf180mcu_fd_sc_mcu7t5v0__fillcap_64_70 VDD VSS VDD VSS gf180mcu_fd_sc_mcu7t5v0__fillcap_64
Xgf180mcu_fd_sc_mcu7t5v0__clkbuf_8_30 gf180mcu_fd_sc_mcu7t5v0__clkinv_1_4/I VSS VDD
+ gf180mcu_fd_sc_mcu7t5v0__clkbuf_8_6/I VDD VSS gf180mcu_fd_sc_mcu7t5v0__clkbuf_8
Xgf180mcu_fd_sc_mcu7t5v0__buf_1_13 VSS gf180mcu_fd_sc_mcu7t5v0__buf_1_13/Z gf180mcu_fd_sc_mcu7t5v0__buf_1_8/I
+ VDD VDD VSS gf180mcu_fd_sc_mcu7t5v0__buf_1
Xgf180mcu_fd_sc_mcu7t5v0__buf_1_35 VSS gf180mcu_fd_sc_mcu7t5v0__buf_1_35/Z gf180mcu_fd_sc_mcu7t5v0__buf_1_4/I
+ VDD VDD VSS gf180mcu_fd_sc_mcu7t5v0__buf_1
Xgf180mcu_fd_sc_mcu7t5v0__buf_1_24 VSS gf180mcu_fd_sc_mcu7t5v0__buf_1_24/Z gf180mcu_fd_sc_mcu7t5v0__buf_1_24/I
+ VDD VDD VSS gf180mcu_fd_sc_mcu7t5v0__buf_1
Xgf180mcu_fd_sc_mcu7t5v0__fillcap_4_204 VDD VSS VDD VSS gf180mcu_fd_sc_mcu7t5v0__fillcap_4
Xgf180mcu_fd_sc_mcu7t5v0__fillcap_4_215 VDD VSS VDD VSS gf180mcu_fd_sc_mcu7t5v0__fillcap_4
Xgf180mcu_fd_sc_mcu7t5v0__oai31_1_11 VDD gf180mcu_fd_sc_mcu7t5v0__oai21_1_4/B gf180mcu_fd_sc_mcu7t5v0__buf_4_23/I
+ gf180mcu_fd_sc_mcu7t5v0__buf_1_4/Z gf180mcu_fd_sc_mcu7t5v0__buf_2_6/Z VSS gf180mcu_fd_sc_mcu7t5v0__buf_1_43/Z
+ VDD VSS gf180mcu_fd_sc_mcu7t5v0__oai31_1
Xgf180mcu_fd_sc_mcu7t5v0__clkbuf_2_10 gf180mcu_fd_sc_mcu7t5v0__clkbuf_2_10/Z VSS VDD
+ gf180mcu_fd_sc_mcu7t5v0__clkbuf_8_15/Z VDD VSS gf180mcu_fd_sc_mcu7t5v0__clkbuf_2
Xgf180mcu_fd_sc_mcu7t5v0__buf_4_24 gf180mcu_fd_sc_mcu7t5v0__buf_4_24/Z gf180mcu_fd_sc_mcu7t5v0__buf_4_24/I
+ VDD VSS VDD VSS gf180mcu_fd_sc_mcu7t5v0__buf_4
Xgf180mcu_fd_sc_mcu7t5v0__buf_4_13 DCTRLN[1] gf180mcu_fd_sc_mcu7t5v0__buf_4_13/I VDD
+ VSS VDD VSS gf180mcu_fd_sc_mcu7t5v0__buf_4
Xgf180mcu_fd_sc_mcu7t5v0__clkbuf_8_5 gf180mcu_fd_sc_mcu7t5v0__clkbuf_8_5/Z VSS VDD
+ gf180mcu_fd_sc_mcu7t5v0__clkbuf_8_5/I VDD VSS gf180mcu_fd_sc_mcu7t5v0__clkbuf_8
Xgf180mcu_fd_sc_mcu7t5v0__clkbuf_16_18 VDD VSS gf180mcu_fd_sc_mcu7t5v0__nor3_1_0/A2
+ gf180mcu_fd_sc_mcu7t5v0__clkbuf_16_18/I VDD VSS gf180mcu_fd_sc_mcu7t5v0__clkbuf_16
Xgf180mcu_fd_sc_mcu7t5v0__clkbuf_16_29 VDD VSS gf180mcu_fd_sc_mcu7t5v0__clkbuf_8_6/I
+ gf180mcu_fd_sc_mcu7t5v0__clkbuf_16_7/I VDD VSS gf180mcu_fd_sc_mcu7t5v0__clkbuf_16
Xgf180mcu_fd_sc_mcu7t5v0__nand2_1_9 VDD VSS gf180mcu_fd_sc_mcu7t5v0__buf_1_43/I gf180mcu_fd_sc_mcu7t5v0__buf_1_17/Z
+ gf180mcu_fd_sc_mcu7t5v0__buf_1_12/Z VDD VSS gf180mcu_fd_sc_mcu7t5v0__nand2_1
Xgf180mcu_fd_sc_mcu7t5v0__fillcap_8_4 VDD VSS VDD VSS gf180mcu_fd_sc_mcu7t5v0__fillcap_8
Xgf180mcu_fd_sc_mcu7t5v0__fillcap_64_82 VDD VSS VDD VSS gf180mcu_fd_sc_mcu7t5v0__fillcap_64
Xgf180mcu_fd_sc_mcu7t5v0__fillcap_64_60 VDD VSS VDD VSS gf180mcu_fd_sc_mcu7t5v0__fillcap_64
Xgf180mcu_fd_sc_mcu7t5v0__fillcap_64_71 VDD VSS VDD VSS gf180mcu_fd_sc_mcu7t5v0__fillcap_64
Xgf180mcu_fd_sc_mcu7t5v0__fillcap_64_93 VDD VSS VDD VSS gf180mcu_fd_sc_mcu7t5v0__fillcap_64
Xgf180mcu_fd_sc_mcu7t5v0__clkbuf_8_20 gf180mcu_fd_sc_mcu7t5v0__clkinv_1_48/I VSS VDD
+ gf180mcu_fd_sc_mcu7t5v0__clkbuf_8_24/I VDD VSS gf180mcu_fd_sc_mcu7t5v0__clkbuf_8
Xgf180mcu_fd_sc_mcu7t5v0__clkbuf_8_31 gf180mcu_fd_sc_mcu7t5v0__clkbuf_2_8/I VSS VDD
+ gf180mcu_fd_sc_mcu7t5v0__clkbuf_8_8/I VDD VSS gf180mcu_fd_sc_mcu7t5v0__clkbuf_8
Xgf180mcu_fd_sc_mcu7t5v0__buf_1_36 VSS gf180mcu_fd_sc_mcu7t5v0__buf_1_36/Z gf180mcu_fd_sc_mcu7t5v0__buf_1_36/I
+ VDD VDD VSS gf180mcu_fd_sc_mcu7t5v0__buf_1
Xgf180mcu_fd_sc_mcu7t5v0__buf_1_25 VSS gf180mcu_fd_sc_mcu7t5v0__buf_1_25/Z gf180mcu_fd_sc_mcu7t5v0__buf_2_8/I
+ VDD VDD VSS gf180mcu_fd_sc_mcu7t5v0__buf_1
Xgf180mcu_fd_sc_mcu7t5v0__buf_1_14 VSS gf180mcu_fd_sc_mcu7t5v0__buf_1_23/I gf180mcu_fd_sc_mcu7t5v0__buf_1_24/I
+ VDD VDD VSS gf180mcu_fd_sc_mcu7t5v0__buf_1
Xgf180mcu_fd_sc_mcu7t5v0__fillcap_4_205 VDD VSS VDD VSS gf180mcu_fd_sc_mcu7t5v0__fillcap_4
Xgf180mcu_fd_sc_mcu7t5v0__oai31_1_12 VDD gf180mcu_fd_sc_mcu7t5v0__oai31_1_12/ZN gf180mcu_fd_sc_mcu7t5v0__oai31_1_12/B
+ gf180mcu_fd_sc_mcu7t5v0__buf_1_4/Z gf180mcu_fd_sc_mcu7t5v0__buf_2_6/Z VSS gf180mcu_fd_sc_mcu7t5v0__buf_1_43/Z
+ VDD VSS gf180mcu_fd_sc_mcu7t5v0__oai31_1
Xgf180mcu_fd_sc_mcu7t5v0__clkbuf_2_11 gf180mcu_fd_sc_mcu7t5v0__clkbuf_2_11/Z VSS VDD
+ gf180mcu_fd_sc_mcu7t5v0__clkbuf_8_19/Z VDD VSS gf180mcu_fd_sc_mcu7t5v0__clkbuf_2
Xgf180mcu_fd_sc_mcu7t5v0__buf_4_14 gf180mcu_fd_sc_mcu7t5v0__buf_4_14/Z gf180mcu_fd_sc_mcu7t5v0__buf_4_14/I
+ VDD VSS VDD VSS gf180mcu_fd_sc_mcu7t5v0__buf_4
Xgf180mcu_fd_sc_mcu7t5v0__buf_4_25 DCTRLP[1] gf180mcu_fd_sc_mcu7t5v0__buf_4_25/I VDD
+ VSS VDD VSS gf180mcu_fd_sc_mcu7t5v0__buf_4
Xgf180mcu_fd_sc_mcu7t5v0__clkbuf_8_6 gf180mcu_fd_sc_mcu7t5v0__clkbuf_8_6/Z VSS VDD
+ gf180mcu_fd_sc_mcu7t5v0__clkbuf_8_6/I VDD VSS gf180mcu_fd_sc_mcu7t5v0__clkbuf_8
Xgf180mcu_fd_sc_mcu7t5v0__clkbuf_16_19 VDD VSS gf180mcu_fd_sc_mcu7t5v0__clkbuf_16_25/I
+ DCMPP VDD VSS gf180mcu_fd_sc_mcu7t5v0__clkbuf_16
Xgf180mcu_fd_sc_mcu7t5v0__fillcap_8_5 VDD VSS VDD VSS gf180mcu_fd_sc_mcu7t5v0__fillcap_8
Xgf180mcu_fd_sc_mcu7t5v0__fillcap_64_50 VDD VSS VDD VSS gf180mcu_fd_sc_mcu7t5v0__fillcap_64
Xgf180mcu_fd_sc_mcu7t5v0__fillcap_64_72 VDD VSS VDD VSS gf180mcu_fd_sc_mcu7t5v0__fillcap_64
Xgf180mcu_fd_sc_mcu7t5v0__fillcap_64_61 VDD VSS VDD VSS gf180mcu_fd_sc_mcu7t5v0__fillcap_64
Xgf180mcu_fd_sc_mcu7t5v0__fillcap_64_83 VDD VSS VDD VSS gf180mcu_fd_sc_mcu7t5v0__fillcap_64
Xgf180mcu_fd_sc_mcu7t5v0__clkbuf_8_21 gf180mcu_fd_sc_mcu7t5v0__clkbuf_8_21/Z VSS VDD
+ gf180mcu_fd_sc_mcu7t5v0__clkbuf_8_22/I VDD VSS gf180mcu_fd_sc_mcu7t5v0__clkbuf_8
Xgf180mcu_fd_sc_mcu7t5v0__clkbuf_8_10 gf180mcu_fd_sc_mcu7t5v0__clkinv_1_37/I VSS VDD
+ gf180mcu_fd_sc_mcu7t5v0__clkbuf_8_9/I VDD VSS gf180mcu_fd_sc_mcu7t5v0__clkbuf_8
Xgf180mcu_fd_sc_mcu7t5v0__buf_1_37 VSS gf180mcu_fd_sc_mcu7t5v0__buf_1_37/Z gf180mcu_fd_sc_mcu7t5v0__buf_2_9/Z
+ VDD VDD VSS gf180mcu_fd_sc_mcu7t5v0__buf_1
Xgf180mcu_fd_sc_mcu7t5v0__buf_1_26 VSS gf180mcu_fd_sc_mcu7t5v0__buf_2_7/I gf180mcu_fd_sc_mcu7t5v0__buf_1_26/I
+ VDD VDD VSS gf180mcu_fd_sc_mcu7t5v0__buf_1
Xgf180mcu_fd_sc_mcu7t5v0__buf_1_15 VSS gf180mcu_fd_sc_mcu7t5v0__buf_1_15/Z gf180mcu_fd_sc_mcu7t5v0__buf_1_36/I
+ VDD VDD VSS gf180mcu_fd_sc_mcu7t5v0__buf_1
.ends

.subckt R8E__nfet_03v3_6LX9QF a_n148_n585# a_n36_618# a_28_n646# VSUBS
X0 a_28_n646# a_n36_618# a_n148_n585# VSUBS nfet_03v3 ad=3.69235p pd=13.64u as=3.69235p ps=13.64u w=6.22u l=0.28u
.ends

.subckt R8E__pfet_03v3_GXTH48 a_n148_n422# a_n36_n559# a_28_n467# w_n234_n645#
X0 a_28_n467# a_n36_n559# a_n148_n422# w_n234_n645# pfet_03v3 ad=2.77275p pd=10.54u as=2.77275p ps=10.54u w=4.67u l=0.28u
.ends

.subckt R8E__nfet_03v3_WHE5HU a_n148_n236# a_n36_230# a_28_n258# VSUBS
X0 a_28_n258# a_n36_230# a_n148_n236# VSUBS nfet_03v3 ad=1.3897p pd=5.88u as=1.3897p ps=5.88u w=2.34u l=0.28u
.ends

.subckt R8E__pfet_03v3_8RS7KV w_n234_n1422# a_n36_n1336# a_n148_n1121# a_28_n1244#
X0 a_28_n1244# a_n36_n1336# a_n148_n1121# w_n234_n1422# pfet_03v3 ad=7.38405p pd=26.08u as=7.38405p ps=26.08u w=12.44u l=0.28u
.ends

.subckt R8E__A44_DCTRL_BIT_DRIVER_R4 VDD GND CTRL_IN CTRL_OUT
XXDCTRL_INV2_NMOS_R0 GND MID CTRL_OUT GND R8E__nfet_03v3_6LX9QF
XXDCTRL_INV1_PMOS_R0 VDD CTRL_IN MID VDD R8E__pfet_03v3_GXTH48
XXDCTRL_INV1_NMOS_R0 GND CTRL_IN MID GND R8E__nfet_03v3_WHE5HU
XXDCTRL_INV2_PMOS_R0 VDD MID VDD CTRL_OUT R8E__pfet_03v3_8RS7KV
.ends

.subckt R8E__A44_DCTRL_STRIP_E_R2 VDD CTRL_OUT[1] CTRL_OUT[2] CTRL_OUT[3] CTRL_OUT[4]
+ CTRL_OUT[5] CTRL_OUT[6] CTRL_OUT[7] CTRL_IN[1] CTRL_IN[2] CTRL_IN[3] CTRL_IN[4]
+ CTRL_IN[5] CTRL_IN[6] CTRL_IN[7] GND
XXDCTRL_CH5_R0 VDD GND CTRL_IN[5] CTRL_OUT[5] R8E__A44_DCTRL_BIT_DRIVER_R4
XXDCTRL_CH2_R0 VDD GND CTRL_IN[2] CTRL_OUT[2] R8E__A44_DCTRL_BIT_DRIVER_R4
XXDCTRL_CH6_R0 VDD GND CTRL_IN[6] CTRL_OUT[6] R8E__A44_DCTRL_BIT_DRIVER_R4
XXDCTRL_CH3_R0 VDD GND CTRL_IN[3] CTRL_OUT[3] R8E__A44_DCTRL_BIT_DRIVER_R4
XXDCTRL_CH1_R0 VDD GND CTRL_IN[1] CTRL_OUT[1] R8E__A44_DCTRL_BIT_DRIVER_R4
XXDCTRL_CH7_R0 VDD GND CTRL_IN[7] CTRL_OUT[7] R8E__A44_DCTRL_BIT_DRIVER_R4
XXDCTRL_CH4_R0 VDD GND CTRL_IN[4] CTRL_OUT[4] R8E__A44_DCTRL_BIT_DRIVER_R4
.ends

.subckt R8E__pfet_03v3_X2N4NU a_588_n132# a_76_n224# a_524_n224# w_n794_n310# a_140_n132#
+ a_n84_n132# a_n372_n224# a_n532_n132# a_n148_n224# a_364_n132# a_n308_n132# a_n596_n224#
+ a_300_n224# a_n708_n118#
X0 a_364_n132# a_300_n224# a_140_n132# w_n794_n310# pfet_03v3 ad=0.6552p pd=2.4u as=0.6552p ps=2.4u w=1.56u l=0.28u
X1 a_140_n132# a_76_n224# a_n84_n132# w_n794_n310# pfet_03v3 ad=0.6552p pd=2.4u as=0.6552p ps=2.4u w=1.56u l=0.28u
X2 a_588_n132# a_524_n224# a_364_n132# w_n794_n310# pfet_03v3 ad=0.9269p pd=4.32u as=0.6552p ps=2.4u w=1.56u l=0.28u
X3 a_n84_n132# a_n148_n224# a_n308_n132# w_n794_n310# pfet_03v3 ad=0.6552p pd=2.4u as=0.6552p ps=2.4u w=1.56u l=0.28u
X4 a_n532_n132# a_n596_n224# a_n708_n118# w_n794_n310# pfet_03v3 ad=0.6552p pd=2.4u as=0.9269p ps=4.32u w=1.56u l=0.28u
X5 a_n308_n132# a_n372_n224# a_n532_n132# w_n794_n310# pfet_03v3 ad=0.6552p pd=2.4u as=0.6552p ps=2.4u w=1.56u l=0.28u
.ends

.subckt R8E__nfet_03v3_GE79XY a_n532_n102# a_748_74# a_364_n102# a_n308_n102# a_524_74#
+ a_812_n102# a_n756_n102# a_300_74# a_588_n102# a_n932_n96# a_76_74# a_n148_74# a_n596_74#
+ a_140_n102# a_n84_n102# a_n372_74# a_n820_74# VSUBS
X0 a_140_n102# a_76_74# a_n84_n102# VSUBS nfet_03v3 ad=0.3276p pd=1.62u as=0.3276p ps=1.62u w=0.78u l=0.28u
X1 a_812_n102# a_748_74# a_588_n102# VSUBS nfet_03v3 ad=0.4641p pd=2.76u as=0.3276p ps=1.62u w=0.78u l=0.28u
X2 a_588_n102# a_524_74# a_364_n102# VSUBS nfet_03v3 ad=0.3276p pd=1.62u as=0.3276p ps=1.62u w=0.78u l=0.28u
X3 a_n756_n102# a_n820_74# a_n932_n96# VSUBS nfet_03v3 ad=0.3276p pd=1.62u as=0.4641p ps=2.76u w=0.78u l=0.28u
X4 a_n84_n102# a_n148_74# a_n308_n102# VSUBS nfet_03v3 ad=0.3276p pd=1.62u as=0.3276p ps=1.62u w=0.78u l=0.28u
X5 a_n532_n102# a_n596_74# a_n756_n102# VSUBS nfet_03v3 ad=0.3276p pd=1.62u as=0.3276p ps=1.62u w=0.78u l=0.28u
X6 a_n308_n102# a_n372_74# a_n532_n102# VSUBS nfet_03v3 ad=0.3276p pd=1.62u as=0.3276p ps=1.62u w=0.78u l=0.28u
X7 a_364_n102# a_300_74# a_140_n102# VSUBS nfet_03v3 ad=0.3276p pd=1.62u as=0.3276p ps=1.62u w=0.78u l=0.28u
.ends

.subckt R8E__nfet_03v3_9HSG6M a_n532_n102# a_364_n102# a_n308_n102# a_524_74# a_300_74#
+ a_588_n102# a_n708_n96# a_76_74# a_n148_74# a_n596_74# a_140_n102# a_n84_n102# a_n372_74#
+ VSUBS
X0 a_140_n102# a_76_74# a_n84_n102# VSUBS nfet_03v3 ad=0.3276p pd=1.62u as=0.3276p ps=1.62u w=0.78u l=0.28u
X1 a_588_n102# a_524_74# a_364_n102# VSUBS nfet_03v3 ad=0.4641p pd=2.76u as=0.3276p ps=1.62u w=0.78u l=0.28u
X2 a_n84_n102# a_n148_74# a_n308_n102# VSUBS nfet_03v3 ad=0.3276p pd=1.62u as=0.3276p ps=1.62u w=0.78u l=0.28u
X3 a_n532_n102# a_n596_74# a_n708_n96# VSUBS nfet_03v3 ad=0.3276p pd=1.62u as=0.4641p ps=2.76u w=0.78u l=0.28u
X4 a_n308_n102# a_n372_74# a_n532_n102# VSUBS nfet_03v3 ad=0.3276p pd=1.62u as=0.3276p ps=1.62u w=0.78u l=0.28u
X5 a_364_n102# a_300_74# a_140_n102# VSUBS nfet_03v3 ad=0.3276p pd=1.62u as=0.3276p ps=1.62u w=0.78u l=0.28u
.ends

.subckt R8E__pfet_03v3_FKHA32 w_n1018_n310# a_588_n132# a_76_n224# a_524_n224# a_140_n132#
+ a_748_n224# a_n84_n132# a_n372_n224# a_n532_n132# a_n820_n224# a_n932_n118# a_n148_n224#
+ a_364_n132# a_n308_n132# a_n596_n224# a_812_n132# a_n756_n132# a_300_n224#
X0 a_364_n132# a_300_n224# a_140_n132# w_n1018_n310# pfet_03v3 ad=0.6552p pd=2.4u as=0.6552p ps=2.4u w=1.56u l=0.28u
X1 a_140_n132# a_76_n224# a_n84_n132# w_n1018_n310# pfet_03v3 ad=0.6552p pd=2.4u as=0.6552p ps=2.4u w=1.56u l=0.28u
X2 a_812_n132# a_748_n224# a_588_n132# w_n1018_n310# pfet_03v3 ad=0.9269p pd=4.32u as=0.6552p ps=2.4u w=1.56u l=0.28u
X3 a_588_n132# a_524_n224# a_364_n132# w_n1018_n310# pfet_03v3 ad=0.6552p pd=2.4u as=0.6552p ps=2.4u w=1.56u l=0.28u
X4 a_n756_n132# a_n820_n224# a_n932_n118# w_n1018_n310# pfet_03v3 ad=0.6552p pd=2.4u as=0.9269p ps=4.32u w=1.56u l=0.28u
X5 a_n84_n132# a_n148_n224# a_n308_n132# w_n1018_n310# pfet_03v3 ad=0.6552p pd=2.4u as=0.6552p ps=2.4u w=1.56u l=0.28u
X6 a_n532_n132# a_n596_n224# a_n756_n132# w_n1018_n310# pfet_03v3 ad=0.6552p pd=2.4u as=0.6552p ps=2.4u w=1.56u l=0.28u
X7 a_n308_n132# a_n372_n224# a_n532_n132# w_n1018_n310# pfet_03v3 ad=0.6552p pd=2.4u as=0.6552p ps=2.4u w=1.56u l=0.28u
.ends

.subckt R8E__A44_TGDRV_PCLK_ROW_E_R1 CLKS P_CLK VDD GND
XPCLK_P_X2_X4_E_R0 VDD net4 net4 VDD VDD net5 CLKS net4 net4 net5 VDD CLKS net4 VDD
+ R8E__pfet_03v3_X2N4NU
XPCLK_N_X8_E_R0 GND net5 GND P_CLK net5 GND P_CLK net5 P_CLK GND net5 net5 net5 P_CLK
+ GND net5 net5 GND R8E__nfet_03v3_GE79XY
XPCLK_N_X2_X4_E_R0 net4 net5 GND net4 net4 GND GND net4 net4 CLKS GND net5 CLKS GND
+ R8E__nfet_03v3_9HSG6M
XPCLK_P_X8_E_R0 VDD P_CLK net5 net5 P_CLK net5 VDD net5 VDD net5 VDD net5 VDD P_CLK
+ net5 VDD P_CLK net5 R8E__pfet_03v3_FKHA32
.ends

.subckt R8E__nfet_03v3_YTQ48T a_n532_n54# a_748_n146# a_n372_n146# a_n308_n54# a_n820_n146#
+ a_588_n54# a_364_n54# a_n1044_n146# a_n148_n146# a_140_n54# a_n596_n146# a_300_n146#
+ a_1036_n54# a_812_n54# a_76_n146# a_524_n146# a_972_n146# a_n1156_n48# a_n84_n54#
+ a_n980_n54# a_n756_n54# VSUBS
X0 a_n532_n54# a_n596_n146# a_n756_n54# VSUBS nfet_03v3 ad=0.3276p pd=1.62u as=0.3276p ps=1.62u w=0.78u l=0.28u
X1 a_140_n54# a_76_n146# a_n84_n54# VSUBS nfet_03v3 ad=0.3276p pd=1.62u as=0.3276p ps=1.62u w=0.78u l=0.28u
X2 a_588_n54# a_524_n146# a_364_n54# VSUBS nfet_03v3 ad=0.3276p pd=1.62u as=0.3276p ps=1.62u w=0.78u l=0.28u
X3 a_n980_n54# a_n1044_n146# a_n1156_n48# VSUBS nfet_03v3 ad=0.3276p pd=1.62u as=0.4641p ps=2.76u w=0.78u l=0.28u
X4 a_n308_n54# a_n372_n146# a_n532_n54# VSUBS nfet_03v3 ad=0.3276p pd=1.62u as=0.3276p ps=1.62u w=0.78u l=0.28u
X5 a_1036_n54# a_972_n146# a_812_n54# VSUBS nfet_03v3 ad=0.4641p pd=2.76u as=0.3276p ps=1.62u w=0.78u l=0.28u
X6 a_364_n54# a_300_n146# a_140_n54# VSUBS nfet_03v3 ad=0.3276p pd=1.62u as=0.3276p ps=1.62u w=0.78u l=0.28u
X7 a_n756_n54# a_n820_n146# a_n980_n54# VSUBS nfet_03v3 ad=0.3276p pd=1.62u as=0.3276p ps=1.62u w=0.78u l=0.28u
X8 a_n84_n54# a_n148_n146# a_n308_n54# VSUBS nfet_03v3 ad=0.3276p pd=1.62u as=0.3276p ps=1.62u w=0.78u l=0.28u
X9 a_812_n54# a_748_n146# a_588_n54# VSUBS nfet_03v3 ad=0.3276p pd=1.62u as=0.3276p ps=1.62u w=0.78u l=0.28u
.ends

.subckt R8E__pfet_03v3_TTAYZ7 a_n420_n180# w_n682_n310# a_252_n180# a_n196_n180# a_n596_n166#
+ a_188_152# a_476_n180# a_28_n180# a_n484_152# a_n260_152# a_n36_152# a_412_152#
X0 a_n196_n180# a_n260_152# a_n420_n180# w_n682_n310# pfet_03v3 ad=0.6552p pd=2.4u as=0.6552p ps=2.4u w=1.56u l=0.28u
X1 a_28_n180# a_n36_152# a_n196_n180# w_n682_n310# pfet_03v3 ad=0.6552p pd=2.4u as=0.6552p ps=2.4u w=1.56u l=0.28u
X2 a_476_n180# a_412_152# a_252_n180# w_n682_n310# pfet_03v3 ad=0.9269p pd=4.32u as=0.6552p ps=2.4u w=1.56u l=0.28u
X3 a_252_n180# a_188_152# a_28_n180# w_n682_n310# pfet_03v3 ad=0.6552p pd=2.4u as=0.6552p ps=2.4u w=1.56u l=0.28u
X4 a_n420_n180# a_n484_152# a_n596_n166# w_n682_n310# pfet_03v3 ad=0.6552p pd=2.4u as=0.9269p ps=4.32u w=1.56u l=0.28u
.ends

.subckt R8E__nfet_03v3_YTZ44F a_28_n54# a_n596_n48# a_n196_n54# a_n36_n146# a_n484_n146#
+ a_n420_n54# a_412_n146# a_476_n54# a_188_n146# a_252_n54# a_n260_n146# VSUBS
X0 a_n420_n54# a_n484_n146# a_n596_n48# VSUBS nfet_03v3 ad=0.3276p pd=1.62u as=0.4641p ps=2.76u w=0.78u l=0.28u
X1 a_476_n54# a_412_n146# a_252_n54# VSUBS nfet_03v3 ad=0.4641p pd=2.76u as=0.3276p ps=1.62u w=0.78u l=0.28u
X2 a_n196_n54# a_n260_n146# a_n420_n54# VSUBS nfet_03v3 ad=0.3276p pd=1.62u as=0.3276p ps=1.62u w=0.78u l=0.28u
X3 a_252_n54# a_188_n146# a_28_n54# VSUBS nfet_03v3 ad=0.3276p pd=1.62u as=0.3276p ps=1.62u w=0.78u l=0.28u
X4 a_28_n54# a_n36_n146# a_n196_n54# VSUBS nfet_03v3 ad=0.3276p pd=1.62u as=0.3276p ps=1.62u w=0.78u l=0.28u
.ends

.subckt R8E__pfet_03v3_PUCBRS a_n596_152# a_n372_152# a_140_n180# a_n84_n180# a_76_152#
+ a_n148_152# a_n532_n180# a_972_152# a_n980_n180# a_748_152# a_524_152# a_n1044_152#
+ a_364_n180# a_300_152# a_n820_152# a_n308_n180# a_n1156_n166# a_812_n180# a_n756_n180#
+ w_n1242_n310# a_588_n180# a_1036_n180#
X0 a_364_n180# a_300_152# a_140_n180# w_n1242_n310# pfet_03v3 ad=0.6552p pd=2.4u as=0.6552p ps=2.4u w=1.56u l=0.28u
X1 a_140_n180# a_76_152# a_n84_n180# w_n1242_n310# pfet_03v3 ad=0.6552p pd=2.4u as=0.6552p ps=2.4u w=1.56u l=0.28u
X2 a_812_n180# a_748_152# a_588_n180# w_n1242_n310# pfet_03v3 ad=0.6552p pd=2.4u as=0.6552p ps=2.4u w=1.56u l=0.28u
X3 a_n980_n180# a_n1044_152# a_n1156_n166# w_n1242_n310# pfet_03v3 ad=0.6552p pd=2.4u as=0.9269p ps=4.32u w=1.56u l=0.28u
X4 a_588_n180# a_524_152# a_364_n180# w_n1242_n310# pfet_03v3 ad=0.6552p pd=2.4u as=0.6552p ps=2.4u w=1.56u l=0.28u
X5 a_n756_n180# a_n820_152# a_n980_n180# w_n1242_n310# pfet_03v3 ad=0.6552p pd=2.4u as=0.6552p ps=2.4u w=1.56u l=0.28u
X6 a_1036_n180# a_972_152# a_812_n180# w_n1242_n310# pfet_03v3 ad=0.9269p pd=4.32u as=0.6552p ps=2.4u w=1.56u l=0.28u
X7 a_n84_n180# a_n148_152# a_n308_n180# w_n1242_n310# pfet_03v3 ad=0.6552p pd=2.4u as=0.6552p ps=2.4u w=1.56u l=0.28u
X8 a_n532_n180# a_n596_152# a_n756_n180# w_n1242_n310# pfet_03v3 ad=0.6552p pd=2.4u as=0.6552p ps=2.4u w=1.56u l=0.28u
X9 a_n308_n180# a_n372_152# a_n532_n180# w_n1242_n310# pfet_03v3 ad=0.6552p pd=2.4u as=0.6552p ps=2.4u w=1.56u l=0.28u
.ends

.subckt R8E__A44_TGDRV_NCLK_ROW_E_R1 N_CLK CLKS VDD GND
XNCLK_N_X4_X6_E_R0 net3 net3 net2 GND net2 GND N_CLK net2 net3 GND net2 net3 GND N_CLK
+ net3 net3 net3 GND N_CLK net3 GND GND R8E__nfet_03v3_YTQ48T
XNCLK_P_X2_X3_E_R0 net1 VDD VDD VDD VDD net1 net2 net2 CLKS CLKS net1 net1 R8E__pfet_03v3_TTAYZ7
XNCLK_N_X2_X3_E_R0 net2 GND GND net1 CLKS net1 net1 net2 net1 GND CLKS GND R8E__nfet_03v3_YTZ44F
XNCLK_P_X4_X6_E_R0 net2 net2 VDD N_CLK net3 net3 net3 net3 net3 net3 net3 net2 N_CLK
+ net3 net2 VDD VDD N_CLK VDD VDD VDD VDD R8E__pfet_03v3_PUCBRS
.ends

.subckt R8E__A44_TGCLK_DRIVER_UDRV_E_R1 CLKS N_CLK P_CLK VDD GND
XPCLK_ROW_E_R0 CLKS P_CLK VDD GND R8E__A44_TGDRV_PCLK_ROW_E_R1
XNCLK_ROW_E_R0 N_CLK CLKS VDD GND R8E__A44_TGDRV_NCLK_ROW_E_R1
.ends

.subckt R8E__pfet_03v3_C2L3T7 a_28_1592# a_n36_n1452# a_n36_n2928# a_n148_1653# a_n148_n1299#
+ a_n148_177# a_n36_24# a_28_n1360# w_n234_n3014# a_28_116# a_28_n2836# a_n36_1500#
+ a_n148_n2775#
X0 a_28_1592# a_n36_1500# a_n148_1653# w_n234_n3014# pfet_03v3 ad=3.69235p pd=13.64u as=3.69235p ps=13.64u w=6.22u l=0.28u
X1 a_28_n2836# a_n36_n2928# a_n148_n2775# w_n234_n3014# pfet_03v3 ad=3.69235p pd=13.64u as=3.69235p ps=13.64u w=6.22u l=0.28u
X2 a_28_n1360# a_n36_n1452# a_n148_n1299# w_n234_n3014# pfet_03v3 ad=3.69235p pd=13.64u as=3.69235p ps=13.64u w=6.22u l=0.28u
X3 a_28_116# a_n36_24# a_n148_177# w_n234_n3014# pfet_03v3 ad=3.69235p pd=13.64u as=3.69235p ps=13.64u w=6.22u l=0.28u
.ends

.subckt R8E__nfet_03v3_SD8HJT a_n148_n1514# a_n148_98# a_28_n738# a_n148_n708# a_n36_n902#
+ a_28_68# a_28_874# a_n36_n96# a_n36_1516# a_n36_710# a_28_n1544# a_n148_904# VSUBS
X0 a_28_874# a_n36_1516# a_n148_904# VSUBS nfet_03v3 ad=1.8465p pd=7.42u as=1.8465p ps=7.42u w=3.11u l=0.28u
X1 a_28_68# a_n36_710# a_n148_98# VSUBS nfet_03v3 ad=1.8465p pd=7.42u as=1.8465p ps=7.42u w=3.11u l=0.28u
X2 a_28_n738# a_n36_n96# a_n148_n708# VSUBS nfet_03v3 ad=1.8465p pd=7.42u as=1.8465p ps=7.42u w=3.11u l=0.28u
X3 a_28_n1544# a_n36_n902# a_n148_n1514# VSUBS nfet_03v3 ad=1.8465p pd=7.42u as=1.8465p ps=7.42u w=3.11u l=0.28u
.ends

.subckt R8E__A44_TG8_CORE_R7 VDD GND VOUT VIN N_CLK P_CLK
XXTG_TRANS_PMOS_M4_0_R0 VOUT P_CLK P_CLK VIN VIN VIN P_CLK VOUT VDD VOUT VOUT P_CLK
+ VIN R8E__pfet_03v3_C2L3T7
XXTG_TRANS_NMOS_M4_0_R0 VIN VIN VOUT VIN N_CLK VOUT VOUT N_CLK N_CLK N_CLK VOUT VIN
+ GND R8E__nfet_03v3_SD8HJT
XXTG_TRANS_PMOS_M4_1_R0 VOUT P_CLK P_CLK VIN VIN VIN P_CLK VOUT VDD VOUT VOUT P_CLK
+ VIN R8E__pfet_03v3_C2L3T7
XXTG_TRANS_NMOS_M4_1_R0 VIN VIN VOUT VIN N_CLK VOUT VOUT N_CLK N_CLK N_CLK VOUT VIN
+ GND R8E__nfet_03v3_SD8HJT
.ends

.subckt R8E__A44_TG8_SLICE_UDRV_E_R1 VOUT VIN VDD GND CLKS
XXTG_UDRV_E_R0 CLKS XTG_UDRV_E_R0/N_CLK XTG_UDRV_E_R0/P_CLK VDD GND R8E__A44_TGCLK_DRIVER_UDRV_E_R1
XXTG_FIXED_CORE_E_R0 VDD GND VOUT VIN XTG_UDRV_E_R0/N_CLK XTG_UDRV_E_R0/P_CLK R8E__A44_TG8_CORE_R7
.ends

.subckt R8E__A44_MIM_6P855_R0 m4_n120_n120# m4_0_0#
X0 m4_0_0# m4_n120_n120# cap_mim_2f0_m4m5_noshield c_width=6.855u c_length=6.855u
.ends

.subckt R8E__A44_C1_MIM6_R0 V_BOT VTOP
XXMIM_R1_C2_R0 V_BOT VTOP R8E__A44_MIM_6P855_R0
XXMIM_R0_C2_R0 V_BOT VTOP R8E__A44_MIM_6P855_R0
XXMIM_R1_C0_R0 V_BOT VTOP R8E__A44_MIM_6P855_R0
XXMIM_R0_C0_R0 V_BOT VTOP R8E__A44_MIM_6P855_R0
XXMIM_R1_C1_R0 V_BOT VTOP R8E__A44_MIM_6P855_R0
XXMIM_R0_C1_R0 V_BOT VTOP R8E__A44_MIM_6P855_R0
.ends

.subckt R8E__A44_CAP_CORE128_M6_R1 CAP_BOTTOM_008 CAP_BOTTOM_009 CAP_BOTTOM_010 CAP_BOTTOM_011
+ CAP_BOTTOM_012 CAP_BOTTOM_013 CAP_BOTTOM_014 CAP_BOTTOM_015 CAP_BOTTOM_024 CAP_BOTTOM_025
+ CAP_BOTTOM_026 CAP_BOTTOM_027 CAP_BOTTOM_028 CAP_BOTTOM_029 CAP_BOTTOM_030 CAP_BOTTOM_031
+ CAP_BOTTOM_040 CAP_BOTTOM_041 CAP_BOTTOM_042 CAP_BOTTOM_043 CAP_BOTTOM_044 CAP_BOTTOM_045
+ CAP_BOTTOM_046 CAP_BOTTOM_047 CAP_BOTTOM_056 CAP_BOTTOM_057 CAP_BOTTOM_058 CAP_BOTTOM_059
+ CAP_BOTTOM_060 CAP_BOTTOM_061 CAP_BOTTOM_062 CAP_BOTTOM_063 CAP_BOTTOM_032 CAP_BOTTOM_033
+ CAP_BOTTOM_034 CAP_BOTTOM_035 CAP_BOTTOM_036 CAP_BOTTOM_037 CAP_BOTTOM_038 CAP_BOTTOM_039
+ CAP_BOTTOM_016 CAP_BOTTOM_017 CAP_BOTTOM_018 CAP_BOTTOM_019 CAP_BOTTOM_020 CAP_BOTTOM_021
+ CAP_BOTTOM_022 CAP_BOTTOM_023 CAP_BOTTOM_048 CAP_BOTTOM_049 CAP_BOTTOM_050 CAP_BOTTOM_051
+ CAP_BOTTOM_052 CAP_BOTTOM_053 CAP_BOTTOM_054 CAP_BOTTOM_055 CAP_BOTTOM_000 CAP_BOTTOM_001
+ CAP_BOTTOM_002 CAP_BOTTOM_003 CAP_BOTTOM_004 CAP_BOTTOM_005 CAP_BOTTOM_006 CAP_BOTTOM_007
+ CAP_BOTTOM_064 CAP_BOTTOM_065 CAP_BOTTOM_066 CAP_BOTTOM_067 CAP_BOTTOM_068 CAP_BOTTOM_069
+ CAP_BOTTOM_070 CAP_BOTTOM_071 CAP_BOTTOM_079 CAP_BOTTOM_080 CAP_BOTTOM_081 CAP_BOTTOM_082
+ CAP_BOTTOM_083 CAP_BOTTOM_084 CAP_BOTTOM_085 CAP_BOTTOM_086 CAP_BOTTOM_095 CAP_BOTTOM_096
+ CAP_BOTTOM_097 CAP_BOTTOM_098 CAP_BOTTOM_099 CAP_BOTTOM_100 CAP_BOTTOM_101 CAP_BOTTOM_102
+ CAP_BOTTOM_111 CAP_BOTTOM_112 CAP_BOTTOM_113 CAP_BOTTOM_114 CAP_BOTTOM_115 CAP_BOTTOM_116
+ CAP_BOTTOM_117 CAP_BOTTOM_118 GND CAP_BOTTOM_072 CAP_BOTTOM_073 CAP_BOTTOM_074 CAP_BOTTOM_075
+ CAP_BOTTOM_076 CAP_BOTTOM_077 CAP_BOTTOM_078 CAP_BOTTOM_103 CAP_BOTTOM_104 CAP_BOTTOM_105
+ CAP_BOTTOM_106 CAP_BOTTOM_107 CAP_BOTTOM_108 CAP_BOTTOM_109 CAP_BOTTOM_110 CAP_BOTTOM_087
+ CAP_BOTTOM_088 CAP_BOTTOM_089 CAP_BOTTOM_090 CAP_BOTTOM_091 CAP_BOTTOM_092 CAP_BOTTOM_093
+ CAP_BOTTOM_094 CAP_BOTTOM_119 CAP_BOTTOM_120 CAP_BOTTOM_121 CAP_BOTTOM_122 CAP_BOTTOM_123
+ CAP_BOTTOM_124 CAP_BOTTOM_125 CAP_BOTTOM_126 VTOP
XR8E__A44_C1_MIM6_R0_120 CAP_BOTTOM_057 VTOP R8E__A44_C1_MIM6_R0
XR8E__A44_C1_MIM6_R0_110 CAP_BOTTOM_030 VTOP R8E__A44_C1_MIM6_R0
XR8E__A44_C1_MIM6_R0_121 CAP_BOTTOM_058 VTOP R8E__A44_C1_MIM6_R0
XR8E__A44_C1_MIM6_R0_100 CAP_BOTTOM_012 VTOP R8E__A44_C1_MIM6_R0
XR8E__A44_C1_MIM6_R0_111 CAP_BOTTOM_031 VTOP R8E__A44_C1_MIM6_R0
XR8E__A44_C1_MIM6_R0_122 CAP_BOTTOM_059 VTOP R8E__A44_C1_MIM6_R0
XR8E__A44_C1_MIM6_R0_101 CAP_BOTTOM_013 VTOP R8E__A44_C1_MIM6_R0
XR8E__A44_C1_MIM6_R0_123 CAP_BOTTOM_060 VTOP R8E__A44_C1_MIM6_R0
XR8E__A44_C1_MIM6_R0_112 CAP_BOTTOM_041 VTOP R8E__A44_C1_MIM6_R0
XR8E__A44_C1_MIM6_R0_102 CAP_BOTTOM_014 VTOP R8E__A44_C1_MIM6_R0
XR8E__A44_C1_MIM6_R0_124 CAP_BOTTOM_061 VTOP R8E__A44_C1_MIM6_R0
XR8E__A44_C1_MIM6_R0_113 CAP_BOTTOM_042 VTOP R8E__A44_C1_MIM6_R0
XR8E__A44_C1_MIM6_R0_103 CAP_BOTTOM_015 VTOP R8E__A44_C1_MIM6_R0
XR8E__A44_C1_MIM6_R0_125 CAP_BOTTOM_062 VTOP R8E__A44_C1_MIM6_R0
XR8E__A44_C1_MIM6_R0_114 CAP_BOTTOM_043 VTOP R8E__A44_C1_MIM6_R0
XR8E__A44_C1_MIM6_R0_0 CAP_BOTTOM_072 VTOP R8E__A44_C1_MIM6_R0
XR8E__A44_C1_MIM6_R0_104 CAP_BOTTOM_024 VTOP R8E__A44_C1_MIM6_R0
XR8E__A44_C1_MIM6_R0_126 CAP_BOTTOM_063 VTOP R8E__A44_C1_MIM6_R0
XR8E__A44_C1_MIM6_R0_115 CAP_BOTTOM_044 VTOP R8E__A44_C1_MIM6_R0
XR8E__A44_C1_MIM6_R0_1 CAP_BOTTOM_073 VTOP R8E__A44_C1_MIM6_R0
XR8E__A44_C1_MIM6_R0_105 CAP_BOTTOM_025 VTOP R8E__A44_C1_MIM6_R0
XR8E__A44_C1_MIM6_R0_127 CAP_BOTTOM_040 VTOP R8E__A44_C1_MIM6_R0
XR8E__A44_C1_MIM6_R0_116 CAP_BOTTOM_045 VTOP R8E__A44_C1_MIM6_R0
XR8E__A44_C1_MIM6_R0_2 CAP_BOTTOM_074 VTOP R8E__A44_C1_MIM6_R0
XR8E__A44_C1_MIM6_R0_106 CAP_BOTTOM_026 VTOP R8E__A44_C1_MIM6_R0
XR8E__A44_C1_MIM6_R0_117 CAP_BOTTOM_046 VTOP R8E__A44_C1_MIM6_R0
XR8E__A44_C1_MIM6_R0_3 CAP_BOTTOM_075 VTOP R8E__A44_C1_MIM6_R0
XR8E__A44_C1_MIM6_R0_107 CAP_BOTTOM_027 VTOP R8E__A44_C1_MIM6_R0
XR8E__A44_C1_MIM6_R0_118 CAP_BOTTOM_047 VTOP R8E__A44_C1_MIM6_R0
XR8E__A44_C1_MIM6_R0_4 CAP_BOTTOM_076 VTOP R8E__A44_C1_MIM6_R0
XR8E__A44_C1_MIM6_R0_108 CAP_BOTTOM_028 VTOP R8E__A44_C1_MIM6_R0
XR8E__A44_C1_MIM6_R0_119 CAP_BOTTOM_056 VTOP R8E__A44_C1_MIM6_R0
XR8E__A44_C1_MIM6_R0_5 CAP_BOTTOM_077 VTOP R8E__A44_C1_MIM6_R0
XR8E__A44_C1_MIM6_R0_109 CAP_BOTTOM_029 VTOP R8E__A44_C1_MIM6_R0
XR8E__A44_C1_MIM6_R0_6 CAP_BOTTOM_078 VTOP R8E__A44_C1_MIM6_R0
XR8E__A44_C1_MIM6_R0_7 CAP_BOTTOM_103 VTOP R8E__A44_C1_MIM6_R0
XR8E__A44_C1_MIM6_R0_8 CAP_BOTTOM_104 VTOP R8E__A44_C1_MIM6_R0
XR8E__A44_C1_MIM6_R0_9 CAP_BOTTOM_105 VTOP R8E__A44_C1_MIM6_R0
XR8E__A44_C1_MIM6_R0_90 CAP_BOTTOM_003 VTOP R8E__A44_C1_MIM6_R0
XR8E__A44_C1_MIM6_R0_91 CAP_BOTTOM_004 VTOP R8E__A44_C1_MIM6_R0
XR8E__A44_C1_MIM6_R0_80 CAP_BOTTOM_049 VTOP R8E__A44_C1_MIM6_R0
XR8E__A44_C1_MIM6_R0_92 CAP_BOTTOM_005 VTOP R8E__A44_C1_MIM6_R0
XR8E__A44_C1_MIM6_R0_81 CAP_BOTTOM_050 VTOP R8E__A44_C1_MIM6_R0
XR8E__A44_C1_MIM6_R0_70 CAP_BOTTOM_039 VTOP R8E__A44_C1_MIM6_R0
XR8E__A44_C1_MIM6_R0_93 CAP_BOTTOM_006 VTOP R8E__A44_C1_MIM6_R0
XR8E__A44_C1_MIM6_R0_71 CAP_BOTTOM_016 VTOP R8E__A44_C1_MIM6_R0
XR8E__A44_C1_MIM6_R0_60 CAP_BOTTOM_116 VTOP R8E__A44_C1_MIM6_R0
XR8E__A44_C1_MIM6_R0_82 CAP_BOTTOM_051 VTOP R8E__A44_C1_MIM6_R0
XR8E__A44_C1_MIM6_R0_94 CAP_BOTTOM_007 VTOP R8E__A44_C1_MIM6_R0
XR8E__A44_C1_MIM6_R0_72 CAP_BOTTOM_017 VTOP R8E__A44_C1_MIM6_R0
XR8E__A44_C1_MIM6_R0_50 CAP_BOTTOM_098 VTOP R8E__A44_C1_MIM6_R0
XR8E__A44_C1_MIM6_R0_61 CAP_BOTTOM_117 VTOP R8E__A44_C1_MIM6_R0
XR8E__A44_C1_MIM6_R0_83 CAP_BOTTOM_052 VTOP R8E__A44_C1_MIM6_R0
XR8E__A44_C1_MIM6_R0_73 CAP_BOTTOM_018 VTOP R8E__A44_C1_MIM6_R0
XR8E__A44_C1_MIM6_R0_51 CAP_BOTTOM_099 VTOP R8E__A44_C1_MIM6_R0
XR8E__A44_C1_MIM6_R0_62 CAP_BOTTOM_118 VTOP R8E__A44_C1_MIM6_R0
XR8E__A44_C1_MIM6_R0_40 CAP_BOTTOM_079 VTOP R8E__A44_C1_MIM6_R0
XR8E__A44_C1_MIM6_R0_95 CAP_BOTTOM_048 VTOP R8E__A44_C1_MIM6_R0
XR8E__A44_C1_MIM6_R0_84 CAP_BOTTOM_053 VTOP R8E__A44_C1_MIM6_R0
XR8E__A44_C1_MIM6_R0_96 CAP_BOTTOM_008 VTOP R8E__A44_C1_MIM6_R0
XR8E__A44_C1_MIM6_R0_74 CAP_BOTTOM_019 VTOP R8E__A44_C1_MIM6_R0
XR8E__A44_C1_MIM6_R0_63 CAP_BOTTOM_095 VTOP R8E__A44_C1_MIM6_R0
XR8E__A44_C1_MIM6_R0_52 CAP_BOTTOM_100 VTOP R8E__A44_C1_MIM6_R0
XR8E__A44_C1_MIM6_R0_30 CAP_BOTTOM_126 VTOP R8E__A44_C1_MIM6_R0
XR8E__A44_C1_MIM6_R0_41 CAP_BOTTOM_080 VTOP R8E__A44_C1_MIM6_R0
XR8E__A44_C1_MIM6_R0_85 CAP_BOTTOM_054 VTOP R8E__A44_C1_MIM6_R0
XR8E__A44_C1_MIM6_R0_97 CAP_BOTTOM_009 VTOP R8E__A44_C1_MIM6_R0
XR8E__A44_C1_MIM6_R0_75 CAP_BOTTOM_020 VTOP R8E__A44_C1_MIM6_R0
XR8E__A44_C1_MIM6_R0_53 CAP_BOTTOM_101 VTOP R8E__A44_C1_MIM6_R0
XR8E__A44_C1_MIM6_R0_42 CAP_BOTTOM_081 VTOP R8E__A44_C1_MIM6_R0
XR8E__A44_C1_MIM6_R0_31 CAP_BOTTOM_087 VTOP R8E__A44_C1_MIM6_R0
XR8E__A44_C1_MIM6_R0_20 CAP_BOTTOM_092 VTOP R8E__A44_C1_MIM6_R0
XR8E__A44_C1_MIM6_R0_86 CAP_BOTTOM_055 VTOP R8E__A44_C1_MIM6_R0
XR8E__A44_C1_MIM6_R0_64 CAP_BOTTOM_033 VTOP R8E__A44_C1_MIM6_R0
XR8E__A44_C1_MIM6_R0_98 CAP_BOTTOM_010 VTOP R8E__A44_C1_MIM6_R0
XR8E__A44_C1_MIM6_R0_87 CAP_BOTTOM_000 VTOP R8E__A44_C1_MIM6_R0
XR8E__A44_C1_MIM6_R0_76 CAP_BOTTOM_021 VTOP R8E__A44_C1_MIM6_R0
XR8E__A44_C1_MIM6_R0_54 CAP_BOTTOM_102 VTOP R8E__A44_C1_MIM6_R0
XR8E__A44_C1_MIM6_R0_10 CAP_BOTTOM_106 VTOP R8E__A44_C1_MIM6_R0
XR8E__A44_C1_MIM6_R0_43 CAP_BOTTOM_082 VTOP R8E__A44_C1_MIM6_R0
XR8E__A44_C1_MIM6_R0_21 CAP_BOTTOM_093 VTOP R8E__A44_C1_MIM6_R0
XR8E__A44_C1_MIM6_R0_32 CAP_BOTTOM_064 VTOP R8E__A44_C1_MIM6_R0
XR8E__A44_C1_MIM6_R0_65 CAP_BOTTOM_034 VTOP R8E__A44_C1_MIM6_R0
XR8E__A44_C1_MIM6_R0_99 CAP_BOTTOM_011 VTOP R8E__A44_C1_MIM6_R0
XR8E__A44_C1_MIM6_R0_88 CAP_BOTTOM_001 VTOP R8E__A44_C1_MIM6_R0
XR8E__A44_C1_MIM6_R0_77 CAP_BOTTOM_022 VTOP R8E__A44_C1_MIM6_R0
XR8E__A44_C1_MIM6_R0_55 CAP_BOTTOM_111 VTOP R8E__A44_C1_MIM6_R0
XR8E__A44_C1_MIM6_R0_11 CAP_BOTTOM_107 VTOP R8E__A44_C1_MIM6_R0
XR8E__A44_C1_MIM6_R0_44 CAP_BOTTOM_083 VTOP R8E__A44_C1_MIM6_R0
XR8E__A44_C1_MIM6_R0_22 CAP_BOTTOM_094 VTOP R8E__A44_C1_MIM6_R0
XR8E__A44_C1_MIM6_R0_33 CAP_BOTTOM_065 VTOP R8E__A44_C1_MIM6_R0
XR8E__A44_C1_MIM6_R0_66 CAP_BOTTOM_035 VTOP R8E__A44_C1_MIM6_R0
XR8E__A44_C1_MIM6_R0_89 CAP_BOTTOM_002 VTOP R8E__A44_C1_MIM6_R0
XR8E__A44_C1_MIM6_R0_78 CAP_BOTTOM_023 VTOP R8E__A44_C1_MIM6_R0
XR8E__A44_C1_MIM6_R0_56 CAP_BOTTOM_112 VTOP R8E__A44_C1_MIM6_R0
XR8E__A44_C1_MIM6_R0_23 CAP_BOTTOM_119 VTOP R8E__A44_C1_MIM6_R0
XR8E__A44_C1_MIM6_R0_12 CAP_BOTTOM_108 VTOP R8E__A44_C1_MIM6_R0
XR8E__A44_C1_MIM6_R0_45 CAP_BOTTOM_084 VTOP R8E__A44_C1_MIM6_R0
XR8E__A44_C1_MIM6_R0_34 CAP_BOTTOM_066 VTOP R8E__A44_C1_MIM6_R0
XR8E__A44_C1_MIM6_R0_67 CAP_BOTTOM_036 VTOP R8E__A44_C1_MIM6_R0
XR8E__A44_C1_MIM6_R0_57 CAP_BOTTOM_113 VTOP R8E__A44_C1_MIM6_R0
XR8E__A44_C1_MIM6_R0_24 CAP_BOTTOM_120 VTOP R8E__A44_C1_MIM6_R0
XR8E__A44_C1_MIM6_R0_13 CAP_BOTTOM_109 VTOP R8E__A44_C1_MIM6_R0
XR8E__A44_C1_MIM6_R0_46 CAP_BOTTOM_085 VTOP R8E__A44_C1_MIM6_R0
XR8E__A44_C1_MIM6_R0_35 CAP_BOTTOM_067 VTOP R8E__A44_C1_MIM6_R0
XR8E__A44_C1_MIM6_R0_79 CAP_BOTTOM_032 VTOP R8E__A44_C1_MIM6_R0
XR8E__A44_C1_MIM6_R0_68 CAP_BOTTOM_037 VTOP R8E__A44_C1_MIM6_R0
XR8E__A44_C1_MIM6_R0_58 CAP_BOTTOM_114 VTOP R8E__A44_C1_MIM6_R0
XR8E__A44_C1_MIM6_R0_25 CAP_BOTTOM_121 VTOP R8E__A44_C1_MIM6_R0
XR8E__A44_C1_MIM6_R0_14 CAP_BOTTOM_110 VTOP R8E__A44_C1_MIM6_R0
XR8E__A44_C1_MIM6_R0_47 CAP_BOTTOM_086 VTOP R8E__A44_C1_MIM6_R0
XR8E__A44_C1_MIM6_R0_36 CAP_BOTTOM_068 VTOP R8E__A44_C1_MIM6_R0
XR8E__A44_C1_MIM6_R0_69 CAP_BOTTOM_038 VTOP R8E__A44_C1_MIM6_R0
XR8E__A44_C1_MIM6_R0_48 CAP_BOTTOM_096 VTOP R8E__A44_C1_MIM6_R0
XR8E__A44_C1_MIM6_R0_59 CAP_BOTTOM_115 VTOP R8E__A44_C1_MIM6_R0
XR8E__A44_C1_MIM6_R0_26 CAP_BOTTOM_122 VTOP R8E__A44_C1_MIM6_R0
XR8E__A44_C1_MIM6_R0_37 CAP_BOTTOM_069 VTOP R8E__A44_C1_MIM6_R0
XR8E__A44_C1_MIM6_R0_15 GND VTOP R8E__A44_C1_MIM6_R0
XR8E__A44_C1_MIM6_R0_49 CAP_BOTTOM_097 VTOP R8E__A44_C1_MIM6_R0
XR8E__A44_C1_MIM6_R0_27 CAP_BOTTOM_123 VTOP R8E__A44_C1_MIM6_R0
XR8E__A44_C1_MIM6_R0_16 CAP_BOTTOM_088 VTOP R8E__A44_C1_MIM6_R0
XR8E__A44_C1_MIM6_R0_38 CAP_BOTTOM_070 VTOP R8E__A44_C1_MIM6_R0
XR8E__A44_C1_MIM6_R0_28 CAP_BOTTOM_124 VTOP R8E__A44_C1_MIM6_R0
XR8E__A44_C1_MIM6_R0_17 CAP_BOTTOM_089 VTOP R8E__A44_C1_MIM6_R0
XR8E__A44_C1_MIM6_R0_39 CAP_BOTTOM_071 VTOP R8E__A44_C1_MIM6_R0
XR8E__A44_C1_MIM6_R0_29 CAP_BOTTOM_125 VTOP R8E__A44_C1_MIM6_R0
XR8E__A44_C1_MIM6_R0_18 CAP_BOTTOM_090 VTOP R8E__A44_C1_MIM6_R0
XR8E__A44_C1_MIM6_R0_19 CAP_BOTTOM_091 VTOP R8E__A44_C1_MIM6_R0
.ends

.subckt R8E__pfet_03v3_XNC3G5 a_n148_n1230# a_n148_n2318# a_n148_946# a_n148_1490#
+ a_28_n156# a_n148_n142# a_28_n700# a_28_n2332# a_28_2020# a_n36_n1880# w_n234_n2510#
+ a_28_n1788# a_n36_n1336# a_n148_402# a_28_1476# a_n148_n1774# a_n148_2034# a_n36_1928#
+ a_n148_n686# a_n36_n792# a_28_388# a_n36_296# a_28_932# a_n36_n2424# a_n36_n248#
+ a_n36_1384# a_28_n1244# a_n36_840#
X0 a_28_2020# a_n36_1928# a_n148_2034# w_n234_n2510# pfet_03v3 ad=0.9269p pd=4.32u as=0.9269p ps=4.32u w=1.56u l=0.28u
X1 a_28_n1244# a_n36_n1336# a_n148_n1230# w_n234_n2510# pfet_03v3 ad=0.9269p pd=4.32u as=0.9269p ps=4.32u w=1.56u l=0.28u
X2 a_28_932# a_n36_840# a_n148_946# w_n234_n2510# pfet_03v3 ad=0.9269p pd=4.32u as=0.9269p ps=4.32u w=1.56u l=0.28u
X3 a_28_n700# a_n36_n792# a_n148_n686# w_n234_n2510# pfet_03v3 ad=0.9269p pd=4.32u as=0.9269p ps=4.32u w=1.56u l=0.28u
X4 a_28_1476# a_n36_1384# a_n148_1490# w_n234_n2510# pfet_03v3 ad=0.9269p pd=4.32u as=0.9269p ps=4.32u w=1.56u l=0.28u
X5 a_28_n2332# a_n36_n2424# a_n148_n2318# w_n234_n2510# pfet_03v3 ad=0.9269p pd=4.32u as=0.9269p ps=4.32u w=1.56u l=0.28u
X6 a_28_388# a_n36_296# a_n148_402# w_n234_n2510# pfet_03v3 ad=0.9269p pd=4.32u as=0.9269p ps=4.32u w=1.56u l=0.28u
X7 a_28_n1788# a_n36_n1880# a_n148_n1774# w_n234_n2510# pfet_03v3 ad=0.9269p pd=4.32u as=0.9269p ps=4.32u w=1.56u l=0.28u
X8 a_28_n156# a_n36_n248# a_n148_n142# w_n234_n2510# pfet_03v3 ad=0.9269p pd=4.32u as=0.9269p ps=4.32u w=1.56u l=0.28u
.ends

.subckt R8E__A44_G6_PFET_M9_GUARD0_R0 M9_R0/a_n36_n792# M9_R0/a_28_932# M9_R0/a_n148_1490#
+ M9_R0/a_28_n700# M9_R0/a_n148_n1774# M9_R0/a_28_2020# M9_R0/a_n148_n142# M9_R0/a_n36_n248#
+ M9_R0/a_n36_1384# M9_R0/a_28_n1244# M9_R0/a_28_1476# M9_R0/a_n36_n1880# M9_R0/a_n148_946#
+ M9_R0/a_n148_n1230# M9_R0/a_n36_n1336# M9_R0/a_28_n2332# M9_R0/a_n148_2034# M9_R0/a_n148_n2318#
+ M9_R0/a_n36_296# M9_R0/a_n148_n686# M9_R0/a_n36_840# M9_R0/a_28_n1788# M9_R0/a_n148_402#
+ M9_R0/a_n36_n2424# M9_R0/w_n234_n2510# M9_R0/a_n36_1928# M9_R0/a_28_388# M9_R0/a_28_n156#
XM9_R0 M9_R0/a_n148_n1230# M9_R0/a_n148_n2318# M9_R0/a_n148_946# M9_R0/a_n148_1490#
+ M9_R0/a_28_n156# M9_R0/a_n148_n142# M9_R0/a_28_n700# M9_R0/a_28_n2332# M9_R0/a_28_2020#
+ M9_R0/a_n36_n1880# M9_R0/w_n234_n2510# M9_R0/a_28_n1788# M9_R0/a_n36_n1336# M9_R0/a_n148_402#
+ M9_R0/a_28_1476# M9_R0/a_n148_n1774# M9_R0/a_n148_2034# M9_R0/a_n36_1928# M9_R0/a_n148_n686#
+ M9_R0/a_n36_n792# M9_R0/a_28_388# M9_R0/a_n36_296# M9_R0/a_28_932# M9_R0/a_n36_n2424#
+ M9_R0/a_n36_n248# M9_R0/a_n36_1384# M9_R0/a_28_n1244# M9_R0/a_n36_840# R8E__pfet_03v3_XNC3G5
.ends

.subckt R8E__nfet_03v3_ATEY9D a_28_812# a_28_1308# a_n36_2136# a_28_1804# a_n148_826#
+ a_n148_n166# a_n36_1144# a_n36_n344# a_n148_330# a_n36_n1336# a_28_n676# a_n148_n662#
+ a_n36_1640# a_n148_1818# a_28_n2164# a_n148_n1158# a_n36_n840# a_28_n180# a_n148_n2150#
+ a_n36_n1832# a_n148_1322# a_28_n1668# a_n148_n1654# a_28_n1172# a_n36_648# a_n36_152#
+ a_28_316# VSUBS
X0 a_28_316# a_n36_648# a_n148_330# VSUBS nfet_03v3 ad=0.9269p pd=4.32u as=0.9269p ps=4.32u w=1.56u l=0.28u
X1 a_28_812# a_n36_1144# a_n148_826# VSUBS nfet_03v3 ad=0.9269p pd=4.32u as=0.9269p ps=4.32u w=1.56u l=0.28u
X2 a_28_n180# a_n36_152# a_n148_n166# VSUBS nfet_03v3 ad=0.9269p pd=4.32u as=0.9269p ps=4.32u w=1.56u l=0.28u
X3 a_28_1308# a_n36_1640# a_n148_1322# VSUBS nfet_03v3 ad=0.9269p pd=4.32u as=0.9269p ps=4.32u w=1.56u l=0.28u
X4 a_28_n676# a_n36_n344# a_n148_n662# VSUBS nfet_03v3 ad=0.9269p pd=4.32u as=0.9269p ps=4.32u w=1.56u l=0.28u
X5 a_28_n1668# a_n36_n1336# a_n148_n1654# VSUBS nfet_03v3 ad=0.9269p pd=4.32u as=0.9269p ps=4.32u w=1.56u l=0.28u
X6 a_28_1804# a_n36_2136# a_n148_1818# VSUBS nfet_03v3 ad=0.9269p pd=4.32u as=0.9269p ps=4.32u w=1.56u l=0.28u
X7 a_28_n2164# a_n36_n1832# a_n148_n2150# VSUBS nfet_03v3 ad=0.9269p pd=4.32u as=0.9269p ps=4.32u w=1.56u l=0.28u
X8 a_28_n1172# a_n36_n840# a_n148_n1158# VSUBS nfet_03v3 ad=0.9269p pd=4.32u as=0.9269p ps=4.32u w=1.56u l=0.28u
.ends

.subckt R8E__A44_G6_NFET_M9_GUARD0_R0 M9_R0/a_28_n1668# M9_R0/a_28_316# M9_R0/a_28_n1172#
+ M9_R0/a_28_1804# M9_R0/a_n148_n1158# M9_R0/a_n148_n2150# M9_R0/a_28_812# M9_R0/a_n148_n166#
+ M9_R0/a_n148_n1654# M9_R0/a_28_n676# M9_R0/a_28_n180# M9_R0/a_n36_n1336# M9_R0/a_n36_2136#
+ M9_R0/a_n148_n662# M9_R0/a_n148_1818# M9_R0/a_n148_826# M9_R0/a_n148_1322# M9_R0/a_n36_1144#
+ M9_R0/a_n36_648# M9_R0/a_n148_330# M9_R0/a_n36_n1832# M9_R0/a_n36_152# M9_R0/a_n36_n344#
+ M9_R0/a_n36_1640# M9_R0/a_28_n2164# M9_R0/a_28_1308# M9_R0/a_n36_n840# VSUBS
XM9_R0 M9_R0/a_28_812# M9_R0/a_28_1308# M9_R0/a_n36_2136# M9_R0/a_28_1804# M9_R0/a_n148_826#
+ M9_R0/a_n148_n166# M9_R0/a_n36_1144# M9_R0/a_n36_n344# M9_R0/a_n148_330# M9_R0/a_n36_n1336#
+ M9_R0/a_28_n676# M9_R0/a_n148_n662# M9_R0/a_n36_1640# M9_R0/a_n148_1818# M9_R0/a_28_n2164#
+ M9_R0/a_n148_n1158# M9_R0/a_n36_n840# M9_R0/a_28_n180# M9_R0/a_n148_n2150# M9_R0/a_n36_n1832#
+ M9_R0/a_n148_1322# M9_R0/a_28_n1668# M9_R0/a_n148_n1654# M9_R0/a_28_n1172# M9_R0/a_n36_648#
+ M9_R0/a_n36_152# M9_R0/a_28_316# VSUBS R8E__nfet_03v3_ATEY9D
.ends

.subckt R8E__A44_CAP_SWITCH_BANK_CORE_O2 VREFP VREFN CTRL CAP_BOTTOM VDD GND
XP0 CTRL VREFP CAP_BOTTOM VREFP CAP_BOTTOM VREFP CAP_BOTTOM CTRL CTRL VREFP VREFP
+ CTRL CAP_BOTTOM CAP_BOTTOM CTRL VREFP CAP_BOTTOM CAP_BOTTOM CTRL CAP_BOTTOM CTRL
+ VREFP CAP_BOTTOM CTRL VDD CTRL VREFP VREFP R8E__A44_G6_PFET_M9_GUARD0_R0
XP1 CTRL VREFP CAP_BOTTOM VREFP CAP_BOTTOM VREFP CAP_BOTTOM CTRL CTRL VREFP VREFP
+ CTRL CAP_BOTTOM CAP_BOTTOM CTRL VREFP CAP_BOTTOM CAP_BOTTOM CTRL CAP_BOTTOM CTRL
+ VREFP CAP_BOTTOM CTRL VDD CTRL VREFP VREFP R8E__A44_G6_PFET_M9_GUARD0_R0
XN0 VREFN VREFN VREFN VREFN CAP_BOTTOM CAP_BOTTOM VREFN CAP_BOTTOM CAP_BOTTOM VREFN
+ VREFN CTRL CTRL CAP_BOTTOM CAP_BOTTOM CAP_BOTTOM CAP_BOTTOM CTRL CTRL CAP_BOTTOM
+ CTRL CTRL CTRL CTRL VREFN VREFN CTRL GND R8E__A44_G6_NFET_M9_GUARD0_R0
XN1 VREFN VREFN VREFN VREFN CAP_BOTTOM CAP_BOTTOM VREFN CAP_BOTTOM CAP_BOTTOM VREFN
+ VREFN CTRL CTRL CAP_BOTTOM CAP_BOTTOM CAP_BOTTOM CAP_BOTTOM CTRL CTRL CAP_BOTTOM
+ CTRL CTRL CTRL CTRL VREFN VREFN CTRL GND R8E__A44_G6_NFET_M9_GUARD0_R0
.ends

.subckt R8E__A44_SW_BANK64_NORTH_R8_M6 CTRL_008 CTRL_024 CTRL_040 CTRL_056 CTRL_009
+ CTRL_025 CTRL_041 CTRL_057 CTRL_010 CTRL_026 CTRL_042 CTRL_058 CTRL_011 CTRL_027
+ CTRL_043 CTRL_059 CTRL_012 CTRL_028 CTRL_044 CTRL_060 CTRL_013 CTRL_029 CTRL_045
+ CTRL_061 CTRL_014 CTRL_030 CTRL_046 CTRL_062 CTRL_015 CTRL_031 CTRL_047 CTRL_063
+ CTRL_000 CTRL_016 CTRL_032 CTRL_048 CTRL_001 CTRL_017 CTRL_033 CTRL_049 CTRL_002
+ CTRL_018 CTRL_034 CTRL_050 CTRL_003 CTRL_019 CTRL_035 CTRL_051 CTRL_004 CTRL_020
+ CTRL_036 CTRL_052 CTRL_005 CTRL_021 CTRL_037 CTRL_053 CTRL_006 CTRL_022 CTRL_038
+ CTRL_054 CTRL_007 CTRL_023 CTRL_039 CTRL_055 CAP_BOTTOM_004 CAP_BOTTOM_002 CAP_BOTTOM_020
+ CAP_BOTTOM_001 CAP_BOTTOM_036 CAP_BOTTOM_018 CAP_BOTTOM_052 CAP_BOTTOM_032 CAP_BOTTOM_005
+ CAP_BOTTOM_034 CAP_BOTTOM_021 CAP_BOTTOM_017 CAP_BOTTOM_037 CAP_BOTTOM_050 CAP_BOTTOM_053
+ CAP_BOTTOM_016 CAP_BOTTOM_006 CAP_BOTTOM_003 CAP_BOTTOM_022 CAP_BOTTOM_033 CAP_BOTTOM_038
+ CAP_BOTTOM_019 CAP_BOTTOM_054 CAP_BOTTOM_048 CAP_BOTTOM_007 CAP_BOTTOM_035 CAP_BOTTOM_023
+ CAP_BOTTOM_049 CAP_BOTTOM_039 CAP_BOTTOM_051 CAP_BOTTOM_000 CAP_BOTTOM_012 CAP_BOTTOM_010
+ CAP_BOTTOM_028 CAP_BOTTOM_009 CAP_BOTTOM_044 CAP_BOTTOM_026 CAP_BOTTOM_060 CAP_BOTTOM_040
+ CAP_BOTTOM_013 CAP_BOTTOM_042 CAP_BOTTOM_029 CAP_BOTTOM_025 CAP_BOTTOM_045 CAP_BOTTOM_058
+ CAP_BOTTOM_061 CAP_BOTTOM_024 CAP_BOTTOM_014 CAP_BOTTOM_011 CAP_BOTTOM_030 CAP_BOTTOM_041
+ CAP_BOTTOM_046 CAP_BOTTOM_027 CAP_BOTTOM_062 CAP_BOTTOM_056 CAP_BOTTOM_015 CAP_BOTTOM_043
+ CAP_BOTTOM_031 CAP_BOTTOM_057 CAP_BOTTOM_047 CAP_BOTTOM_059 CAP_BOTTOM_063 CAP_BOTTOM_008
+ VREFN VREFP VDD CAP_BOTTOM_055 GND
XR8E__A44_CAP_SWITCH_BANK_CORE_O2_60 VREFP VREFN CTRL_056 CAP_BOTTOM_056 VDD GND R8E__A44_CAP_SWITCH_BANK_CORE_O2
XR8E__A44_CAP_SWITCH_BANK_CORE_O2_61 VREFP VREFN CTRL_040 CAP_BOTTOM_040 VDD GND R8E__A44_CAP_SWITCH_BANK_CORE_O2
XR8E__A44_CAP_SWITCH_BANK_CORE_O2_50 VREFP VREFN CTRL_027 CAP_BOTTOM_027 VDD GND R8E__A44_CAP_SWITCH_BANK_CORE_O2
XR8E__A44_CAP_SWITCH_BANK_CORE_O2_51 VREFP VREFN CTRL_011 CAP_BOTTOM_011 VDD GND R8E__A44_CAP_SWITCH_BANK_CORE_O2
XR8E__A44_CAP_SWITCH_BANK_CORE_O2_40 VREFP VREFN CTRL_061 CAP_BOTTOM_061 VDD GND R8E__A44_CAP_SWITCH_BANK_CORE_O2
XR8E__A44_CAP_SWITCH_BANK_CORE_O2_62 VREFP VREFN CTRL_024 CAP_BOTTOM_024 VDD GND R8E__A44_CAP_SWITCH_BANK_CORE_O2
XR8E__A44_CAP_SWITCH_BANK_CORE_O2_41 VREFP VREFN CTRL_045 CAP_BOTTOM_045 VDD GND R8E__A44_CAP_SWITCH_BANK_CORE_O2
XR8E__A44_CAP_SWITCH_BANK_CORE_O2_63 VREFP VREFN CTRL_012 CAP_BOTTOM_012 VDD GND R8E__A44_CAP_SWITCH_BANK_CORE_O2
XR8E__A44_CAP_SWITCH_BANK_CORE_O2_53 VREFP VREFN CTRL_042 CAP_BOTTOM_042 VDD GND R8E__A44_CAP_SWITCH_BANK_CORE_O2
XR8E__A44_CAP_SWITCH_BANK_CORE_O2_31 VREFP VREFN CTRL_004 CAP_BOTTOM_004 VDD GND R8E__A44_CAP_SWITCH_BANK_CORE_O2
XR8E__A44_CAP_SWITCH_BANK_CORE_O2_42 VREFP VREFN CTRL_029 CAP_BOTTOM_029 VDD GND R8E__A44_CAP_SWITCH_BANK_CORE_O2
XR8E__A44_CAP_SWITCH_BANK_CORE_O2_52 VREFP VREFN CTRL_058 CAP_BOTTOM_058 VDD GND R8E__A44_CAP_SWITCH_BANK_CORE_O2
XR8E__A44_CAP_SWITCH_BANK_CORE_O2_20 VREFP VREFN CTRL_050 CAP_BOTTOM_050 VDD GND R8E__A44_CAP_SWITCH_BANK_CORE_O2
XR8E__A44_CAP_SWITCH_BANK_CORE_O2_30 VREFP VREFN CTRL_016 CAP_BOTTOM_016 VDD GND R8E__A44_CAP_SWITCH_BANK_CORE_O2
XR8E__A44_CAP_SWITCH_BANK_CORE_O2_43 VREFP VREFN CTRL_013 CAP_BOTTOM_013 VDD GND R8E__A44_CAP_SWITCH_BANK_CORE_O2
XR8E__A44_CAP_SWITCH_BANK_CORE_O2_21 VREFP VREFN CTRL_034 CAP_BOTTOM_034 VDD GND R8E__A44_CAP_SWITCH_BANK_CORE_O2
XR8E__A44_CAP_SWITCH_BANK_CORE_O2_32 VREFP VREFN CTRL_063 CAP_BOTTOM_063 VDD GND R8E__A44_CAP_SWITCH_BANK_CORE_O2
XR8E__A44_CAP_SWITCH_BANK_CORE_O2_54 VREFP VREFN CTRL_026 CAP_BOTTOM_026 VDD GND R8E__A44_CAP_SWITCH_BANK_CORE_O2
XR8E__A44_CAP_SWITCH_BANK_CORE_O2_10 VREFP VREFN CTRL_021 CAP_BOTTOM_021 VDD GND R8E__A44_CAP_SWITCH_BANK_CORE_O2
XR8E__A44_CAP_SWITCH_BANK_CORE_O2_33 VREFP VREFN CTRL_047 CAP_BOTTOM_047 VDD GND R8E__A44_CAP_SWITCH_BANK_CORE_O2
XR8E__A44_CAP_SWITCH_BANK_CORE_O2_55 VREFP VREFN CTRL_010 CAP_BOTTOM_010 VDD GND R8E__A44_CAP_SWITCH_BANK_CORE_O2
XR8E__A44_CAP_SWITCH_BANK_CORE_O2_11 VREFP VREFN CTRL_005 CAP_BOTTOM_005 VDD GND R8E__A44_CAP_SWITCH_BANK_CORE_O2
XR8E__A44_CAP_SWITCH_BANK_CORE_O2_44 VREFP VREFN CTRL_060 CAP_BOTTOM_060 VDD GND R8E__A44_CAP_SWITCH_BANK_CORE_O2
XR8E__A44_CAP_SWITCH_BANK_CORE_O2_22 VREFP VREFN CTRL_018 CAP_BOTTOM_018 VDD GND R8E__A44_CAP_SWITCH_BANK_CORE_O2
XR8E__A44_CAP_SWITCH_BANK_CORE_O2_45 VREFP VREFN CTRL_044 CAP_BOTTOM_044 VDD GND R8E__A44_CAP_SWITCH_BANK_CORE_O2
XR8E__A44_CAP_SWITCH_BANK_CORE_O2_23 VREFP VREFN CTRL_002 CAP_BOTTOM_002 VDD GND R8E__A44_CAP_SWITCH_BANK_CORE_O2
XR8E__A44_CAP_SWITCH_BANK_CORE_O2_34 VREFP VREFN CTRL_031 CAP_BOTTOM_031 VDD GND R8E__A44_CAP_SWITCH_BANK_CORE_O2
XR8E__A44_CAP_SWITCH_BANK_CORE_O2_56 VREFP VREFN CTRL_057 CAP_BOTTOM_057 VDD GND R8E__A44_CAP_SWITCH_BANK_CORE_O2
XR8E__A44_CAP_SWITCH_BANK_CORE_O2_12 VREFP VREFN CTRL_052 CAP_BOTTOM_052 VDD GND R8E__A44_CAP_SWITCH_BANK_CORE_O2
XR8E__A44_CAP_SWITCH_BANK_CORE_O2_35 VREFP VREFN CTRL_015 CAP_BOTTOM_015 VDD GND R8E__A44_CAP_SWITCH_BANK_CORE_O2
XR8E__A44_CAP_SWITCH_BANK_CORE_O2_57 VREFP VREFN CTRL_041 CAP_BOTTOM_041 VDD GND R8E__A44_CAP_SWITCH_BANK_CORE_O2
XR8E__A44_CAP_SWITCH_BANK_CORE_O2_13 VREFP VREFN CTRL_036 CAP_BOTTOM_036 VDD GND R8E__A44_CAP_SWITCH_BANK_CORE_O2
XR8E__A44_CAP_SWITCH_BANK_CORE_O2_46 VREFP VREFN CTRL_028 CAP_BOTTOM_028 VDD GND R8E__A44_CAP_SWITCH_BANK_CORE_O2
XR8E__A44_CAP_SWITCH_BANK_CORE_O2_24 VREFP VREFN CTRL_049 CAP_BOTTOM_049 VDD GND R8E__A44_CAP_SWITCH_BANK_CORE_O2
XR8E__A44_CAP_SWITCH_BANK_CORE_O2_47 VREFP VREFN CTRL_008 CAP_BOTTOM_008 VDD GND R8E__A44_CAP_SWITCH_BANK_CORE_O2
XR8E__A44_CAP_SWITCH_BANK_CORE_O2_25 VREFP VREFN CTRL_033 CAP_BOTTOM_033 VDD GND R8E__A44_CAP_SWITCH_BANK_CORE_O2
XR8E__A44_CAP_SWITCH_BANK_CORE_O2_36 VREFP VREFN CTRL_062 CAP_BOTTOM_062 VDD GND R8E__A44_CAP_SWITCH_BANK_CORE_O2
XR8E__A44_CAP_SWITCH_BANK_CORE_O2_58 VREFP VREFN CTRL_025 CAP_BOTTOM_025 VDD GND R8E__A44_CAP_SWITCH_BANK_CORE_O2
XR8E__A44_CAP_SWITCH_BANK_CORE_O2_14 VREFP VREFN CTRL_020 CAP_BOTTOM_020 VDD GND R8E__A44_CAP_SWITCH_BANK_CORE_O2
XR8E__A44_CAP_SWITCH_BANK_CORE_O2_37 VREFP VREFN CTRL_046 CAP_BOTTOM_046 VDD GND R8E__A44_CAP_SWITCH_BANK_CORE_O2
XR8E__A44_CAP_SWITCH_BANK_CORE_O2_59 VREFP VREFN CTRL_009 CAP_BOTTOM_009 VDD GND R8E__A44_CAP_SWITCH_BANK_CORE_O2
XR8E__A44_CAP_SWITCH_BANK_CORE_O2_15 VREFP VREFN CTRL_000 CAP_BOTTOM_000 VDD GND R8E__A44_CAP_SWITCH_BANK_CORE_O2
XR8E__A44_CAP_SWITCH_BANK_CORE_O2_48 VREFP VREFN CTRL_059 CAP_BOTTOM_059 VDD GND R8E__A44_CAP_SWITCH_BANK_CORE_O2
XR8E__A44_CAP_SWITCH_BANK_CORE_O2_26 VREFP VREFN CTRL_017 CAP_BOTTOM_017 VDD GND R8E__A44_CAP_SWITCH_BANK_CORE_O2
XR8E__A44_CAP_SWITCH_BANK_CORE_O2_39 VREFP VREFN CTRL_014 CAP_BOTTOM_014 VDD GND R8E__A44_CAP_SWITCH_BANK_CORE_O2
XR8E__A44_CAP_SWITCH_BANK_CORE_O2_49 VREFP VREFN CTRL_043 CAP_BOTTOM_043 VDD GND R8E__A44_CAP_SWITCH_BANK_CORE_O2
XR8E__A44_CAP_SWITCH_BANK_CORE_O2_17 VREFP VREFN CTRL_035 CAP_BOTTOM_035 VDD GND R8E__A44_CAP_SWITCH_BANK_CORE_O2
XR8E__A44_CAP_SWITCH_BANK_CORE_O2_27 VREFP VREFN CTRL_001 CAP_BOTTOM_001 VDD GND R8E__A44_CAP_SWITCH_BANK_CORE_O2
XR8E__A44_CAP_SWITCH_BANK_CORE_O2_38 VREFP VREFN CTRL_030 CAP_BOTTOM_030 VDD GND R8E__A44_CAP_SWITCH_BANK_CORE_O2
XR8E__A44_CAP_SWITCH_BANK_CORE_O2_0 VREFP VREFN CTRL_055 CAP_BOTTOM_055 VDD GND R8E__A44_CAP_SWITCH_BANK_CORE_O2
XR8E__A44_CAP_SWITCH_BANK_CORE_O2_16 VREFP VREFN CTRL_051 CAP_BOTTOM_051 VDD GND R8E__A44_CAP_SWITCH_BANK_CORE_O2
XR8E__A44_CAP_SWITCH_BANK_CORE_O2_28 VREFP VREFN CTRL_048 CAP_BOTTOM_048 VDD GND R8E__A44_CAP_SWITCH_BANK_CORE_O2
XR8E__A44_CAP_SWITCH_BANK_CORE_O2_1 VREFP VREFN CTRL_039 CAP_BOTTOM_039 VDD GND R8E__A44_CAP_SWITCH_BANK_CORE_O2
XR8E__A44_CAP_SWITCH_BANK_CORE_O2_29 VREFP VREFN CTRL_032 CAP_BOTTOM_032 VDD GND R8E__A44_CAP_SWITCH_BANK_CORE_O2
XR8E__A44_CAP_SWITCH_BANK_CORE_O2_18 VREFP VREFN CTRL_019 CAP_BOTTOM_019 VDD GND R8E__A44_CAP_SWITCH_BANK_CORE_O2
XR8E__A44_CAP_SWITCH_BANK_CORE_O2_19 VREFP VREFN CTRL_003 CAP_BOTTOM_003 VDD GND R8E__A44_CAP_SWITCH_BANK_CORE_O2
XR8E__A44_CAP_SWITCH_BANK_CORE_O2_2 VREFP VREFN CTRL_023 CAP_BOTTOM_023 VDD GND R8E__A44_CAP_SWITCH_BANK_CORE_O2
XR8E__A44_CAP_SWITCH_BANK_CORE_O2_3 VREFP VREFN CTRL_007 CAP_BOTTOM_007 VDD GND R8E__A44_CAP_SWITCH_BANK_CORE_O2
XR8E__A44_CAP_SWITCH_BANK_CORE_O2_4 VREFP VREFN CTRL_054 CAP_BOTTOM_054 VDD GND R8E__A44_CAP_SWITCH_BANK_CORE_O2
XR8E__A44_CAP_SWITCH_BANK_CORE_O2_5 VREFP VREFN CTRL_038 CAP_BOTTOM_038 VDD GND R8E__A44_CAP_SWITCH_BANK_CORE_O2
XR8E__A44_CAP_SWITCH_BANK_CORE_O2_6 VREFP VREFN CTRL_022 CAP_BOTTOM_022 VDD GND R8E__A44_CAP_SWITCH_BANK_CORE_O2
XR8E__A44_CAP_SWITCH_BANK_CORE_O2_7 VREFP VREFN CTRL_006 CAP_BOTTOM_006 VDD GND R8E__A44_CAP_SWITCH_BANK_CORE_O2
XR8E__A44_CAP_SWITCH_BANK_CORE_O2_8 VREFP VREFN CTRL_053 CAP_BOTTOM_053 VDD GND R8E__A44_CAP_SWITCH_BANK_CORE_O2
XR8E__A44_CAP_SWITCH_BANK_CORE_O2_9 VREFP VREFN CTRL_037 CAP_BOTTOM_037 VDD GND R8E__A44_CAP_SWITCH_BANK_CORE_O2
.ends

.subckt R8E__A44_SW_BANK64_SOUTH_R8_M6 CAP_BOTTOM_087 CAP_BOTTOM_103 CAP_BOTTOM_119
+ CAP_BOTTOM_072 CAP_BOTTOM_088 CAP_BOTTOM_104 CAP_BOTTOM_120 CAP_BOTTOM_073 CAP_BOTTOM_089
+ CAP_BOTTOM_105 CAP_BOTTOM_121 CAP_BOTTOM_074 CAP_BOTTOM_090 CAP_BOTTOM_106 CAP_BOTTOM_122
+ CAP_BOTTOM_075 CAP_BOTTOM_091 CAP_BOTTOM_107 CAP_BOTTOM_123 CAP_BOTTOM_076 CAP_BOTTOM_092
+ CAP_BOTTOM_108 CAP_BOTTOM_124 CAP_BOTTOM_077 CAP_BOTTOM_093 CAP_BOTTOM_109 CAP_BOTTOM_125
+ CAP_BOTTOM_078 CAP_BOTTOM_094 CAP_BOTTOM_110 CAP_BOTTOM_126 CAP_BOTTOM_064 CAP_BOTTOM_079
+ CAP_BOTTOM_095 CAP_BOTTOM_111 CAP_BOTTOM_065 CAP_BOTTOM_080 CAP_BOTTOM_096 CAP_BOTTOM_112
+ CAP_BOTTOM_066 CAP_BOTTOM_081 CAP_BOTTOM_097 CAP_BOTTOM_113 CAP_BOTTOM_067 CAP_BOTTOM_082
+ CAP_BOTTOM_098 CAP_BOTTOM_114 CAP_BOTTOM_068 CAP_BOTTOM_083 CAP_BOTTOM_099 CAP_BOTTOM_115
+ CAP_BOTTOM_069 CAP_BOTTOM_084 CAP_BOTTOM_100 CAP_BOTTOM_116 CAP_BOTTOM_070 CAP_BOTTOM_085
+ CAP_BOTTOM_101 CAP_BOTTOM_117 CAP_BOTTOM_071 CAP_BOTTOM_086 CAP_BOTTOM_102 CAP_BOTTOM_118
+ CTRL_064 CTRL_068 CTRL_066 CTRL_083 CTRL_065 CTRL_099 CTRL_081 CTRL_115 CTRL_095
+ CTRL_069 CTRL_097 CTRL_084 CTRL_080 CTRL_100 CTRL_113 CTRL_116 CTRL_079 CTRL_070
+ CTRL_067 CTRL_085 CTRL_096 CTRL_101 CTRL_082 CTRL_117 CTRL_111 CTRL_071 CTRL_098
+ CTRL_086 CTRL_112 CTRL_102 CTRL_114 CTRL_118 CTRL_075 CTRL_087 CTRL_091 CTRL_089
+ CTRL_107 CTRL_088 CTRL_123 CTRL_105 CTRL_076 CTRL_119 CTRL_092 CTRL_121 CTRL_108
+ CTRL_104 CTRL_124 CTRL_074 CTRL_077 CTRL_103 CTRL_093 CTRL_090 CTRL_109 CTRL_120
+ CTRL_125 CTRL_106 CTRL_078 CTRL_072 CTRL_094 CTRL_122 CTRL_110 CTRL_073 CTRL_126
+ VREFN VREFP VDD GND
XR8E__A44_CAP_SWITCH_BANK_CORE_O2_60 VREFP VREFN CTRL_103 CAP_BOTTOM_103 VDD GND R8E__A44_CAP_SWITCH_BANK_CORE_O2
XR8E__A44_CAP_SWITCH_BANK_CORE_O2_61 VREFP VREFN CTRL_087 CAP_BOTTOM_087 VDD GND R8E__A44_CAP_SWITCH_BANK_CORE_O2
XR8E__A44_CAP_SWITCH_BANK_CORE_O2_50 VREFP VREFN CTRL_074 CAP_BOTTOM_074 VDD GND R8E__A44_CAP_SWITCH_BANK_CORE_O2
XR8E__A44_CAP_SWITCH_BANK_CORE_O2_51 VREFP VREFN CTRL_121 CAP_BOTTOM_121 VDD GND R8E__A44_CAP_SWITCH_BANK_CORE_O2
XR8E__A44_CAP_SWITCH_BANK_CORE_O2_40 VREFP VREFN CTRL_108 CAP_BOTTOM_108 VDD GND R8E__A44_CAP_SWITCH_BANK_CORE_O2
XR8E__A44_CAP_SWITCH_BANK_CORE_O2_62 VREFP VREFN CTRL_075 CAP_BOTTOM_075 VDD GND R8E__A44_CAP_SWITCH_BANK_CORE_O2
XR8E__A44_CAP_SWITCH_BANK_CORE_O2_31 VREFP VREFN CTRL_126 CAP_BOTTOM_126 VDD GND R8E__A44_CAP_SWITCH_BANK_CORE_O2
XR8E__A44_CAP_SWITCH_BANK_CORE_O2_41 VREFP VREFN CTRL_092 CAP_BOTTOM_092 VDD GND R8E__A44_CAP_SWITCH_BANK_CORE_O2
XR8E__A44_CAP_SWITCH_BANK_CORE_O2_53 VREFP VREFN CTRL_089 CAP_BOTTOM_089 VDD GND R8E__A44_CAP_SWITCH_BANK_CORE_O2
XR8E__A44_CAP_SWITCH_BANK_CORE_O2_42 VREFP VREFN CTRL_076 CAP_BOTTOM_076 VDD GND R8E__A44_CAP_SWITCH_BANK_CORE_O2
XR8E__A44_CAP_SWITCH_BANK_CORE_O2_52 VREFP VREFN CTRL_105 CAP_BOTTOM_105 VDD GND R8E__A44_CAP_SWITCH_BANK_CORE_O2
XR8E__A44_CAP_SWITCH_BANK_CORE_O2_30 VREFP VREFN CTRL_068 CAP_BOTTOM_068 VDD GND R8E__A44_CAP_SWITCH_BANK_CORE_O2
XR8E__A44_CAP_SWITCH_BANK_CORE_O2_20 VREFP VREFN CTRL_097 CAP_BOTTOM_097 VDD GND R8E__A44_CAP_SWITCH_BANK_CORE_O2
XR8E__A44_CAP_SWITCH_BANK_CORE_O2_43 VREFP VREFN CTRL_123 CAP_BOTTOM_123 VDD GND R8E__A44_CAP_SWITCH_BANK_CORE_O2
XR8E__A44_CAP_SWITCH_BANK_CORE_O2_21 VREFP VREFN CTRL_081 CAP_BOTTOM_081 VDD GND R8E__A44_CAP_SWITCH_BANK_CORE_O2
XR8E__A44_CAP_SWITCH_BANK_CORE_O2_32 VREFP VREFN CTRL_110 CAP_BOTTOM_110 VDD GND R8E__A44_CAP_SWITCH_BANK_CORE_O2
XR8E__A44_CAP_SWITCH_BANK_CORE_O2_54 VREFP VREFN CTRL_073 CAP_BOTTOM_073 VDD GND R8E__A44_CAP_SWITCH_BANK_CORE_O2
XR8E__A44_CAP_SWITCH_BANK_CORE_O2_10 VREFP VREFN CTRL_069 CAP_BOTTOM_069 VDD GND R8E__A44_CAP_SWITCH_BANK_CORE_O2
XR8E__A44_CAP_SWITCH_BANK_CORE_O2_33 VREFP VREFN CTRL_094 CAP_BOTTOM_094 VDD GND R8E__A44_CAP_SWITCH_BANK_CORE_O2
XR8E__A44_CAP_SWITCH_BANK_CORE_O2_55 VREFP VREFN CTRL_120 CAP_BOTTOM_120 VDD GND R8E__A44_CAP_SWITCH_BANK_CORE_O2
XR8E__A44_CAP_SWITCH_BANK_CORE_O2_11 VREFP VREFN CTRL_115 CAP_BOTTOM_115 VDD GND R8E__A44_CAP_SWITCH_BANK_CORE_O2
XR8E__A44_CAP_SWITCH_BANK_CORE_O2_44 VREFP VREFN CTRL_107 CAP_BOTTOM_107 VDD GND R8E__A44_CAP_SWITCH_BANK_CORE_O2
XR8E__A44_CAP_SWITCH_BANK_CORE_O2_22 VREFP VREFN CTRL_066 CAP_BOTTOM_066 VDD GND R8E__A44_CAP_SWITCH_BANK_CORE_O2
XR8E__A44_CAP_SWITCH_BANK_CORE_O2_45 VREFP VREFN CTRL_091 CAP_BOTTOM_091 VDD GND R8E__A44_CAP_SWITCH_BANK_CORE_O2
XR8E__A44_CAP_SWITCH_BANK_CORE_O2_23 VREFP VREFN CTRL_112 CAP_BOTTOM_112 VDD GND R8E__A44_CAP_SWITCH_BANK_CORE_O2
XR8E__A44_CAP_SWITCH_BANK_CORE_O2_34 VREFP VREFN CTRL_078 CAP_BOTTOM_078 VDD GND R8E__A44_CAP_SWITCH_BANK_CORE_O2
XR8E__A44_CAP_SWITCH_BANK_CORE_O2_56 VREFP VREFN CTRL_104 CAP_BOTTOM_104 VDD GND R8E__A44_CAP_SWITCH_BANK_CORE_O2
XR8E__A44_CAP_SWITCH_BANK_CORE_O2_12 VREFP VREFN CTRL_099 CAP_BOTTOM_099 VDD GND R8E__A44_CAP_SWITCH_BANK_CORE_O2
XR8E__A44_CAP_SWITCH_BANK_CORE_O2_35 VREFP VREFN CTRL_125 CAP_BOTTOM_125 VDD GND R8E__A44_CAP_SWITCH_BANK_CORE_O2
XR8E__A44_CAP_SWITCH_BANK_CORE_O2_57 VREFP VREFN CTRL_088 CAP_BOTTOM_088 VDD GND R8E__A44_CAP_SWITCH_BANK_CORE_O2
XR8E__A44_CAP_SWITCH_BANK_CORE_O2_46 VREFP VREFN CTRL_118 CAP_BOTTOM_118 VDD GND R8E__A44_CAP_SWITCH_BANK_CORE_O2
XR8E__A44_CAP_SWITCH_BANK_CORE_O2_13 VREFP VREFN CTRL_083 CAP_BOTTOM_083 VDD GND R8E__A44_CAP_SWITCH_BANK_CORE_O2
XR8E__A44_CAP_SWITCH_BANK_CORE_O2_24 VREFP VREFN CTRL_096 CAP_BOTTOM_096 VDD GND R8E__A44_CAP_SWITCH_BANK_CORE_O2
XR8E__A44_CAP_SWITCH_BANK_CORE_O2_47 VREFP VREFN CTRL_122 CAP_BOTTOM_122 VDD GND R8E__A44_CAP_SWITCH_BANK_CORE_O2
XR8E__A44_CAP_SWITCH_BANK_CORE_O2_25 VREFP VREFN CTRL_080 CAP_BOTTOM_080 VDD GND R8E__A44_CAP_SWITCH_BANK_CORE_O2
XR8E__A44_CAP_SWITCH_BANK_CORE_O2_36 VREFP VREFN CTRL_109 CAP_BOTTOM_109 VDD GND R8E__A44_CAP_SWITCH_BANK_CORE_O2
XR8E__A44_CAP_SWITCH_BANK_CORE_O2_58 VREFP VREFN CTRL_072 CAP_BOTTOM_072 VDD GND R8E__A44_CAP_SWITCH_BANK_CORE_O2
XR8E__A44_CAP_SWITCH_BANK_CORE_O2_14 VREFP VREFN CTRL_064 CAP_BOTTOM_064 VDD GND R8E__A44_CAP_SWITCH_BANK_CORE_O2
XR8E__A44_CAP_SWITCH_BANK_CORE_O2_37 VREFP VREFN CTRL_093 CAP_BOTTOM_093 VDD GND R8E__A44_CAP_SWITCH_BANK_CORE_O2
XR8E__A44_CAP_SWITCH_BANK_CORE_O2_59 VREFP VREFN CTRL_119 CAP_BOTTOM_119 VDD GND R8E__A44_CAP_SWITCH_BANK_CORE_O2
XR8E__A44_CAP_SWITCH_BANK_CORE_O2_15 VREFP VREFN CTRL_114 CAP_BOTTOM_114 VDD GND R8E__A44_CAP_SWITCH_BANK_CORE_O2
XR8E__A44_CAP_SWITCH_BANK_CORE_O2_48 VREFP VREFN CTRL_106 CAP_BOTTOM_106 VDD GND R8E__A44_CAP_SWITCH_BANK_CORE_O2
XR8E__A44_CAP_SWITCH_BANK_CORE_O2_26 VREFP VREFN CTRL_065 CAP_BOTTOM_065 VDD GND R8E__A44_CAP_SWITCH_BANK_CORE_O2
XR8E__A44_CAP_SWITCH_BANK_CORE_O2_39 VREFP VREFN CTRL_124 CAP_BOTTOM_124 VDD GND R8E__A44_CAP_SWITCH_BANK_CORE_O2
XR8E__A44_CAP_SWITCH_BANK_CORE_O2_49 VREFP VREFN CTRL_090 CAP_BOTTOM_090 VDD GND R8E__A44_CAP_SWITCH_BANK_CORE_O2
XR8E__A44_CAP_SWITCH_BANK_CORE_O2_17 VREFP VREFN CTRL_082 CAP_BOTTOM_082 VDD GND R8E__A44_CAP_SWITCH_BANK_CORE_O2
XR8E__A44_CAP_SWITCH_BANK_CORE_O2_27 VREFP VREFN CTRL_111 CAP_BOTTOM_111 VDD GND R8E__A44_CAP_SWITCH_BANK_CORE_O2
XR8E__A44_CAP_SWITCH_BANK_CORE_O2_38 VREFP VREFN CTRL_077 CAP_BOTTOM_077 VDD GND R8E__A44_CAP_SWITCH_BANK_CORE_O2
XR8E__A44_CAP_SWITCH_BANK_CORE_O2_0 VREFP VREFN CTRL_102 CAP_BOTTOM_102 VDD GND R8E__A44_CAP_SWITCH_BANK_CORE_O2
XR8E__A44_CAP_SWITCH_BANK_CORE_O2_16 VREFP VREFN CTRL_098 CAP_BOTTOM_098 VDD GND R8E__A44_CAP_SWITCH_BANK_CORE_O2
XR8E__A44_CAP_SWITCH_BANK_CORE_O2_28 VREFP VREFN CTRL_095 CAP_BOTTOM_095 VDD GND R8E__A44_CAP_SWITCH_BANK_CORE_O2
XR8E__A44_CAP_SWITCH_BANK_CORE_O2_1 VREFP VREFN CTRL_086 CAP_BOTTOM_086 VDD GND R8E__A44_CAP_SWITCH_BANK_CORE_O2
XR8E__A44_CAP_SWITCH_BANK_CORE_O2_29 VREFP VREFN CTRL_079 CAP_BOTTOM_079 VDD GND R8E__A44_CAP_SWITCH_BANK_CORE_O2
XR8E__A44_CAP_SWITCH_BANK_CORE_O2_18 VREFP VREFN CTRL_067 CAP_BOTTOM_067 VDD GND R8E__A44_CAP_SWITCH_BANK_CORE_O2
XR8E__A44_CAP_SWITCH_BANK_CORE_O2_19 VREFP VREFN CTRL_113 CAP_BOTTOM_113 VDD GND R8E__A44_CAP_SWITCH_BANK_CORE_O2
XR8E__A44_CAP_SWITCH_BANK_CORE_O2_2 VREFP VREFN CTRL_071 CAP_BOTTOM_071 VDD GND R8E__A44_CAP_SWITCH_BANK_CORE_O2
XR8E__A44_CAP_SWITCH_BANK_CORE_O2_3 VREFP VREFN CTRL_117 CAP_BOTTOM_117 VDD GND R8E__A44_CAP_SWITCH_BANK_CORE_O2
XR8E__A44_CAP_SWITCH_BANK_CORE_O2_4 VREFP VREFN CTRL_101 CAP_BOTTOM_101 VDD GND R8E__A44_CAP_SWITCH_BANK_CORE_O2
XR8E__A44_CAP_SWITCH_BANK_CORE_O2_5 VREFP VREFN CTRL_085 CAP_BOTTOM_085 VDD GND R8E__A44_CAP_SWITCH_BANK_CORE_O2
XR8E__A44_CAP_SWITCH_BANK_CORE_O2_6 VREFP VREFN CTRL_070 CAP_BOTTOM_070 VDD GND R8E__A44_CAP_SWITCH_BANK_CORE_O2
XR8E__A44_CAP_SWITCH_BANK_CORE_O2_7 VREFP VREFN CTRL_116 CAP_BOTTOM_116 VDD GND R8E__A44_CAP_SWITCH_BANK_CORE_O2
XR8E__A44_CAP_SWITCH_BANK_CORE_O2_8 VREFP VREFN CTRL_100 CAP_BOTTOM_100 VDD GND R8E__A44_CAP_SWITCH_BANK_CORE_O2
XR8E__A44_CAP_SWITCH_BANK_CORE_O2_9 VREFP VREFN CTRL_084 CAP_BOTTOM_084 VDD GND R8E__A44_CAP_SWITCH_BANK_CORE_O2
.ends

.subckt R8E__A44_CDAC_CAP_BANK_ASSEMBLY_R8_M6 R8E__A44_SW_BANK64_NORTH_R8_M6_0/CTRL_020
+ R8E__A44_SW_BANK64_NORTH_R8_M6_0/CTRL_053 R8E__A44_SW_BANK64_NORTH_R8_M6_0/CTRL_042
+ R8E__A44_SW_BANK64_SOUTH_R8_M6_0/CTRL_083 R8E__A44_SW_BANK64_SOUTH_R8_M6_0/CTRL_072
+ R8E__A44_SW_BANK64_NORTH_R8_M6_0/CTRL_031 R8E__A44_SW_BANK64_SOUTH_R8_M6_0/CTRL_094
+ R8E__A44_SW_BANK64_SOUTH_R8_M6_0/VDD R8E__A44_SW_BANK64_SOUTH_R8_M6_0/CTRL_082 R8E__A44_SW_BANK64_NORTH_R8_M6_0/CTRL_030
+ R8E__A44_SW_BANK64_SOUTH_R8_M6_0/CTRL_071 R8E__A44_SW_BANK64_SOUTH_R8_M6_0/CTRL_093
+ R8E__A44_SW_BANK64_NORTH_R8_M6_0/CTRL_052 R8E__A44_SW_BANK64_NORTH_R8_M6_0/CTRL_041
+ R8E__A44_SW_BANK64_NORTH_R8_M6_0/CTRL_063 R8E__A44_SW_BANK64_NORTH_R8_M6_0/CTRL_051
+ R8E__A44_SW_BANK64_NORTH_R8_M6_0/CTRL_040 R8E__A44_SW_BANK64_SOUTH_R8_M6_0/CTRL_070
+ R8E__A44_SW_BANK64_SOUTH_R8_M6_0/CTRL_092 R8E__A44_SW_BANK64_SOUTH_R8_M6_0/CTRL_081
+ R8E__A44_SW_BANK64_NORTH_R8_M6_0/CTRL_062 R8E__A44_SW_BANK64_SOUTH_R8_M6_0/CTRL_080
+ R8E__A44_SW_BANK64_NORTH_R8_M6_0/CTRL_061 R8E__A44_SW_BANK64_SOUTH_R8_M6_0/CTRL_091
+ R8E__A44_SW_BANK64_NORTH_R8_M6_0/CTRL_050 R8E__A44_SW_BANK64_NORTH_R8_M6_0/CTRL_060
+ R8E__A44_SW_BANK64_SOUTH_R8_M6_0/CTRL_090 R8E__A44_SW_BANK64_SOUTH_R8_M6_0/CTRL_109
+ R8E__A44_SW_BANK64_SOUTH_R8_M6_0/CTRL_119 R8E__A44_SW_BANK64_SOUTH_R8_M6_0/CTRL_108
+ R8E__A44_SW_BANK64_SOUTH_R8_M6_0/CTRL_118 R8E__A44_SW_BANK64_SOUTH_R8_M6_0/CTRL_107
+ R8E__A44_SW_BANK64_SOUTH_R8_M6_0/VREFP R8E__A44_SW_BANK64_SOUTH_R8_M6_0/CTRL_106
+ R8E__A44_SW_BANK64_SOUTH_R8_M6_0/CTRL_117 R8E__A44_SW_BANK64_SOUTH_R8_M6_0/CTRL_116
+ R8E__A44_SW_BANK64_SOUTH_R8_M6_0/CTRL_105 R8E__A44_SW_BANK64_SOUTH_R8_M6_0/CTRL_115
+ R8E__A44_SW_BANK64_SOUTH_R8_M6_0/CTRL_126 R8E__A44_SW_BANK64_SOUTH_R8_M6_0/CTRL_104
+ R8E__A44_SW_BANK64_SOUTH_R8_M6_0/CTRL_125 R8E__A44_SW_BANK64_SOUTH_R8_M6_0/CTRL_114
+ R8E__A44_SW_BANK64_SOUTH_R8_M6_0/CTRL_103 R8E__A44_SW_BANK64_SOUTH_R8_M6_0/CTRL_102
+ R8E__A44_SW_BANK64_SOUTH_R8_M6_0/CTRL_124 R8E__A44_SW_BANK64_SOUTH_R8_M6_0/CTRL_113
+ R8E__A44_SW_BANK64_SOUTH_R8_M6_0/CTRL_123 R8E__A44_SW_BANK64_SOUTH_R8_M6_0/CTRL_112
+ R8E__A44_SW_BANK64_SOUTH_R8_M6_0/CTRL_101 R8E__A44_SW_BANK64_SOUTH_R8_M6_0/CTRL_111
+ R8E__A44_SW_BANK64_SOUTH_R8_M6_0/CTRL_122 R8E__A44_SW_BANK64_SOUTH_R8_M6_0/CTRL_100
+ R8E__A44_SW_BANK64_SOUTH_R8_M6_0/CTRL_121 R8E__A44_SW_BANK64_SOUTH_R8_M6_0/CTRL_110
+ R8E__A44_SW_BANK64_SOUTH_R8_M6_0/CTRL_120 R8E__A44_SW_BANK64_SOUTH_R8_M6_0/VREFN
+ R8E__A44_SW_BANK64_NORTH_R8_M6_0/VREFP R8E__A44_SW_BANK64_NORTH_R8_M6_0/CTRL_009
+ R8E__A44_SW_BANK64_NORTH_R8_M6_0/CTRL_019 R8E__A44_SW_BANK64_NORTH_R8_M6_0/CTRL_008
+ R8E__A44_SW_BANK64_NORTH_R8_M6_0/VREFN R8E__A44_SW_BANK64_NORTH_R8_M6_0/CTRL_007
+ R8E__A44_SW_BANK64_NORTH_R8_M6_0/CTRL_029 R8E__A44_SW_BANK64_NORTH_R8_M6_0/CTRL_018
+ R8E__A44_SW_BANK64_NORTH_R8_M6_0/CTRL_028 R8E__A44_SW_BANK64_SOUTH_R8_M6_0/CTRL_069
+ R8E__A44_SW_BANK64_NORTH_R8_M6_0/CTRL_017 R8E__A44_SW_BANK64_NORTH_R8_M6_0/CTRL_006
+ R8E__A44_SW_BANK64_NORTH_R8_M6_0/CTRL_039 R8E__A44_SW_BANK64_NORTH_R8_M6_0/CTRL_005
+ R8E__A44_SW_BANK64_NORTH_R8_M6_0/CTRL_016 R8E__A44_SW_BANK64_NORTH_R8_M6_0/CTRL_049
+ R8E__A44_SW_BANK64_NORTH_R8_M6_0/CTRL_038 R8E__A44_SW_BANK64_SOUTH_R8_M6_0/CTRL_079
+ R8E__A44_SW_BANK64_NORTH_R8_M6_0/CTRL_027 R8E__A44_SW_BANK64_SOUTH_R8_M6_0/CTRL_068
+ R8E__A44_SW_BANK64_NORTH_R8_M6_0/CTRL_015 R8E__A44_SW_BANK64_SOUTH_R8_M6_0/CTRL_067
+ R8E__A44_SW_BANK64_SOUTH_R8_M6_0/CTRL_089 R8E__A44_SW_BANK64_SOUTH_R8_M6_0/CTRL_078
+ R8E__A44_SW_BANK64_NORTH_R8_M6_0/CTRL_048 R8E__A44_SW_BANK64_NORTH_R8_M6_0/CTRL_004
+ R8E__A44_SW_BANK64_NORTH_R8_M6_0/CTRL_037 R8E__A44_SW_BANK64_NORTH_R8_M6_0/CTRL_059
+ R8E__A44_SW_BANK64_NORTH_R8_M6_0/CTRL_026 R8E__A44_SW_BANK64_NORTH_R8_M6_0/CTRL_003
+ R8E__A44_SW_BANK64_NORTH_R8_M6_0/VDD R8E__A44_SW_BANK64_NORTH_R8_M6_0/CTRL_025 R8E__A44_SW_BANK64_NORTH_R8_M6_0/CTRL_058
+ R8E__A44_SW_BANK64_NORTH_R8_M6_0/CTRL_014 R8E__A44_SW_BANK64_NORTH_R8_M6_0/CTRL_047
+ R8E__A44_SW_BANK64_NORTH_R8_M6_0/CTRL_036 R8E__A44_SW_BANK64_SOUTH_R8_M6_0/CTRL_066
+ R8E__A44_SW_BANK64_SOUTH_R8_M6_0/CTRL_088 R8E__A44_SW_BANK64_SOUTH_R8_M6_0/CTRL_077
+ R8E__A44_SW_BANK64_SOUTH_R8_M6_0/CTRL_099 R8E__A44_SW_BANK64_SOUTH_R8_M6_0/CTRL_098
+ R8E__A44_SW_BANK64_NORTH_R8_M6_0/CTRL_024 R8E__A44_SW_BANK64_NORTH_R8_M6_0/CTRL_057
+ R8E__A44_SW_BANK64_NORTH_R8_M6_0/CTRL_046 R8E__A44_SW_BANK64_SOUTH_R8_M6_0/CTRL_065
+ R8E__A44_SW_BANK64_SOUTH_R8_M6_0/CTRL_087 R8E__A44_SW_BANK64_SOUTH_R8_M6_0/CTRL_076
+ R8E__A44_SW_BANK64_NORTH_R8_M6_0/CTRL_002 R8E__A44_SW_BANK64_NORTH_R8_M6_0/CTRL_035
+ R8E__A44_SW_BANK64_NORTH_R8_M6_0/CTRL_013 R8E__A44_SW_BANK64_NORTH_R8_M6_0/CTRL_001
+ R8E__A44_SW_BANK64_SOUTH_R8_M6_0/CTRL_086 R8E__A44_SW_BANK64_SOUTH_R8_M6_0/CTRL_075
+ R8E__A44_SW_BANK64_NORTH_R8_M6_0/CTRL_034 R8E__A44_SW_BANK64_SOUTH_R8_M6_0/CTRL_097
+ R8E__A44_SW_BANK64_NORTH_R8_M6_0/CTRL_023 R8E__A44_SW_BANK64_NORTH_R8_M6_0/CTRL_056
+ R8E__A44_SW_BANK64_NORTH_R8_M6_0/CTRL_012 R8E__A44_SW_BANK64_NORTH_R8_M6_0/CTRL_045
+ R8E__A44_SW_BANK64_SOUTH_R8_M6_0/CTRL_064 R8E__A44_SW_BANK64_NORTH_R8_M6_0/CTRL_055
+ R8E__A44_SW_BANK64_NORTH_R8_M6_0/CTRL_044 R8E__A44_SW_BANK64_SOUTH_R8_M6_0/CTRL_096
+ R8E__A44_SW_BANK64_NORTH_R8_M6_0/CTRL_011 R8E__A44_SW_BANK64_SOUTH_R8_M6_0/CTRL_085
+ R8E__A44_SW_BANK64_SOUTH_R8_M6_0/CTRL_074 R8E__A44_SW_BANK64_NORTH_R8_M6_0/CTRL_000
+ R8E__A44_SW_BANK64_NORTH_R8_M6_0/CTRL_033 R8E__A44_SW_BANK64_NORTH_R8_M6_0/CTRL_022
+ VSUBS R8E__A44_SW_BANK64_SOUTH_R8_M6_0/CTRL_084 R8E__A44_SW_BANK64_SOUTH_R8_M6_0/CTRL_073
+ R8E__A44_SW_BANK64_SOUTH_R8_M6_0/CTRL_095 R8E__A44_SW_BANK64_NORTH_R8_M6_0/CTRL_021
+ R8E__A44_SW_BANK64_NORTH_R8_M6_0/CTRL_054 R8E__A44_SW_BANK64_NORTH_R8_M6_0/CTRL_010
+ R8E__A44_SW_BANK64_NORTH_R8_M6_0/CTRL_043 R8E__A44_SW_BANK64_NORTH_R8_M6_0/CTRL_032
+ VTOP
XR8E__A44_CAP_CORE128_M6_R1_0 R8E__A44_CAP_CORE128_M6_R1_0/CAP_BOTTOM_008 R8E__A44_CAP_CORE128_M6_R1_0/CAP_BOTTOM_009
+ R8E__A44_CAP_CORE128_M6_R1_0/CAP_BOTTOM_010 R8E__A44_CAP_CORE128_M6_R1_0/CAP_BOTTOM_011
+ R8E__A44_CAP_CORE128_M6_R1_0/CAP_BOTTOM_012 R8E__A44_CAP_CORE128_M6_R1_0/CAP_BOTTOM_013
+ R8E__A44_CAP_CORE128_M6_R1_0/CAP_BOTTOM_014 R8E__A44_CAP_CORE128_M6_R1_0/CAP_BOTTOM_015
+ R8E__A44_CAP_CORE128_M6_R1_0/CAP_BOTTOM_024 R8E__A44_CAP_CORE128_M6_R1_0/CAP_BOTTOM_025
+ R8E__A44_CAP_CORE128_M6_R1_0/CAP_BOTTOM_026 R8E__A44_CAP_CORE128_M6_R1_0/CAP_BOTTOM_027
+ R8E__A44_CAP_CORE128_M6_R1_0/CAP_BOTTOM_028 R8E__A44_CAP_CORE128_M6_R1_0/CAP_BOTTOM_029
+ R8E__A44_CAP_CORE128_M6_R1_0/CAP_BOTTOM_030 R8E__A44_CAP_CORE128_M6_R1_0/CAP_BOTTOM_031
+ R8E__A44_CAP_CORE128_M6_R1_0/CAP_BOTTOM_040 R8E__A44_CAP_CORE128_M6_R1_0/CAP_BOTTOM_041
+ R8E__A44_CAP_CORE128_M6_R1_0/CAP_BOTTOM_042 R8E__A44_CAP_CORE128_M6_R1_0/CAP_BOTTOM_043
+ R8E__A44_CAP_CORE128_M6_R1_0/CAP_BOTTOM_044 R8E__A44_CAP_CORE128_M6_R1_0/CAP_BOTTOM_045
+ R8E__A44_CAP_CORE128_M6_R1_0/CAP_BOTTOM_046 R8E__A44_CAP_CORE128_M6_R1_0/CAP_BOTTOM_047
+ R8E__A44_CAP_CORE128_M6_R1_0/CAP_BOTTOM_056 R8E__A44_CAP_CORE128_M6_R1_0/CAP_BOTTOM_057
+ R8E__A44_CAP_CORE128_M6_R1_0/CAP_BOTTOM_058 R8E__A44_CAP_CORE128_M6_R1_0/CAP_BOTTOM_059
+ R8E__A44_CAP_CORE128_M6_R1_0/CAP_BOTTOM_060 R8E__A44_CAP_CORE128_M6_R1_0/CAP_BOTTOM_061
+ R8E__A44_CAP_CORE128_M6_R1_0/CAP_BOTTOM_062 R8E__A44_CAP_CORE128_M6_R1_0/CAP_BOTTOM_063
+ R8E__A44_CAP_CORE128_M6_R1_0/CAP_BOTTOM_032 R8E__A44_CAP_CORE128_M6_R1_0/CAP_BOTTOM_033
+ R8E__A44_CAP_CORE128_M6_R1_0/CAP_BOTTOM_034 R8E__A44_CAP_CORE128_M6_R1_0/CAP_BOTTOM_035
+ R8E__A44_CAP_CORE128_M6_R1_0/CAP_BOTTOM_036 R8E__A44_CAP_CORE128_M6_R1_0/CAP_BOTTOM_037
+ R8E__A44_CAP_CORE128_M6_R1_0/CAP_BOTTOM_038 R8E__A44_CAP_CORE128_M6_R1_0/CAP_BOTTOM_039
+ R8E__A44_CAP_CORE128_M6_R1_0/CAP_BOTTOM_016 R8E__A44_CAP_CORE128_M6_R1_0/CAP_BOTTOM_017
+ R8E__A44_CAP_CORE128_M6_R1_0/CAP_BOTTOM_018 R8E__A44_CAP_CORE128_M6_R1_0/CAP_BOTTOM_019
+ R8E__A44_CAP_CORE128_M6_R1_0/CAP_BOTTOM_020 R8E__A44_CAP_CORE128_M6_R1_0/CAP_BOTTOM_021
+ R8E__A44_CAP_CORE128_M6_R1_0/CAP_BOTTOM_022 R8E__A44_CAP_CORE128_M6_R1_0/CAP_BOTTOM_023
+ R8E__A44_CAP_CORE128_M6_R1_0/CAP_BOTTOM_048 R8E__A44_CAP_CORE128_M6_R1_0/CAP_BOTTOM_049
+ R8E__A44_CAP_CORE128_M6_R1_0/CAP_BOTTOM_050 R8E__A44_CAP_CORE128_M6_R1_0/CAP_BOTTOM_051
+ R8E__A44_CAP_CORE128_M6_R1_0/CAP_BOTTOM_052 R8E__A44_CAP_CORE128_M6_R1_0/CAP_BOTTOM_053
+ R8E__A44_CAP_CORE128_M6_R1_0/CAP_BOTTOM_054 R8E__A44_CAP_CORE128_M6_R1_0/CAP_BOTTOM_055
+ R8E__A44_CAP_CORE128_M6_R1_0/CAP_BOTTOM_000 R8E__A44_CAP_CORE128_M6_R1_0/CAP_BOTTOM_001
+ R8E__A44_CAP_CORE128_M6_R1_0/CAP_BOTTOM_002 R8E__A44_CAP_CORE128_M6_R1_0/CAP_BOTTOM_003
+ R8E__A44_CAP_CORE128_M6_R1_0/CAP_BOTTOM_004 R8E__A44_CAP_CORE128_M6_R1_0/CAP_BOTTOM_005
+ R8E__A44_CAP_CORE128_M6_R1_0/CAP_BOTTOM_006 R8E__A44_CAP_CORE128_M6_R1_0/CAP_BOTTOM_007
+ R8E__A44_CAP_CORE128_M6_R1_0/CAP_BOTTOM_064 R8E__A44_CAP_CORE128_M6_R1_0/CAP_BOTTOM_065
+ R8E__A44_CAP_CORE128_M6_R1_0/CAP_BOTTOM_066 R8E__A44_CAP_CORE128_M6_R1_0/CAP_BOTTOM_067
+ R8E__A44_CAP_CORE128_M6_R1_0/CAP_BOTTOM_068 R8E__A44_CAP_CORE128_M6_R1_0/CAP_BOTTOM_069
+ R8E__A44_CAP_CORE128_M6_R1_0/CAP_BOTTOM_070 R8E__A44_CAP_CORE128_M6_R1_0/CAP_BOTTOM_071
+ R8E__A44_CAP_CORE128_M6_R1_0/CAP_BOTTOM_079 R8E__A44_CAP_CORE128_M6_R1_0/CAP_BOTTOM_080
+ R8E__A44_CAP_CORE128_M6_R1_0/CAP_BOTTOM_081 R8E__A44_CAP_CORE128_M6_R1_0/CAP_BOTTOM_082
+ R8E__A44_CAP_CORE128_M6_R1_0/CAP_BOTTOM_083 R8E__A44_CAP_CORE128_M6_R1_0/CAP_BOTTOM_084
+ R8E__A44_CAP_CORE128_M6_R1_0/CAP_BOTTOM_085 R8E__A44_CAP_CORE128_M6_R1_0/CAP_BOTTOM_086
+ R8E__A44_CAP_CORE128_M6_R1_0/CAP_BOTTOM_095 R8E__A44_CAP_CORE128_M6_R1_0/CAP_BOTTOM_096
+ R8E__A44_CAP_CORE128_M6_R1_0/CAP_BOTTOM_097 R8E__A44_CAP_CORE128_M6_R1_0/CAP_BOTTOM_098
+ R8E__A44_CAP_CORE128_M6_R1_0/CAP_BOTTOM_099 R8E__A44_CAP_CORE128_M6_R1_0/CAP_BOTTOM_100
+ R8E__A44_CAP_CORE128_M6_R1_0/CAP_BOTTOM_101 R8E__A44_CAP_CORE128_M6_R1_0/CAP_BOTTOM_102
+ R8E__A44_CAP_CORE128_M6_R1_0/CAP_BOTTOM_111 R8E__A44_CAP_CORE128_M6_R1_0/CAP_BOTTOM_112
+ R8E__A44_CAP_CORE128_M6_R1_0/CAP_BOTTOM_113 R8E__A44_CAP_CORE128_M6_R1_0/CAP_BOTTOM_114
+ R8E__A44_CAP_CORE128_M6_R1_0/CAP_BOTTOM_115 R8E__A44_CAP_CORE128_M6_R1_0/CAP_BOTTOM_116
+ R8E__A44_CAP_CORE128_M6_R1_0/CAP_BOTTOM_117 R8E__A44_CAP_CORE128_M6_R1_0/CAP_BOTTOM_118
+ VSUBS R8E__A44_CAP_CORE128_M6_R1_0/CAP_BOTTOM_072 R8E__A44_CAP_CORE128_M6_R1_0/CAP_BOTTOM_073
+ R8E__A44_CAP_CORE128_M6_R1_0/CAP_BOTTOM_074 R8E__A44_CAP_CORE128_M6_R1_0/CAP_BOTTOM_075
+ R8E__A44_CAP_CORE128_M6_R1_0/CAP_BOTTOM_076 R8E__A44_CAP_CORE128_M6_R1_0/CAP_BOTTOM_077
+ R8E__A44_CAP_CORE128_M6_R1_0/CAP_BOTTOM_078 R8E__A44_CAP_CORE128_M6_R1_0/CAP_BOTTOM_103
+ R8E__A44_CAP_CORE128_M6_R1_0/CAP_BOTTOM_104 R8E__A44_CAP_CORE128_M6_R1_0/CAP_BOTTOM_105
+ R8E__A44_CAP_CORE128_M6_R1_0/CAP_BOTTOM_106 R8E__A44_CAP_CORE128_M6_R1_0/CAP_BOTTOM_107
+ R8E__A44_CAP_CORE128_M6_R1_0/CAP_BOTTOM_108 R8E__A44_CAP_CORE128_M6_R1_0/CAP_BOTTOM_109
+ R8E__A44_CAP_CORE128_M6_R1_0/CAP_BOTTOM_110 R8E__A44_CAP_CORE128_M6_R1_0/CAP_BOTTOM_087
+ R8E__A44_CAP_CORE128_M6_R1_0/CAP_BOTTOM_088 R8E__A44_CAP_CORE128_M6_R1_0/CAP_BOTTOM_089
+ R8E__A44_CAP_CORE128_M6_R1_0/CAP_BOTTOM_090 R8E__A44_CAP_CORE128_M6_R1_0/CAP_BOTTOM_091
+ R8E__A44_CAP_CORE128_M6_R1_0/CAP_BOTTOM_092 R8E__A44_CAP_CORE128_M6_R1_0/CAP_BOTTOM_093
+ R8E__A44_CAP_CORE128_M6_R1_0/CAP_BOTTOM_094 R8E__A44_CAP_CORE128_M6_R1_0/CAP_BOTTOM_119
+ R8E__A44_CAP_CORE128_M6_R1_0/CAP_BOTTOM_120 R8E__A44_CAP_CORE128_M6_R1_0/CAP_BOTTOM_121
+ R8E__A44_CAP_CORE128_M6_R1_0/CAP_BOTTOM_122 R8E__A44_CAP_CORE128_M6_R1_0/CAP_BOTTOM_123
+ R8E__A44_CAP_CORE128_M6_R1_0/CAP_BOTTOM_124 R8E__A44_CAP_CORE128_M6_R1_0/CAP_BOTTOM_125
+ R8E__A44_CAP_CORE128_M6_R1_0/CAP_BOTTOM_126 VTOP R8E__A44_CAP_CORE128_M6_R1
XR8E__A44_SW_BANK64_NORTH_R8_M6_0 R8E__A44_SW_BANK64_NORTH_R8_M6_0/CTRL_008 R8E__A44_SW_BANK64_NORTH_R8_M6_0/CTRL_024
+ R8E__A44_SW_BANK64_NORTH_R8_M6_0/CTRL_040 R8E__A44_SW_BANK64_NORTH_R8_M6_0/CTRL_056
+ R8E__A44_SW_BANK64_NORTH_R8_M6_0/CTRL_009 R8E__A44_SW_BANK64_NORTH_R8_M6_0/CTRL_025
+ R8E__A44_SW_BANK64_NORTH_R8_M6_0/CTRL_041 R8E__A44_SW_BANK64_NORTH_R8_M6_0/CTRL_057
+ R8E__A44_SW_BANK64_NORTH_R8_M6_0/CTRL_010 R8E__A44_SW_BANK64_NORTH_R8_M6_0/CTRL_026
+ R8E__A44_SW_BANK64_NORTH_R8_M6_0/CTRL_042 R8E__A44_SW_BANK64_NORTH_R8_M6_0/CTRL_058
+ R8E__A44_SW_BANK64_NORTH_R8_M6_0/CTRL_011 R8E__A44_SW_BANK64_NORTH_R8_M6_0/CTRL_027
+ R8E__A44_SW_BANK64_NORTH_R8_M6_0/CTRL_043 R8E__A44_SW_BANK64_NORTH_R8_M6_0/CTRL_059
+ R8E__A44_SW_BANK64_NORTH_R8_M6_0/CTRL_012 R8E__A44_SW_BANK64_NORTH_R8_M6_0/CTRL_028
+ R8E__A44_SW_BANK64_NORTH_R8_M6_0/CTRL_044 R8E__A44_SW_BANK64_NORTH_R8_M6_0/CTRL_060
+ R8E__A44_SW_BANK64_NORTH_R8_M6_0/CTRL_013 R8E__A44_SW_BANK64_NORTH_R8_M6_0/CTRL_029
+ R8E__A44_SW_BANK64_NORTH_R8_M6_0/CTRL_045 R8E__A44_SW_BANK64_NORTH_R8_M6_0/CTRL_061
+ R8E__A44_SW_BANK64_NORTH_R8_M6_0/CTRL_014 R8E__A44_SW_BANK64_NORTH_R8_M6_0/CTRL_030
+ R8E__A44_SW_BANK64_NORTH_R8_M6_0/CTRL_046 R8E__A44_SW_BANK64_NORTH_R8_M6_0/CTRL_062
+ R8E__A44_SW_BANK64_NORTH_R8_M6_0/CTRL_015 R8E__A44_SW_BANK64_NORTH_R8_M6_0/CTRL_031
+ R8E__A44_SW_BANK64_NORTH_R8_M6_0/CTRL_047 R8E__A44_SW_BANK64_NORTH_R8_M6_0/CTRL_063
+ R8E__A44_SW_BANK64_NORTH_R8_M6_0/CTRL_000 R8E__A44_SW_BANK64_NORTH_R8_M6_0/CTRL_016
+ R8E__A44_SW_BANK64_NORTH_R8_M6_0/CTRL_032 R8E__A44_SW_BANK64_NORTH_R8_M6_0/CTRL_048
+ R8E__A44_SW_BANK64_NORTH_R8_M6_0/CTRL_001 R8E__A44_SW_BANK64_NORTH_R8_M6_0/CTRL_017
+ R8E__A44_SW_BANK64_NORTH_R8_M6_0/CTRL_033 R8E__A44_SW_BANK64_NORTH_R8_M6_0/CTRL_049
+ R8E__A44_SW_BANK64_NORTH_R8_M6_0/CTRL_002 R8E__A44_SW_BANK64_NORTH_R8_M6_0/CTRL_018
+ R8E__A44_SW_BANK64_NORTH_R8_M6_0/CTRL_034 R8E__A44_SW_BANK64_NORTH_R8_M6_0/CTRL_050
+ R8E__A44_SW_BANK64_NORTH_R8_M6_0/CTRL_003 R8E__A44_SW_BANK64_NORTH_R8_M6_0/CTRL_019
+ R8E__A44_SW_BANK64_NORTH_R8_M6_0/CTRL_035 R8E__A44_SW_BANK64_NORTH_R8_M6_0/CTRL_051
+ R8E__A44_SW_BANK64_NORTH_R8_M6_0/CTRL_004 R8E__A44_SW_BANK64_NORTH_R8_M6_0/CTRL_020
+ R8E__A44_SW_BANK64_NORTH_R8_M6_0/CTRL_036 R8E__A44_SW_BANK64_NORTH_R8_M6_0/CTRL_052
+ R8E__A44_SW_BANK64_NORTH_R8_M6_0/CTRL_005 R8E__A44_SW_BANK64_NORTH_R8_M6_0/CTRL_021
+ R8E__A44_SW_BANK64_NORTH_R8_M6_0/CTRL_037 R8E__A44_SW_BANK64_NORTH_R8_M6_0/CTRL_053
+ R8E__A44_SW_BANK64_NORTH_R8_M6_0/CTRL_006 R8E__A44_SW_BANK64_NORTH_R8_M6_0/CTRL_022
+ R8E__A44_SW_BANK64_NORTH_R8_M6_0/CTRL_038 R8E__A44_SW_BANK64_NORTH_R8_M6_0/CTRL_054
+ R8E__A44_SW_BANK64_NORTH_R8_M6_0/CTRL_007 R8E__A44_SW_BANK64_NORTH_R8_M6_0/CTRL_023
+ R8E__A44_SW_BANK64_NORTH_R8_M6_0/CTRL_039 R8E__A44_SW_BANK64_NORTH_R8_M6_0/CTRL_055
+ R8E__A44_CAP_CORE128_M6_R1_0/CAP_BOTTOM_004 R8E__A44_CAP_CORE128_M6_R1_0/CAP_BOTTOM_002
+ R8E__A44_CAP_CORE128_M6_R1_0/CAP_BOTTOM_020 R8E__A44_CAP_CORE128_M6_R1_0/CAP_BOTTOM_001
+ R8E__A44_CAP_CORE128_M6_R1_0/CAP_BOTTOM_036 R8E__A44_CAP_CORE128_M6_R1_0/CAP_BOTTOM_018
+ R8E__A44_CAP_CORE128_M6_R1_0/CAP_BOTTOM_052 R8E__A44_CAP_CORE128_M6_R1_0/CAP_BOTTOM_032
+ R8E__A44_CAP_CORE128_M6_R1_0/CAP_BOTTOM_005 R8E__A44_CAP_CORE128_M6_R1_0/CAP_BOTTOM_034
+ R8E__A44_CAP_CORE128_M6_R1_0/CAP_BOTTOM_021 R8E__A44_CAP_CORE128_M6_R1_0/CAP_BOTTOM_017
+ R8E__A44_CAP_CORE128_M6_R1_0/CAP_BOTTOM_037 R8E__A44_CAP_CORE128_M6_R1_0/CAP_BOTTOM_050
+ R8E__A44_CAP_CORE128_M6_R1_0/CAP_BOTTOM_053 R8E__A44_CAP_CORE128_M6_R1_0/CAP_BOTTOM_016
+ R8E__A44_CAP_CORE128_M6_R1_0/CAP_BOTTOM_006 R8E__A44_CAP_CORE128_M6_R1_0/CAP_BOTTOM_003
+ R8E__A44_CAP_CORE128_M6_R1_0/CAP_BOTTOM_022 R8E__A44_CAP_CORE128_M6_R1_0/CAP_BOTTOM_033
+ R8E__A44_CAP_CORE128_M6_R1_0/CAP_BOTTOM_038 R8E__A44_CAP_CORE128_M6_R1_0/CAP_BOTTOM_019
+ R8E__A44_CAP_CORE128_M6_R1_0/CAP_BOTTOM_054 R8E__A44_CAP_CORE128_M6_R1_0/CAP_BOTTOM_048
+ R8E__A44_CAP_CORE128_M6_R1_0/CAP_BOTTOM_007 R8E__A44_CAP_CORE128_M6_R1_0/CAP_BOTTOM_035
+ R8E__A44_CAP_CORE128_M6_R1_0/CAP_BOTTOM_023 R8E__A44_CAP_CORE128_M6_R1_0/CAP_BOTTOM_049
+ R8E__A44_CAP_CORE128_M6_R1_0/CAP_BOTTOM_039 R8E__A44_CAP_CORE128_M6_R1_0/CAP_BOTTOM_051
+ R8E__A44_CAP_CORE128_M6_R1_0/CAP_BOTTOM_000 R8E__A44_CAP_CORE128_M6_R1_0/CAP_BOTTOM_012
+ R8E__A44_CAP_CORE128_M6_R1_0/CAP_BOTTOM_010 R8E__A44_CAP_CORE128_M6_R1_0/CAP_BOTTOM_028
+ R8E__A44_CAP_CORE128_M6_R1_0/CAP_BOTTOM_009 R8E__A44_CAP_CORE128_M6_R1_0/CAP_BOTTOM_044
+ R8E__A44_CAP_CORE128_M6_R1_0/CAP_BOTTOM_026 R8E__A44_CAP_CORE128_M6_R1_0/CAP_BOTTOM_060
+ R8E__A44_CAP_CORE128_M6_R1_0/CAP_BOTTOM_040 R8E__A44_CAP_CORE128_M6_R1_0/CAP_BOTTOM_013
+ R8E__A44_CAP_CORE128_M6_R1_0/CAP_BOTTOM_042 R8E__A44_CAP_CORE128_M6_R1_0/CAP_BOTTOM_029
+ R8E__A44_CAP_CORE128_M6_R1_0/CAP_BOTTOM_025 R8E__A44_CAP_CORE128_M6_R1_0/CAP_BOTTOM_045
+ R8E__A44_CAP_CORE128_M6_R1_0/CAP_BOTTOM_058 R8E__A44_CAP_CORE128_M6_R1_0/CAP_BOTTOM_061
+ R8E__A44_CAP_CORE128_M6_R1_0/CAP_BOTTOM_024 R8E__A44_CAP_CORE128_M6_R1_0/CAP_BOTTOM_014
+ R8E__A44_CAP_CORE128_M6_R1_0/CAP_BOTTOM_011 R8E__A44_CAP_CORE128_M6_R1_0/CAP_BOTTOM_030
+ R8E__A44_CAP_CORE128_M6_R1_0/CAP_BOTTOM_041 R8E__A44_CAP_CORE128_M6_R1_0/CAP_BOTTOM_046
+ R8E__A44_CAP_CORE128_M6_R1_0/CAP_BOTTOM_027 R8E__A44_CAP_CORE128_M6_R1_0/CAP_BOTTOM_062
+ R8E__A44_CAP_CORE128_M6_R1_0/CAP_BOTTOM_056 R8E__A44_CAP_CORE128_M6_R1_0/CAP_BOTTOM_015
+ R8E__A44_CAP_CORE128_M6_R1_0/CAP_BOTTOM_043 R8E__A44_CAP_CORE128_M6_R1_0/CAP_BOTTOM_031
+ R8E__A44_CAP_CORE128_M6_R1_0/CAP_BOTTOM_057 R8E__A44_CAP_CORE128_M6_R1_0/CAP_BOTTOM_047
+ R8E__A44_CAP_CORE128_M6_R1_0/CAP_BOTTOM_059 R8E__A44_CAP_CORE128_M6_R1_0/CAP_BOTTOM_063
+ R8E__A44_CAP_CORE128_M6_R1_0/CAP_BOTTOM_008 R8E__A44_SW_BANK64_NORTH_R8_M6_0/VREFN
+ R8E__A44_SW_BANK64_NORTH_R8_M6_0/VREFP R8E__A44_SW_BANK64_NORTH_R8_M6_0/VDD R8E__A44_CAP_CORE128_M6_R1_0/CAP_BOTTOM_055
+ VSUBS R8E__A44_SW_BANK64_NORTH_R8_M6
XR8E__A44_SW_BANK64_SOUTH_R8_M6_0 R8E__A44_CAP_CORE128_M6_R1_0/CAP_BOTTOM_087 R8E__A44_CAP_CORE128_M6_R1_0/CAP_BOTTOM_103
+ R8E__A44_CAP_CORE128_M6_R1_0/CAP_BOTTOM_119 R8E__A44_CAP_CORE128_M6_R1_0/CAP_BOTTOM_072
+ R8E__A44_CAP_CORE128_M6_R1_0/CAP_BOTTOM_088 R8E__A44_CAP_CORE128_M6_R1_0/CAP_BOTTOM_104
+ R8E__A44_CAP_CORE128_M6_R1_0/CAP_BOTTOM_120 R8E__A44_CAP_CORE128_M6_R1_0/CAP_BOTTOM_073
+ R8E__A44_CAP_CORE128_M6_R1_0/CAP_BOTTOM_089 R8E__A44_CAP_CORE128_M6_R1_0/CAP_BOTTOM_105
+ R8E__A44_CAP_CORE128_M6_R1_0/CAP_BOTTOM_121 R8E__A44_CAP_CORE128_M6_R1_0/CAP_BOTTOM_074
+ R8E__A44_CAP_CORE128_M6_R1_0/CAP_BOTTOM_090 R8E__A44_CAP_CORE128_M6_R1_0/CAP_BOTTOM_106
+ R8E__A44_CAP_CORE128_M6_R1_0/CAP_BOTTOM_122 R8E__A44_CAP_CORE128_M6_R1_0/CAP_BOTTOM_075
+ R8E__A44_CAP_CORE128_M6_R1_0/CAP_BOTTOM_091 R8E__A44_CAP_CORE128_M6_R1_0/CAP_BOTTOM_107
+ R8E__A44_CAP_CORE128_M6_R1_0/CAP_BOTTOM_123 R8E__A44_CAP_CORE128_M6_R1_0/CAP_BOTTOM_076
+ R8E__A44_CAP_CORE128_M6_R1_0/CAP_BOTTOM_092 R8E__A44_CAP_CORE128_M6_R1_0/CAP_BOTTOM_108
+ R8E__A44_CAP_CORE128_M6_R1_0/CAP_BOTTOM_124 R8E__A44_CAP_CORE128_M6_R1_0/CAP_BOTTOM_077
+ R8E__A44_CAP_CORE128_M6_R1_0/CAP_BOTTOM_093 R8E__A44_CAP_CORE128_M6_R1_0/CAP_BOTTOM_109
+ R8E__A44_CAP_CORE128_M6_R1_0/CAP_BOTTOM_125 R8E__A44_CAP_CORE128_M6_R1_0/CAP_BOTTOM_078
+ R8E__A44_CAP_CORE128_M6_R1_0/CAP_BOTTOM_094 R8E__A44_CAP_CORE128_M6_R1_0/CAP_BOTTOM_110
+ R8E__A44_CAP_CORE128_M6_R1_0/CAP_BOTTOM_126 R8E__A44_CAP_CORE128_M6_R1_0/CAP_BOTTOM_064
+ R8E__A44_CAP_CORE128_M6_R1_0/CAP_BOTTOM_079 R8E__A44_CAP_CORE128_M6_R1_0/CAP_BOTTOM_095
+ R8E__A44_CAP_CORE128_M6_R1_0/CAP_BOTTOM_111 R8E__A44_CAP_CORE128_M6_R1_0/CAP_BOTTOM_065
+ R8E__A44_CAP_CORE128_M6_R1_0/CAP_BOTTOM_080 R8E__A44_CAP_CORE128_M6_R1_0/CAP_BOTTOM_096
+ R8E__A44_CAP_CORE128_M6_R1_0/CAP_BOTTOM_112 R8E__A44_CAP_CORE128_M6_R1_0/CAP_BOTTOM_066
+ R8E__A44_CAP_CORE128_M6_R1_0/CAP_BOTTOM_081 R8E__A44_CAP_CORE128_M6_R1_0/CAP_BOTTOM_097
+ R8E__A44_CAP_CORE128_M6_R1_0/CAP_BOTTOM_113 R8E__A44_CAP_CORE128_M6_R1_0/CAP_BOTTOM_067
+ R8E__A44_CAP_CORE128_M6_R1_0/CAP_BOTTOM_082 R8E__A44_CAP_CORE128_M6_R1_0/CAP_BOTTOM_098
+ R8E__A44_CAP_CORE128_M6_R1_0/CAP_BOTTOM_114 R8E__A44_CAP_CORE128_M6_R1_0/CAP_BOTTOM_068
+ R8E__A44_CAP_CORE128_M6_R1_0/CAP_BOTTOM_083 R8E__A44_CAP_CORE128_M6_R1_0/CAP_BOTTOM_099
+ R8E__A44_CAP_CORE128_M6_R1_0/CAP_BOTTOM_115 R8E__A44_CAP_CORE128_M6_R1_0/CAP_BOTTOM_069
+ R8E__A44_CAP_CORE128_M6_R1_0/CAP_BOTTOM_084 R8E__A44_CAP_CORE128_M6_R1_0/CAP_BOTTOM_100
+ R8E__A44_CAP_CORE128_M6_R1_0/CAP_BOTTOM_116 R8E__A44_CAP_CORE128_M6_R1_0/CAP_BOTTOM_070
+ R8E__A44_CAP_CORE128_M6_R1_0/CAP_BOTTOM_085 R8E__A44_CAP_CORE128_M6_R1_0/CAP_BOTTOM_101
+ R8E__A44_CAP_CORE128_M6_R1_0/CAP_BOTTOM_117 R8E__A44_CAP_CORE128_M6_R1_0/CAP_BOTTOM_071
+ R8E__A44_CAP_CORE128_M6_R1_0/CAP_BOTTOM_086 R8E__A44_CAP_CORE128_M6_R1_0/CAP_BOTTOM_102
+ R8E__A44_CAP_CORE128_M6_R1_0/CAP_BOTTOM_118 R8E__A44_SW_BANK64_SOUTH_R8_M6_0/CTRL_064
+ R8E__A44_SW_BANK64_SOUTH_R8_M6_0/CTRL_068 R8E__A44_SW_BANK64_SOUTH_R8_M6_0/CTRL_066
+ R8E__A44_SW_BANK64_SOUTH_R8_M6_0/CTRL_083 R8E__A44_SW_BANK64_SOUTH_R8_M6_0/CTRL_065
+ R8E__A44_SW_BANK64_SOUTH_R8_M6_0/CTRL_099 R8E__A44_SW_BANK64_SOUTH_R8_M6_0/CTRL_081
+ R8E__A44_SW_BANK64_SOUTH_R8_M6_0/CTRL_115 R8E__A44_SW_BANK64_SOUTH_R8_M6_0/CTRL_095
+ R8E__A44_SW_BANK64_SOUTH_R8_M6_0/CTRL_069 R8E__A44_SW_BANK64_SOUTH_R8_M6_0/CTRL_097
+ R8E__A44_SW_BANK64_SOUTH_R8_M6_0/CTRL_084 R8E__A44_SW_BANK64_SOUTH_R8_M6_0/CTRL_080
+ R8E__A44_SW_BANK64_SOUTH_R8_M6_0/CTRL_100 R8E__A44_SW_BANK64_SOUTH_R8_M6_0/CTRL_113
+ R8E__A44_SW_BANK64_SOUTH_R8_M6_0/CTRL_116 R8E__A44_SW_BANK64_SOUTH_R8_M6_0/CTRL_079
+ R8E__A44_SW_BANK64_SOUTH_R8_M6_0/CTRL_070 R8E__A44_SW_BANK64_SOUTH_R8_M6_0/CTRL_067
+ R8E__A44_SW_BANK64_SOUTH_R8_M6_0/CTRL_085 R8E__A44_SW_BANK64_SOUTH_R8_M6_0/CTRL_096
+ R8E__A44_SW_BANK64_SOUTH_R8_M6_0/CTRL_101 R8E__A44_SW_BANK64_SOUTH_R8_M6_0/CTRL_082
+ R8E__A44_SW_BANK64_SOUTH_R8_M6_0/CTRL_117 R8E__A44_SW_BANK64_SOUTH_R8_M6_0/CTRL_111
+ R8E__A44_SW_BANK64_SOUTH_R8_M6_0/CTRL_071 R8E__A44_SW_BANK64_SOUTH_R8_M6_0/CTRL_098
+ R8E__A44_SW_BANK64_SOUTH_R8_M6_0/CTRL_086 R8E__A44_SW_BANK64_SOUTH_R8_M6_0/CTRL_112
+ R8E__A44_SW_BANK64_SOUTH_R8_M6_0/CTRL_102 R8E__A44_SW_BANK64_SOUTH_R8_M6_0/CTRL_114
+ R8E__A44_SW_BANK64_SOUTH_R8_M6_0/CTRL_118 R8E__A44_SW_BANK64_SOUTH_R8_M6_0/CTRL_075
+ R8E__A44_SW_BANK64_SOUTH_R8_M6_0/CTRL_087 R8E__A44_SW_BANK64_SOUTH_R8_M6_0/CTRL_091
+ R8E__A44_SW_BANK64_SOUTH_R8_M6_0/CTRL_089 R8E__A44_SW_BANK64_SOUTH_R8_M6_0/CTRL_107
+ R8E__A44_SW_BANK64_SOUTH_R8_M6_0/CTRL_088 R8E__A44_SW_BANK64_SOUTH_R8_M6_0/CTRL_123
+ R8E__A44_SW_BANK64_SOUTH_R8_M6_0/CTRL_105 R8E__A44_SW_BANK64_SOUTH_R8_M6_0/CTRL_076
+ R8E__A44_SW_BANK64_SOUTH_R8_M6_0/CTRL_119 R8E__A44_SW_BANK64_SOUTH_R8_M6_0/CTRL_092
+ R8E__A44_SW_BANK64_SOUTH_R8_M6_0/CTRL_121 R8E__A44_SW_BANK64_SOUTH_R8_M6_0/CTRL_108
+ R8E__A44_SW_BANK64_SOUTH_R8_M6_0/CTRL_104 R8E__A44_SW_BANK64_SOUTH_R8_M6_0/CTRL_124
+ R8E__A44_SW_BANK64_SOUTH_R8_M6_0/CTRL_074 R8E__A44_SW_BANK64_SOUTH_R8_M6_0/CTRL_077
+ R8E__A44_SW_BANK64_SOUTH_R8_M6_0/CTRL_103 R8E__A44_SW_BANK64_SOUTH_R8_M6_0/CTRL_093
+ R8E__A44_SW_BANK64_SOUTH_R8_M6_0/CTRL_090 R8E__A44_SW_BANK64_SOUTH_R8_M6_0/CTRL_109
+ R8E__A44_SW_BANK64_SOUTH_R8_M6_0/CTRL_120 R8E__A44_SW_BANK64_SOUTH_R8_M6_0/CTRL_125
+ R8E__A44_SW_BANK64_SOUTH_R8_M6_0/CTRL_106 R8E__A44_SW_BANK64_SOUTH_R8_M6_0/CTRL_078
+ R8E__A44_SW_BANK64_SOUTH_R8_M6_0/CTRL_072 R8E__A44_SW_BANK64_SOUTH_R8_M6_0/CTRL_094
+ R8E__A44_SW_BANK64_SOUTH_R8_M6_0/CTRL_122 R8E__A44_SW_BANK64_SOUTH_R8_M6_0/CTRL_110
+ R8E__A44_SW_BANK64_SOUTH_R8_M6_0/CTRL_073 R8E__A44_SW_BANK64_SOUTH_R8_M6_0/CTRL_126
+ R8E__A44_SW_BANK64_SOUTH_R8_M6_0/VREFN R8E__A44_SW_BANK64_SOUTH_R8_M6_0/VREFP R8E__A44_SW_BANK64_SOUTH_R8_M6_0/VDD
+ VSUBS R8E__A44_SW_BANK64_SOUTH_R8_M6
.ends

.subckt A44_CDAC_UNIT_E_R8_M6 R8E__A44_DCTRL_STRIP_E_R2_0/CTRL_IN[7] R8E__A44_DCTRL_STRIP_E_R2_0/CTRL_IN[1]
+ R8E__A44_DCTRL_STRIP_E_R2_0/VDD R8E__A44_DCTRL_STRIP_E_R2_0/CTRL_IN[6] R8E__A44_DCTRL_STRIP_E_R2_0/CTRL_IN[3]
+ R8E__A44_CDAC_CAP_BANK_ASSEMBLY_R8_M6_0/R8E__A44_SW_BANK64_SOUTH_R8_M6_0/VREFN R8E__A44_DCTRL_STRIP_E_R2_0/CTRL_IN[5]
+ R8E__A44_TG8_SLICE_UDRV_E_R1_0/CLKS R8E__A44_DCTRL_STRIP_E_R2_0/CTRL_IN[2] R8E__A44_DCTRL_STRIP_E_R2_0/CTRL_IN[4]
+ R8E__A44_TG8_SLICE_UDRV_E_R1_0/VOUT R8E__A44_CDAC_CAP_BANK_ASSEMBLY_R8_M6_0/R8E__A44_SW_BANK64_SOUTH_R8_M6_0/VREFP
+ R8E__A44_TG8_SLICE_UDRV_E_R1_0/VIN VSUBS
XR8E__A44_DCTRL_STRIP_E_R2_0 R8E__A44_DCTRL_STRIP_E_R2_0/VDD R8E__A44_DCTRL_STRIP_E_R2_0/CTRL_OUT[1]
+ R8E__A44_DCTRL_STRIP_E_R2_0/CTRL_OUT[2] R8E__A44_DCTRL_STRIP_E_R2_0/CTRL_OUT[3]
+ R8E__A44_DCTRL_STRIP_E_R2_0/CTRL_OUT[4] R8E__A44_DCTRL_STRIP_E_R2_0/CTRL_OUT[5]
+ R8E__A44_DCTRL_STRIP_E_R2_0/CTRL_OUT[6] R8E__A44_DCTRL_STRIP_E_R2_0/CTRL_OUT[7]
+ R8E__A44_DCTRL_STRIP_E_R2_0/CTRL_IN[1] R8E__A44_DCTRL_STRIP_E_R2_0/CTRL_IN[2] R8E__A44_DCTRL_STRIP_E_R2_0/CTRL_IN[3]
+ R8E__A44_DCTRL_STRIP_E_R2_0/CTRL_IN[4] R8E__A44_DCTRL_STRIP_E_R2_0/CTRL_IN[5] R8E__A44_DCTRL_STRIP_E_R2_0/CTRL_IN[6]
+ R8E__A44_DCTRL_STRIP_E_R2_0/CTRL_IN[7] VSUBS R8E__A44_DCTRL_STRIP_E_R2
XR8E__A44_TG8_SLICE_UDRV_E_R1_0 R8E__A44_TG8_SLICE_UDRV_E_R1_0/VOUT R8E__A44_TG8_SLICE_UDRV_E_R1_0/VIN
+ R8E__A44_DCTRL_STRIP_E_R2_0/VDD VSUBS R8E__A44_TG8_SLICE_UDRV_E_R1_0/CLKS R8E__A44_TG8_SLICE_UDRV_E_R1
XR8E__A44_CDAC_CAP_BANK_ASSEMBLY_R8_M6_0 R8E__A44_DCTRL_STRIP_E_R2_0/CTRL_OUT[6] R8E__A44_DCTRL_STRIP_E_R2_0/CTRL_OUT[6]
+ R8E__A44_DCTRL_STRIP_E_R2_0/CTRL_OUT[6] R8E__A44_DCTRL_STRIP_E_R2_0/CTRL_OUT[7]
+ R8E__A44_DCTRL_STRIP_E_R2_0/CTRL_OUT[7] R8E__A44_DCTRL_STRIP_E_R2_0/CTRL_OUT[7]
+ R8E__A44_DCTRL_STRIP_E_R2_0/CTRL_OUT[5] R8E__A44_DCTRL_STRIP_E_R2_0/VDD R8E__A44_DCTRL_STRIP_E_R2_0/CTRL_OUT[3]
+ R8E__A44_DCTRL_STRIP_E_R2_0/CTRL_OUT[4] R8E__A44_DCTRL_STRIP_E_R2_0/CTRL_OUT[7]
+ R8E__A44_DCTRL_STRIP_E_R2_0/CTRL_OUT[7] R8E__A44_DCTRL_STRIP_E_R2_0/CTRL_OUT[7]
+ R8E__A44_DCTRL_STRIP_E_R2_0/CTRL_OUT[7] R8E__A44_DCTRL_STRIP_E_R2_0/CTRL_OUT[5]
+ R8E__A44_DCTRL_STRIP_E_R2_0/CTRL_OUT[4] R8E__A44_DCTRL_STRIP_E_R2_0/CTRL_OUT[4]
+ R8E__A44_DCTRL_STRIP_E_R2_0/CTRL_OUT[6] R8E__A44_DCTRL_STRIP_E_R2_0/CTRL_OUT[6]
+ R8E__A44_DCTRL_STRIP_E_R2_0/CTRL_OUT[7] R8E__A44_DCTRL_STRIP_E_R2_0/CTRL_OUT[7]
+ R8E__A44_DCTRL_STRIP_E_R2_0/CTRL_OUT[6] R8E__A44_DCTRL_STRIP_E_R2_0/CTRL_OUT[6]
+ R8E__A44_DCTRL_STRIP_E_R2_0/CTRL_OUT[7] R8E__A44_DCTRL_STRIP_E_R2_0/CTRL_OUT[7]
+ R8E__A44_DCTRL_STRIP_E_R2_0/CTRL_OUT[7] R8E__A44_DCTRL_STRIP_E_R2_0/CTRL_OUT[5]
+ R8E__A44_DCTRL_STRIP_E_R2_0/CTRL_OUT[7] R8E__A44_DCTRL_STRIP_E_R2_0/CTRL_OUT[6]
+ R8E__A44_DCTRL_STRIP_E_R2_0/CTRL_OUT[5] R8E__A44_DCTRL_STRIP_E_R2_0/CTRL_OUT[7]
+ R8E__A44_DCTRL_STRIP_E_R2_0/CTRL_OUT[7] R8E__A44_CDAC_CAP_BANK_ASSEMBLY_R8_M6_0/R8E__A44_SW_BANK64_SOUTH_R8_M6_0/VREFP
+ R8E__A44_DCTRL_STRIP_E_R2_0/CTRL_OUT[6] R8E__A44_DCTRL_STRIP_E_R2_0/CTRL_OUT[5]
+ R8E__A44_DCTRL_STRIP_E_R2_0/CTRL_OUT[7] R8E__A44_DCTRL_STRIP_E_R2_0/CTRL_OUT[7]
+ R8E__A44_DCTRL_STRIP_E_R2_0/CTRL_OUT[6] R8E__A44_DCTRL_STRIP_E_R2_0/CTRL_OUT[7]
+ R8E__A44_DCTRL_STRIP_E_R2_0/CTRL_OUT[5] R8E__A44_DCTRL_STRIP_E_R2_0/CTRL_OUT[3]
+ R8E__A44_DCTRL_STRIP_E_R2_0/CTRL_OUT[7] R8E__A44_DCTRL_STRIP_E_R2_0/CTRL_OUT[7]
+ R8E__A44_DCTRL_STRIP_E_R2_0/CTRL_OUT[6] R8E__A44_DCTRL_STRIP_E_R2_0/CTRL_OUT[7]
+ R8E__A44_DCTRL_STRIP_E_R2_0/CTRL_OUT[5] R8E__A44_DCTRL_STRIP_E_R2_0/CTRL_OUT[6]
+ R8E__A44_DCTRL_STRIP_E_R2_0/CTRL_OUT[7] R8E__A44_DCTRL_STRIP_E_R2_0/CTRL_OUT[7]
+ R8E__A44_DCTRL_STRIP_E_R2_0/CTRL_OUT[6] R8E__A44_DCTRL_STRIP_E_R2_0/CTRL_OUT[7]
+ R8E__A44_DCTRL_STRIP_E_R2_0/CTRL_OUT[2] R8E__A44_DCTRL_STRIP_E_R2_0/CTRL_OUT[4]
+ R8E__A44_DCTRL_STRIP_E_R2_0/CTRL_OUT[6] R8E__A44_DCTRL_STRIP_E_R2_0/CTRL_OUT[7]
+ R8E__A44_CDAC_CAP_BANK_ASSEMBLY_R8_M6_0/R8E__A44_SW_BANK64_SOUTH_R8_M6_0/VREFN R8E__A44_CDAC_CAP_BANK_ASSEMBLY_R8_M6_0/R8E__A44_SW_BANK64_SOUTH_R8_M6_0/VREFP
+ R8E__A44_DCTRL_STRIP_E_R2_0/CTRL_OUT[5] R8E__A44_DCTRL_STRIP_E_R2_0/CTRL_OUT[7]
+ R8E__A44_DCTRL_STRIP_E_R2_0/CTRL_OUT[7] R8E__A44_CDAC_CAP_BANK_ASSEMBLY_R8_M6_0/R8E__A44_SW_BANK64_SOUTH_R8_M6_0/VREFN
+ R8E__A44_DCTRL_STRIP_E_R2_0/CTRL_OUT[6] R8E__A44_DCTRL_STRIP_E_R2_0/CTRL_OUT[7]
+ R8E__A44_DCTRL_STRIP_E_R2_0/CTRL_OUT[5] R8E__A44_DCTRL_STRIP_E_R2_0/CTRL_OUT[6]
+ R8E__A44_DCTRL_STRIP_E_R2_0/CTRL_OUT[7] R8E__A44_DCTRL_STRIP_E_R2_0/CTRL_OUT[7]
+ R8E__A44_DCTRL_STRIP_E_R2_0/CTRL_OUT[7] R8E__A44_DCTRL_STRIP_E_R2_0/CTRL_OUT[7]
+ R8E__A44_DCTRL_STRIP_E_R2_0/CTRL_OUT[4] R8E__A44_DCTRL_STRIP_E_R2_0/CTRL_OUT[6]
+ R8E__A44_DCTRL_STRIP_E_R2_0/CTRL_OUT[6] R8E__A44_DCTRL_STRIP_E_R2_0/CTRL_OUT[6]
+ R8E__A44_DCTRL_STRIP_E_R2_0/CTRL_OUT[7] R8E__A44_DCTRL_STRIP_E_R2_0/CTRL_OUT[7]
+ R8E__A44_DCTRL_STRIP_E_R2_0/CTRL_OUT[5] R8E__A44_DCTRL_STRIP_E_R2_0/CTRL_OUT[6]
+ R8E__A44_DCTRL_STRIP_E_R2_0/CTRL_OUT[7] R8E__A44_DCTRL_STRIP_E_R2_0/CTRL_OUT[7]
+ R8E__A44_DCTRL_STRIP_E_R2_0/CTRL_OUT[7] R8E__A44_DCTRL_STRIP_E_R2_0/CTRL_OUT[7]
+ R8E__A44_DCTRL_STRIP_E_R2_0/CTRL_OUT[7] R8E__A44_DCTRL_STRIP_E_R2_0/CTRL_OUT[7]
+ R8E__A44_DCTRL_STRIP_E_R2_0/CTRL_OUT[5] R8E__A44_DCTRL_STRIP_E_R2_0/CTRL_OUT[2]
+ R8E__A44_DCTRL_STRIP_E_R2_0/CTRL_OUT[6] R8E__A44_DCTRL_STRIP_E_R2_0/VDD R8E__A44_DCTRL_STRIP_E_R2_0/CTRL_OUT[7]
+ R8E__A44_DCTRL_STRIP_E_R2_0/CTRL_OUT[7] R8E__A44_DCTRL_STRIP_E_R2_0/CTRL_OUT[7]
+ R8E__A44_DCTRL_STRIP_E_R2_0/CTRL_OUT[7] R8E__A44_DCTRL_STRIP_E_R2_0/CTRL_OUT[5]
+ R8E__A44_DCTRL_STRIP_E_R2_0/CTRL_OUT[6] R8E__A44_DCTRL_STRIP_E_R2_0/CTRL_OUT[6]
+ R8E__A44_DCTRL_STRIP_E_R2_0/CTRL_OUT[6] R8E__A44_DCTRL_STRIP_E_R2_0/CTRL_OUT[7]
+ R8E__A44_DCTRL_STRIP_E_R2_0/CTRL_OUT[6] R8E__A44_DCTRL_STRIP_E_R2_0/CTRL_OUT[6]
+ R8E__A44_DCTRL_STRIP_E_R2_0/CTRL_OUT[6] R8E__A44_DCTRL_STRIP_E_R2_0/CTRL_OUT[6]
+ R8E__A44_DCTRL_STRIP_E_R2_0/CTRL_OUT[7] R8E__A44_DCTRL_STRIP_E_R2_0/CTRL_OUT[7]
+ R8E__A44_DCTRL_STRIP_E_R2_0/CTRL_OUT[7] R8E__A44_DCTRL_STRIP_E_R2_0/CTRL_OUT[7]
+ R8E__A44_DCTRL_STRIP_E_R2_0/CTRL_OUT[7] R8E__A44_DCTRL_STRIP_E_R2_0/CTRL_OUT[5]
+ R8E__A44_DCTRL_STRIP_E_R2_0/CTRL_OUT[3] R8E__A44_DCTRL_STRIP_E_R2_0/CTRL_OUT[4]
+ R8E__A44_DCTRL_STRIP_E_R2_0/CTRL_OUT[4] R8E__A44_DCTRL_STRIP_E_R2_0/CTRL_OUT[6]
+ R8E__A44_DCTRL_STRIP_E_R2_0/CTRL_OUT[7] R8E__A44_DCTRL_STRIP_E_R2_0/CTRL_OUT[7]
+ R8E__A44_DCTRL_STRIP_E_R2_0/CTRL_OUT[7] R8E__A44_DCTRL_STRIP_E_R2_0/CTRL_OUT[7]
+ R8E__A44_DCTRL_STRIP_E_R2_0/CTRL_OUT[7] R8E__A44_DCTRL_STRIP_E_R2_0/CTRL_OUT[5]
+ R8E__A44_DCTRL_STRIP_E_R2_0/CTRL_OUT[1] R8E__A44_DCTRL_STRIP_E_R2_0/CTRL_OUT[3]
+ R8E__A44_DCTRL_STRIP_E_R2_0/CTRL_OUT[4] R8E__A44_DCTRL_STRIP_E_R2_0/CTRL_OUT[6]
+ R8E__A44_DCTRL_STRIP_E_R2_0/CTRL_OUT[7] R8E__A44_DCTRL_STRIP_E_R2_0/CTRL_OUT[7]
+ R8E__A44_DCTRL_STRIP_E_R2_0/CTRL_OUT[7] R8E__A44_DCTRL_STRIP_E_R2_0/CTRL_OUT[7]
+ R8E__A44_DCTRL_STRIP_E_R2_0/CTRL_OUT[5] VSUBS R8E__A44_DCTRL_STRIP_E_R2_0/CTRL_OUT[6]
+ R8E__A44_DCTRL_STRIP_E_R2_0/CTRL_OUT[6] R8E__A44_DCTRL_STRIP_E_R2_0/CTRL_OUT[7]
+ R8E__A44_DCTRL_STRIP_E_R2_0/CTRL_OUT[7] R8E__A44_DCTRL_STRIP_E_R2_0/CTRL_OUT[7]
+ R8E__A44_DCTRL_STRIP_E_R2_0/CTRL_OUT[7] R8E__A44_DCTRL_STRIP_E_R2_0/CTRL_OUT[7]
+ R8E__A44_DCTRL_STRIP_E_R2_0/CTRL_OUT[5] R8E__A44_TG8_SLICE_UDRV_E_R1_0/VOUT R8E__A44_CDAC_CAP_BANK_ASSEMBLY_R8_M6
.ends

.subckt A44_CDAC_UNIT_E_R7 A44_CDAC_UNIT_E_R8_M6_0/R8E__A44_DCTRL_STRIP_E_R2_0/VDD
+ A44_CDAC_UNIT_E_R8_M6_0/R8E__A44_DCTRL_STRIP_E_R2_0/CTRL_IN[7] A44_CDAC_UNIT_E_R8_M6_0/R8E__A44_TG8_SLICE_UDRV_E_R1_0/VOUT
+ A44_CDAC_UNIT_E_R8_M6_0/R8E__A44_DCTRL_STRIP_E_R2_0/CTRL_IN[1] A44_CDAC_UNIT_E_R8_M6_0/R8E__A44_DCTRL_STRIP_E_R2_0/CTRL_IN[6]
+ A44_CDAC_UNIT_E_R8_M6_0/R8E__A44_DCTRL_STRIP_E_R2_0/CTRL_IN[3] A44_CDAC_UNIT_E_R8_M6_0/R8E__A44_DCTRL_STRIP_E_R2_0/CTRL_IN[5]
+ A44_CDAC_UNIT_E_R8_M6_0/R8E__A44_CDAC_CAP_BANK_ASSEMBLY_R8_M6_0/R8E__A44_SW_BANK64_SOUTH_R8_M6_0/VREFP
+ A44_CDAC_UNIT_E_R8_M6_0/R8E__A44_DCTRL_STRIP_E_R2_0/CTRL_IN[2] A44_CDAC_UNIT_E_R8_M6_0/R8E__A44_DCTRL_STRIP_E_R2_0/CTRL_IN[4]
+ A44_CDAC_UNIT_E_R8_M6_0/R8E__A44_TG8_SLICE_UDRV_E_R1_0/CLKS A44_CDAC_UNIT_E_R8_M6_0/R8E__A44_CDAC_CAP_BANK_ASSEMBLY_R8_M6_0/R8E__A44_SW_BANK64_SOUTH_R8_M6_0/VREFN
+ A44_CDAC_UNIT_E_R8_M6_0/R8E__A44_TG8_SLICE_UDRV_E_R1_0/VIN VSUBS
XA44_CDAC_UNIT_E_R8_M6_0 A44_CDAC_UNIT_E_R8_M6_0/R8E__A44_DCTRL_STRIP_E_R2_0/CTRL_IN[7]
+ A44_CDAC_UNIT_E_R8_M6_0/R8E__A44_DCTRL_STRIP_E_R2_0/CTRL_IN[1] A44_CDAC_UNIT_E_R8_M6_0/R8E__A44_DCTRL_STRIP_E_R2_0/VDD
+ A44_CDAC_UNIT_E_R8_M6_0/R8E__A44_DCTRL_STRIP_E_R2_0/CTRL_IN[6] A44_CDAC_UNIT_E_R8_M6_0/R8E__A44_DCTRL_STRIP_E_R2_0/CTRL_IN[3]
+ A44_CDAC_UNIT_E_R8_M6_0/R8E__A44_CDAC_CAP_BANK_ASSEMBLY_R8_M6_0/R8E__A44_SW_BANK64_SOUTH_R8_M6_0/VREFN
+ A44_CDAC_UNIT_E_R8_M6_0/R8E__A44_DCTRL_STRIP_E_R2_0/CTRL_IN[5] A44_CDAC_UNIT_E_R8_M6_0/R8E__A44_TG8_SLICE_UDRV_E_R1_0/CLKS
+ A44_CDAC_UNIT_E_R8_M6_0/R8E__A44_DCTRL_STRIP_E_R2_0/CTRL_IN[2] A44_CDAC_UNIT_E_R8_M6_0/R8E__A44_DCTRL_STRIP_E_R2_0/CTRL_IN[4]
+ A44_CDAC_UNIT_E_R8_M6_0/R8E__A44_TG8_SLICE_UDRV_E_R1_0/VOUT A44_CDAC_UNIT_E_R8_M6_0/R8E__A44_CDAC_CAP_BANK_ASSEMBLY_R8_M6_0/R8E__A44_SW_BANK64_SOUTH_R8_M6_0/VREFP
+ A44_CDAC_UNIT_E_R8_M6_0/R8E__A44_TG8_SLICE_UDRV_E_R1_0/VIN VSUBS A44_CDAC_UNIT_E_R8_M6
.ends

.subckt R8W__pfet_03v3_XNC3G5 a_n148_n1230# a_n148_n2318# a_n148_946# a_n148_1490#
+ a_28_n156# a_n148_n142# a_28_n700# a_28_n2332# a_28_2020# a_n36_n1880# w_n234_n2510#
+ a_28_n1788# a_n36_n1336# a_n148_402# a_28_1476# a_n148_n1774# a_n148_2034# a_n36_1928#
+ a_n148_n686# a_n36_n792# a_28_388# a_n36_296# a_28_932# a_n36_n2424# a_n36_n248#
+ a_n36_1384# a_28_n1244# a_n36_840#
X0 a_28_2020# a_n36_1928# a_n148_2034# w_n234_n2510# pfet_03v3 ad=0.9269p pd=4.32u as=0.9269p ps=4.32u w=1.56u l=0.28u
X1 a_28_n1244# a_n36_n1336# a_n148_n1230# w_n234_n2510# pfet_03v3 ad=0.9269p pd=4.32u as=0.9269p ps=4.32u w=1.56u l=0.28u
X2 a_28_932# a_n36_840# a_n148_946# w_n234_n2510# pfet_03v3 ad=0.9269p pd=4.32u as=0.9269p ps=4.32u w=1.56u l=0.28u
X3 a_28_n700# a_n36_n792# a_n148_n686# w_n234_n2510# pfet_03v3 ad=0.9269p pd=4.32u as=0.9269p ps=4.32u w=1.56u l=0.28u
X4 a_28_1476# a_n36_1384# a_n148_1490# w_n234_n2510# pfet_03v3 ad=0.9269p pd=4.32u as=0.9269p ps=4.32u w=1.56u l=0.28u
X5 a_28_n2332# a_n36_n2424# a_n148_n2318# w_n234_n2510# pfet_03v3 ad=0.9269p pd=4.32u as=0.9269p ps=4.32u w=1.56u l=0.28u
X6 a_28_388# a_n36_296# a_n148_402# w_n234_n2510# pfet_03v3 ad=0.9269p pd=4.32u as=0.9269p ps=4.32u w=1.56u l=0.28u
X7 a_28_n1788# a_n36_n1880# a_n148_n1774# w_n234_n2510# pfet_03v3 ad=0.9269p pd=4.32u as=0.9269p ps=4.32u w=1.56u l=0.28u
X8 a_28_n156# a_n36_n248# a_n148_n142# w_n234_n2510# pfet_03v3 ad=0.9269p pd=4.32u as=0.9269p ps=4.32u w=1.56u l=0.28u
.ends

.subckt R8W__A44_G6_PFET_M9_GUARD0_R0 M9_R0/a_n36_n792# M9_R0/a_28_932# M9_R0/a_n148_1490#
+ M9_R0/a_28_n700# M9_R0/a_n148_n1774# M9_R0/a_28_2020# M9_R0/a_n148_n142# M9_R0/a_n36_n248#
+ M9_R0/a_n36_1384# M9_R0/a_28_n1244# M9_R0/a_28_1476# M9_R0/a_n36_n1880# M9_R0/a_n148_946#
+ M9_R0/a_n148_n1230# M9_R0/a_n36_n1336# M9_R0/a_28_n2332# M9_R0/a_n148_2034# M9_R0/a_n148_n2318#
+ M9_R0/a_n36_296# M9_R0/a_n148_n686# M9_R0/a_n36_840# M9_R0/a_28_n1788# M9_R0/a_n148_402#
+ M9_R0/a_n36_n2424# M9_R0/w_n234_n2510# M9_R0/a_n36_1928# M9_R0/a_28_388# M9_R0/a_28_n156#
XM9_R0 M9_R0/a_n148_n1230# M9_R0/a_n148_n2318# M9_R0/a_n148_946# M9_R0/a_n148_1490#
+ M9_R0/a_28_n156# M9_R0/a_n148_n142# M9_R0/a_28_n700# M9_R0/a_28_n2332# M9_R0/a_28_2020#
+ M9_R0/a_n36_n1880# M9_R0/w_n234_n2510# M9_R0/a_28_n1788# M9_R0/a_n36_n1336# M9_R0/a_n148_402#
+ M9_R0/a_28_1476# M9_R0/a_n148_n1774# M9_R0/a_n148_2034# M9_R0/a_n36_1928# M9_R0/a_n148_n686#
+ M9_R0/a_n36_n792# M9_R0/a_28_388# M9_R0/a_n36_296# M9_R0/a_28_932# M9_R0/a_n36_n2424#
+ M9_R0/a_n36_n248# M9_R0/a_n36_1384# M9_R0/a_28_n1244# M9_R0/a_n36_840# R8W__pfet_03v3_XNC3G5
.ends

.subckt R8W__nfet_03v3_ATEY9D a_28_812# a_28_1308# a_n36_2136# a_28_1804# a_n148_826#
+ a_n148_n166# a_n36_1144# a_n36_n344# a_n148_330# a_n36_n1336# a_28_n676# a_n148_n662#
+ a_n36_1640# a_n148_1818# a_28_n2164# a_n148_n1158# a_n36_n840# a_28_n180# a_n148_n2150#
+ a_n36_n1832# a_n148_1322# a_28_n1668# a_n148_n1654# a_28_n1172# a_n36_648# a_n36_152#
+ a_28_316# VSUBS
X0 a_28_316# a_n36_648# a_n148_330# VSUBS nfet_03v3 ad=0.9269p pd=4.32u as=0.9269p ps=4.32u w=1.56u l=0.28u
X1 a_28_812# a_n36_1144# a_n148_826# VSUBS nfet_03v3 ad=0.9269p pd=4.32u as=0.9269p ps=4.32u w=1.56u l=0.28u
X2 a_28_n180# a_n36_152# a_n148_n166# VSUBS nfet_03v3 ad=0.9269p pd=4.32u as=0.9269p ps=4.32u w=1.56u l=0.28u
X3 a_28_1308# a_n36_1640# a_n148_1322# VSUBS nfet_03v3 ad=0.9269p pd=4.32u as=0.9269p ps=4.32u w=1.56u l=0.28u
X4 a_28_n676# a_n36_n344# a_n148_n662# VSUBS nfet_03v3 ad=0.9269p pd=4.32u as=0.9269p ps=4.32u w=1.56u l=0.28u
X5 a_28_n1668# a_n36_n1336# a_n148_n1654# VSUBS nfet_03v3 ad=0.9269p pd=4.32u as=0.9269p ps=4.32u w=1.56u l=0.28u
X6 a_28_1804# a_n36_2136# a_n148_1818# VSUBS nfet_03v3 ad=0.9269p pd=4.32u as=0.9269p ps=4.32u w=1.56u l=0.28u
X7 a_28_n2164# a_n36_n1832# a_n148_n2150# VSUBS nfet_03v3 ad=0.9269p pd=4.32u as=0.9269p ps=4.32u w=1.56u l=0.28u
X8 a_28_n1172# a_n36_n840# a_n148_n1158# VSUBS nfet_03v3 ad=0.9269p pd=4.32u as=0.9269p ps=4.32u w=1.56u l=0.28u
.ends

.subckt R8W__A44_G6_NFET_M9_GUARD0_R0 M9_R0/a_28_n1668# M9_R0/a_28_316# M9_R0/a_28_n1172#
+ M9_R0/a_28_1804# M9_R0/a_n148_n1158# M9_R0/a_n148_n2150# M9_R0/a_28_812# M9_R0/a_n148_n166#
+ M9_R0/a_n148_n1654# M9_R0/a_28_n676# M9_R0/a_28_n180# M9_R0/a_n36_n1336# M9_R0/a_n36_2136#
+ M9_R0/a_n148_n662# M9_R0/a_n148_1818# M9_R0/a_n148_826# M9_R0/a_n148_1322# M9_R0/a_n36_1144#
+ M9_R0/a_n36_648# M9_R0/a_n148_330# M9_R0/a_n36_n1832# M9_R0/a_n36_152# M9_R0/a_n36_n344#
+ M9_R0/a_n36_1640# M9_R0/a_28_n2164# M9_R0/a_28_1308# M9_R0/a_n36_n840# VSUBS
XM9_R0 M9_R0/a_28_812# M9_R0/a_28_1308# M9_R0/a_n36_2136# M9_R0/a_28_1804# M9_R0/a_n148_826#
+ M9_R0/a_n148_n166# M9_R0/a_n36_1144# M9_R0/a_n36_n344# M9_R0/a_n148_330# M9_R0/a_n36_n1336#
+ M9_R0/a_28_n676# M9_R0/a_n148_n662# M9_R0/a_n36_1640# M9_R0/a_n148_1818# M9_R0/a_28_n2164#
+ M9_R0/a_n148_n1158# M9_R0/a_n36_n840# M9_R0/a_28_n180# M9_R0/a_n148_n2150# M9_R0/a_n36_n1832#
+ M9_R0/a_n148_1322# M9_R0/a_28_n1668# M9_R0/a_n148_n1654# M9_R0/a_28_n1172# M9_R0/a_n36_648#
+ M9_R0/a_n36_152# M9_R0/a_28_316# VSUBS R8W__nfet_03v3_ATEY9D
.ends

.subckt R8W__A44_CAP_SWITCH_BANK_CORE_O2 VREFP VREFN CTRL CAP_BOTTOM VDD GND
XP0 CTRL VREFP CAP_BOTTOM VREFP CAP_BOTTOM VREFP CAP_BOTTOM CTRL CTRL VREFP VREFP
+ CTRL CAP_BOTTOM CAP_BOTTOM CTRL VREFP CAP_BOTTOM CAP_BOTTOM CTRL CAP_BOTTOM CTRL
+ VREFP CAP_BOTTOM CTRL VDD CTRL VREFP VREFP R8W__A44_G6_PFET_M9_GUARD0_R0
XP1 CTRL VREFP CAP_BOTTOM VREFP CAP_BOTTOM VREFP CAP_BOTTOM CTRL CTRL VREFP VREFP
+ CTRL CAP_BOTTOM CAP_BOTTOM CTRL VREFP CAP_BOTTOM CAP_BOTTOM CTRL CAP_BOTTOM CTRL
+ VREFP CAP_BOTTOM CTRL VDD CTRL VREFP VREFP R8W__A44_G6_PFET_M9_GUARD0_R0
XN0 VREFN VREFN VREFN VREFN CAP_BOTTOM CAP_BOTTOM VREFN CAP_BOTTOM CAP_BOTTOM VREFN
+ VREFN CTRL CTRL CAP_BOTTOM CAP_BOTTOM CAP_BOTTOM CAP_BOTTOM CTRL CTRL CAP_BOTTOM
+ CTRL CTRL CTRL CTRL VREFN VREFN CTRL GND R8W__A44_G6_NFET_M9_GUARD0_R0
XN1 VREFN VREFN VREFN VREFN CAP_BOTTOM CAP_BOTTOM VREFN CAP_BOTTOM CAP_BOTTOM VREFN
+ VREFN CTRL CTRL CAP_BOTTOM CAP_BOTTOM CAP_BOTTOM CAP_BOTTOM CTRL CTRL CAP_BOTTOM
+ CTRL CTRL CTRL CTRL VREFN VREFN CTRL GND R8W__A44_G6_NFET_M9_GUARD0_R0
.ends

.subckt R8W__A44_SW_BANK64_NORTH_R8_M6 CTRL_008 CTRL_024 CTRL_040 CTRL_056 CTRL_009
+ CTRL_025 CTRL_041 CTRL_057 CTRL_010 CTRL_026 CTRL_042 CTRL_058 CTRL_011 CTRL_027
+ CTRL_043 CTRL_059 CTRL_012 CTRL_028 CTRL_044 CTRL_060 CTRL_013 CTRL_029 CTRL_045
+ CTRL_061 CTRL_014 CTRL_030 CTRL_046 CTRL_062 CTRL_015 CTRL_031 CTRL_047 CTRL_063
+ CTRL_000 CTRL_016 CTRL_032 CTRL_048 CTRL_001 CTRL_017 CTRL_033 CTRL_049 CTRL_002
+ CTRL_018 CTRL_034 CTRL_050 CTRL_003 CTRL_019 CTRL_035 CTRL_051 CTRL_004 CTRL_020
+ CTRL_036 CTRL_052 CTRL_005 CTRL_021 CTRL_037 CTRL_053 CTRL_006 CTRL_022 CTRL_038
+ CTRL_054 CTRL_007 CTRL_023 CTRL_039 CTRL_055 CAP_BOTTOM_004 CAP_BOTTOM_002 CAP_BOTTOM_020
+ CAP_BOTTOM_001 CAP_BOTTOM_036 CAP_BOTTOM_018 CAP_BOTTOM_052 CAP_BOTTOM_032 CAP_BOTTOM_005
+ CAP_BOTTOM_034 CAP_BOTTOM_021 CAP_BOTTOM_017 CAP_BOTTOM_037 CAP_BOTTOM_050 CAP_BOTTOM_053
+ CAP_BOTTOM_016 CAP_BOTTOM_006 CAP_BOTTOM_003 CAP_BOTTOM_022 CAP_BOTTOM_033 CAP_BOTTOM_038
+ CAP_BOTTOM_019 CAP_BOTTOM_054 CAP_BOTTOM_048 CAP_BOTTOM_007 CAP_BOTTOM_035 CAP_BOTTOM_023
+ CAP_BOTTOM_049 CAP_BOTTOM_039 CAP_BOTTOM_051 CAP_BOTTOM_000 CAP_BOTTOM_012 CAP_BOTTOM_010
+ CAP_BOTTOM_028 CAP_BOTTOM_009 CAP_BOTTOM_044 CAP_BOTTOM_026 CAP_BOTTOM_060 CAP_BOTTOM_040
+ CAP_BOTTOM_013 CAP_BOTTOM_042 CAP_BOTTOM_025 CAP_BOTTOM_045 CAP_BOTTOM_058 CAP_BOTTOM_061
+ CAP_BOTTOM_024 CAP_BOTTOM_014 CAP_BOTTOM_011 CAP_BOTTOM_030 CAP_BOTTOM_041 CAP_BOTTOM_046
+ CAP_BOTTOM_027 CAP_BOTTOM_062 CAP_BOTTOM_056 CAP_BOTTOM_015 CAP_BOTTOM_043 CAP_BOTTOM_031
+ CAP_BOTTOM_057 CAP_BOTTOM_047 CAP_BOTTOM_059 CAP_BOTTOM_063 CAP_BOTTOM_008 VREFN
+ VREFP VDD CAP_BOTTOM_055 CAP_BOTTOM_029 GND
XR8W__A44_CAP_SWITCH_BANK_CORE_O2_61 VREFP VREFN CTRL_040 CAP_BOTTOM_040 VDD GND R8W__A44_CAP_SWITCH_BANK_CORE_O2
XR8W__A44_CAP_SWITCH_BANK_CORE_O2_50 VREFP VREFN CTRL_027 CAP_BOTTOM_027 VDD GND R8W__A44_CAP_SWITCH_BANK_CORE_O2
XR8W__A44_CAP_SWITCH_BANK_CORE_O2_51 VREFP VREFN CTRL_011 CAP_BOTTOM_011 VDD GND R8W__A44_CAP_SWITCH_BANK_CORE_O2
XR8W__A44_CAP_SWITCH_BANK_CORE_O2_40 VREFP VREFN CTRL_061 CAP_BOTTOM_061 VDD GND R8W__A44_CAP_SWITCH_BANK_CORE_O2
XR8W__A44_CAP_SWITCH_BANK_CORE_O2_62 VREFP VREFN CTRL_024 CAP_BOTTOM_024 VDD GND R8W__A44_CAP_SWITCH_BANK_CORE_O2
XR8W__A44_CAP_SWITCH_BANK_CORE_O2_41 VREFP VREFN CTRL_045 CAP_BOTTOM_045 VDD GND R8W__A44_CAP_SWITCH_BANK_CORE_O2
XR8W__A44_CAP_SWITCH_BANK_CORE_O2_63 VREFP VREFN CTRL_012 CAP_BOTTOM_012 VDD GND R8W__A44_CAP_SWITCH_BANK_CORE_O2
XR8W__A44_CAP_SWITCH_BANK_CORE_O2_52 VREFP VREFN CTRL_058 CAP_BOTTOM_058 VDD GND R8W__A44_CAP_SWITCH_BANK_CORE_O2
XR8W__A44_CAP_SWITCH_BANK_CORE_O2_30 VREFP VREFN CTRL_016 CAP_BOTTOM_016 VDD GND R8W__A44_CAP_SWITCH_BANK_CORE_O2
XR8W__A44_CAP_SWITCH_BANK_CORE_O2_53 VREFP VREFN CTRL_042 CAP_BOTTOM_042 VDD GND R8W__A44_CAP_SWITCH_BANK_CORE_O2
XR8W__A44_CAP_SWITCH_BANK_CORE_O2_31 VREFP VREFN CTRL_004 CAP_BOTTOM_004 VDD GND R8W__A44_CAP_SWITCH_BANK_CORE_O2
XR8W__A44_CAP_SWITCH_BANK_CORE_O2_42 VREFP VREFN CTRL_029 CAP_BOTTOM_029 VDD GND R8W__A44_CAP_SWITCH_BANK_CORE_O2
XR8W__A44_CAP_SWITCH_BANK_CORE_O2_20 VREFP VREFN CTRL_050 CAP_BOTTOM_050 VDD GND R8W__A44_CAP_SWITCH_BANK_CORE_O2
XR8W__A44_CAP_SWITCH_BANK_CORE_O2_43 VREFP VREFN CTRL_013 CAP_BOTTOM_013 VDD GND R8W__A44_CAP_SWITCH_BANK_CORE_O2
XR8W__A44_CAP_SWITCH_BANK_CORE_O2_21 VREFP VREFN CTRL_034 CAP_BOTTOM_034 VDD GND R8W__A44_CAP_SWITCH_BANK_CORE_O2
XR8W__A44_CAP_SWITCH_BANK_CORE_O2_32 VREFP VREFN CTRL_063 CAP_BOTTOM_063 VDD GND R8W__A44_CAP_SWITCH_BANK_CORE_O2
XR8W__A44_CAP_SWITCH_BANK_CORE_O2_54 VREFP VREFN CTRL_026 CAP_BOTTOM_026 VDD GND R8W__A44_CAP_SWITCH_BANK_CORE_O2
XR8W__A44_CAP_SWITCH_BANK_CORE_O2_10 VREFP VREFN CTRL_021 CAP_BOTTOM_021 VDD GND R8W__A44_CAP_SWITCH_BANK_CORE_O2
XR8W__A44_CAP_SWITCH_BANK_CORE_O2_33 VREFP VREFN CTRL_047 CAP_BOTTOM_047 VDD GND R8W__A44_CAP_SWITCH_BANK_CORE_O2
XR8W__A44_CAP_SWITCH_BANK_CORE_O2_55 VREFP VREFN CTRL_010 CAP_BOTTOM_010 VDD GND R8W__A44_CAP_SWITCH_BANK_CORE_O2
XR8W__A44_CAP_SWITCH_BANK_CORE_O2_11 VREFP VREFN CTRL_005 CAP_BOTTOM_005 VDD GND R8W__A44_CAP_SWITCH_BANK_CORE_O2
XR8W__A44_CAP_SWITCH_BANK_CORE_O2_44 VREFP VREFN CTRL_060 CAP_BOTTOM_060 VDD GND R8W__A44_CAP_SWITCH_BANK_CORE_O2
XR8W__A44_CAP_SWITCH_BANK_CORE_O2_22 VREFP VREFN CTRL_018 CAP_BOTTOM_018 VDD GND R8W__A44_CAP_SWITCH_BANK_CORE_O2
XR8W__A44_CAP_SWITCH_BANK_CORE_O2_45 VREFP VREFN CTRL_044 CAP_BOTTOM_044 VDD GND R8W__A44_CAP_SWITCH_BANK_CORE_O2
XR8W__A44_CAP_SWITCH_BANK_CORE_O2_23 VREFP VREFN CTRL_002 CAP_BOTTOM_002 VDD GND R8W__A44_CAP_SWITCH_BANK_CORE_O2
XR8W__A44_CAP_SWITCH_BANK_CORE_O2_34 VREFP VREFN CTRL_031 CAP_BOTTOM_031 VDD GND R8W__A44_CAP_SWITCH_BANK_CORE_O2
XR8W__A44_CAP_SWITCH_BANK_CORE_O2_56 VREFP VREFN CTRL_057 CAP_BOTTOM_057 VDD GND R8W__A44_CAP_SWITCH_BANK_CORE_O2
XR8W__A44_CAP_SWITCH_BANK_CORE_O2_12 VREFP VREFN CTRL_052 CAP_BOTTOM_052 VDD GND R8W__A44_CAP_SWITCH_BANK_CORE_O2
XR8W__A44_CAP_SWITCH_BANK_CORE_O2_35 VREFP VREFN CTRL_015 CAP_BOTTOM_015 VDD GND R8W__A44_CAP_SWITCH_BANK_CORE_O2
XR8W__A44_CAP_SWITCH_BANK_CORE_O2_57 VREFP VREFN CTRL_041 CAP_BOTTOM_041 VDD GND R8W__A44_CAP_SWITCH_BANK_CORE_O2
XR8W__A44_CAP_SWITCH_BANK_CORE_O2_47 VREFP VREFN CTRL_008 CAP_BOTTOM_008 VDD GND R8W__A44_CAP_SWITCH_BANK_CORE_O2
XR8W__A44_CAP_SWITCH_BANK_CORE_O2_13 VREFP VREFN CTRL_036 CAP_BOTTOM_036 VDD GND R8W__A44_CAP_SWITCH_BANK_CORE_O2
XR8W__A44_CAP_SWITCH_BANK_CORE_O2_25 VREFP VREFN CTRL_033 CAP_BOTTOM_033 VDD GND R8W__A44_CAP_SWITCH_BANK_CORE_O2
XR8W__A44_CAP_SWITCH_BANK_CORE_O2_36 VREFP VREFN CTRL_062 CAP_BOTTOM_062 VDD GND R8W__A44_CAP_SWITCH_BANK_CORE_O2
XR8W__A44_CAP_SWITCH_BANK_CORE_O2_46 VREFP VREFN CTRL_028 CAP_BOTTOM_028 VDD GND R8W__A44_CAP_SWITCH_BANK_CORE_O2
XR8W__A44_CAP_SWITCH_BANK_CORE_O2_58 VREFP VREFN CTRL_025 CAP_BOTTOM_025 VDD GND R8W__A44_CAP_SWITCH_BANK_CORE_O2
XR8W__A44_CAP_SWITCH_BANK_CORE_O2_14 VREFP VREFN CTRL_020 CAP_BOTTOM_020 VDD GND R8W__A44_CAP_SWITCH_BANK_CORE_O2
XR8W__A44_CAP_SWITCH_BANK_CORE_O2_24 VREFP VREFN CTRL_049 CAP_BOTTOM_049 VDD GND R8W__A44_CAP_SWITCH_BANK_CORE_O2
XR8W__A44_CAP_SWITCH_BANK_CORE_O2_37 VREFP VREFN CTRL_046 CAP_BOTTOM_046 VDD GND R8W__A44_CAP_SWITCH_BANK_CORE_O2
XR8W__A44_CAP_SWITCH_BANK_CORE_O2_59 VREFP VREFN CTRL_009 CAP_BOTTOM_009 VDD GND R8W__A44_CAP_SWITCH_BANK_CORE_O2
XR8W__A44_CAP_SWITCH_BANK_CORE_O2_15 VREFP VREFN CTRL_000 CAP_BOTTOM_000 VDD GND R8W__A44_CAP_SWITCH_BANK_CORE_O2
XR8W__A44_CAP_SWITCH_BANK_CORE_O2_48 VREFP VREFN CTRL_059 CAP_BOTTOM_059 VDD GND R8W__A44_CAP_SWITCH_BANK_CORE_O2
XR8W__A44_CAP_SWITCH_BANK_CORE_O2_26 VREFP VREFN CTRL_017 CAP_BOTTOM_017 VDD GND R8W__A44_CAP_SWITCH_BANK_CORE_O2
XR8W__A44_CAP_SWITCH_BANK_CORE_O2_49 VREFP VREFN CTRL_043 CAP_BOTTOM_043 VDD GND R8W__A44_CAP_SWITCH_BANK_CORE_O2
XR8W__A44_CAP_SWITCH_BANK_CORE_O2_27 VREFP VREFN CTRL_001 CAP_BOTTOM_001 VDD GND R8W__A44_CAP_SWITCH_BANK_CORE_O2
XR8W__A44_CAP_SWITCH_BANK_CORE_O2_38 VREFP VREFN CTRL_030 CAP_BOTTOM_030 VDD GND R8W__A44_CAP_SWITCH_BANK_CORE_O2
XR8W__A44_CAP_SWITCH_BANK_CORE_O2_0 VREFP VREFN CTRL_055 CAP_BOTTOM_055 VDD GND R8W__A44_CAP_SWITCH_BANK_CORE_O2
XR8W__A44_CAP_SWITCH_BANK_CORE_O2_16 VREFP VREFN CTRL_051 CAP_BOTTOM_051 VDD GND R8W__A44_CAP_SWITCH_BANK_CORE_O2
XR8W__A44_CAP_SWITCH_BANK_CORE_O2_39 VREFP VREFN CTRL_014 CAP_BOTTOM_014 VDD GND R8W__A44_CAP_SWITCH_BANK_CORE_O2
XR8W__A44_CAP_SWITCH_BANK_CORE_O2_1 VREFP VREFN CTRL_039 CAP_BOTTOM_039 VDD GND R8W__A44_CAP_SWITCH_BANK_CORE_O2
XR8W__A44_CAP_SWITCH_BANK_CORE_O2_17 VREFP VREFN CTRL_035 CAP_BOTTOM_035 VDD GND R8W__A44_CAP_SWITCH_BANK_CORE_O2
XR8W__A44_CAP_SWITCH_BANK_CORE_O2_28 VREFP VREFN CTRL_048 CAP_BOTTOM_048 VDD GND R8W__A44_CAP_SWITCH_BANK_CORE_O2
XR8W__A44_CAP_SWITCH_BANK_CORE_O2_29 VREFP VREFN CTRL_032 CAP_BOTTOM_032 VDD GND R8W__A44_CAP_SWITCH_BANK_CORE_O2
XR8W__A44_CAP_SWITCH_BANK_CORE_O2_2 VREFP VREFN CTRL_023 CAP_BOTTOM_023 VDD GND R8W__A44_CAP_SWITCH_BANK_CORE_O2
XR8W__A44_CAP_SWITCH_BANK_CORE_O2_18 VREFP VREFN CTRL_019 CAP_BOTTOM_019 VDD GND R8W__A44_CAP_SWITCH_BANK_CORE_O2
XR8W__A44_CAP_SWITCH_BANK_CORE_O2_3 VREFP VREFN CTRL_007 CAP_BOTTOM_007 VDD GND R8W__A44_CAP_SWITCH_BANK_CORE_O2
XR8W__A44_CAP_SWITCH_BANK_CORE_O2_19 VREFP VREFN CTRL_003 CAP_BOTTOM_003 VDD GND R8W__A44_CAP_SWITCH_BANK_CORE_O2
XR8W__A44_CAP_SWITCH_BANK_CORE_O2_5 VREFP VREFN CTRL_038 CAP_BOTTOM_038 VDD GND R8W__A44_CAP_SWITCH_BANK_CORE_O2
XR8W__A44_CAP_SWITCH_BANK_CORE_O2_4 VREFP VREFN CTRL_054 CAP_BOTTOM_054 VDD GND R8W__A44_CAP_SWITCH_BANK_CORE_O2
XR8W__A44_CAP_SWITCH_BANK_CORE_O2_6 VREFP VREFN CTRL_022 CAP_BOTTOM_022 VDD GND R8W__A44_CAP_SWITCH_BANK_CORE_O2
XR8W__A44_CAP_SWITCH_BANK_CORE_O2_7 VREFP VREFN CTRL_006 CAP_BOTTOM_006 VDD GND R8W__A44_CAP_SWITCH_BANK_CORE_O2
XR8W__A44_CAP_SWITCH_BANK_CORE_O2_8 VREFP VREFN CTRL_053 CAP_BOTTOM_053 VDD GND R8W__A44_CAP_SWITCH_BANK_CORE_O2
XR8W__A44_CAP_SWITCH_BANK_CORE_O2_9 VREFP VREFN CTRL_037 CAP_BOTTOM_037 VDD GND R8W__A44_CAP_SWITCH_BANK_CORE_O2
XR8W__A44_CAP_SWITCH_BANK_CORE_O2_60 VREFP VREFN CTRL_056 CAP_BOTTOM_056 VDD GND R8W__A44_CAP_SWITCH_BANK_CORE_O2
.ends

.subckt R8W__A44_SW_BANK64_SOUTH_R8_M6 CAP_BOTTOM_087 CAP_BOTTOM_103 CAP_BOTTOM_119
+ CAP_BOTTOM_072 CAP_BOTTOM_088 CAP_BOTTOM_104 CAP_BOTTOM_120 CAP_BOTTOM_073 CAP_BOTTOM_089
+ CAP_BOTTOM_105 CAP_BOTTOM_121 CAP_BOTTOM_074 CAP_BOTTOM_090 CAP_BOTTOM_106 CAP_BOTTOM_122
+ CAP_BOTTOM_075 CAP_BOTTOM_091 CAP_BOTTOM_107 CAP_BOTTOM_123 CAP_BOTTOM_076 CAP_BOTTOM_092
+ CAP_BOTTOM_108 CAP_BOTTOM_124 CAP_BOTTOM_077 CAP_BOTTOM_093 CAP_BOTTOM_109 CAP_BOTTOM_125
+ CAP_BOTTOM_078 CAP_BOTTOM_094 CAP_BOTTOM_110 CAP_BOTTOM_126 CAP_BOTTOM_064 CAP_BOTTOM_079
+ CAP_BOTTOM_095 CAP_BOTTOM_111 CAP_BOTTOM_065 CAP_BOTTOM_080 CAP_BOTTOM_096 CAP_BOTTOM_112
+ CAP_BOTTOM_066 CAP_BOTTOM_081 CAP_BOTTOM_097 CAP_BOTTOM_113 CAP_BOTTOM_067 CAP_BOTTOM_082
+ CAP_BOTTOM_098 CAP_BOTTOM_114 CAP_BOTTOM_068 CAP_BOTTOM_083 CAP_BOTTOM_099 CAP_BOTTOM_115
+ CAP_BOTTOM_069 CAP_BOTTOM_084 CAP_BOTTOM_100 CAP_BOTTOM_116 CAP_BOTTOM_070 CAP_BOTTOM_085
+ CAP_BOTTOM_101 CAP_BOTTOM_117 CAP_BOTTOM_071 CAP_BOTTOM_086 CAP_BOTTOM_102 CAP_BOTTOM_118
+ CTRL_064 CTRL_068 CTRL_066 CTRL_083 CTRL_065 CTRL_099 CTRL_081 CTRL_115 CTRL_095
+ CTRL_069 CTRL_097 CTRL_084 CTRL_080 CTRL_100 CTRL_113 CTRL_116 CTRL_079 CTRL_070
+ CTRL_067 CTRL_085 CTRL_096 CTRL_101 CTRL_082 CTRL_117 CTRL_111 CTRL_071 CTRL_098
+ CTRL_086 CTRL_112 CTRL_102 CTRL_114 CTRL_118 CTRL_075 CTRL_087 CTRL_091 CTRL_089
+ CTRL_107 CTRL_088 CTRL_123 CTRL_105 CTRL_076 CTRL_119 CTRL_092 CTRL_121 CTRL_108
+ CTRL_104 CTRL_124 CTRL_074 CTRL_077 CTRL_103 CTRL_093 CTRL_090 CTRL_109 CTRL_120
+ CTRL_125 CTRL_106 CTRL_078 CTRL_072 CTRL_094 CTRL_122 CTRL_110 CTRL_073 CTRL_126
+ VREFN VREFP VDD GND
XR8W__A44_CAP_SWITCH_BANK_CORE_O2_61 VREFP VREFN CTRL_087 CAP_BOTTOM_087 VDD GND R8W__A44_CAP_SWITCH_BANK_CORE_O2
XR8W__A44_CAP_SWITCH_BANK_CORE_O2_50 VREFP VREFN CTRL_074 CAP_BOTTOM_074 VDD GND R8W__A44_CAP_SWITCH_BANK_CORE_O2
XR8W__A44_CAP_SWITCH_BANK_CORE_O2_51 VREFP VREFN CTRL_121 CAP_BOTTOM_121 VDD GND R8W__A44_CAP_SWITCH_BANK_CORE_O2
XR8W__A44_CAP_SWITCH_BANK_CORE_O2_40 VREFP VREFN CTRL_108 CAP_BOTTOM_108 VDD GND R8W__A44_CAP_SWITCH_BANK_CORE_O2
XR8W__A44_CAP_SWITCH_BANK_CORE_O2_62 VREFP VREFN CTRL_075 CAP_BOTTOM_075 VDD GND R8W__A44_CAP_SWITCH_BANK_CORE_O2
XR8W__A44_CAP_SWITCH_BANK_CORE_O2_41 VREFP VREFN CTRL_092 CAP_BOTTOM_092 VDD GND R8W__A44_CAP_SWITCH_BANK_CORE_O2
XR8W__A44_CAP_SWITCH_BANK_CORE_O2_52 VREFP VREFN CTRL_105 CAP_BOTTOM_105 VDD GND R8W__A44_CAP_SWITCH_BANK_CORE_O2
XR8W__A44_CAP_SWITCH_BANK_CORE_O2_30 VREFP VREFN CTRL_068 CAP_BOTTOM_068 VDD GND R8W__A44_CAP_SWITCH_BANK_CORE_O2
XR8W__A44_CAP_SWITCH_BANK_CORE_O2_31 VREFP VREFN CTRL_126 CAP_BOTTOM_126 VDD GND R8W__A44_CAP_SWITCH_BANK_CORE_O2
XR8W__A44_CAP_SWITCH_BANK_CORE_O2_53 VREFP VREFN CTRL_089 CAP_BOTTOM_089 VDD GND R8W__A44_CAP_SWITCH_BANK_CORE_O2
XR8W__A44_CAP_SWITCH_BANK_CORE_O2_42 VREFP VREFN CTRL_076 CAP_BOTTOM_076 VDD GND R8W__A44_CAP_SWITCH_BANK_CORE_O2
XR8W__A44_CAP_SWITCH_BANK_CORE_O2_20 VREFP VREFN CTRL_097 CAP_BOTTOM_097 VDD GND R8W__A44_CAP_SWITCH_BANK_CORE_O2
XR8W__A44_CAP_SWITCH_BANK_CORE_O2_43 VREFP VREFN CTRL_123 CAP_BOTTOM_123 VDD GND R8W__A44_CAP_SWITCH_BANK_CORE_O2
XR8W__A44_CAP_SWITCH_BANK_CORE_O2_21 VREFP VREFN CTRL_081 CAP_BOTTOM_081 VDD GND R8W__A44_CAP_SWITCH_BANK_CORE_O2
XR8W__A44_CAP_SWITCH_BANK_CORE_O2_32 VREFP VREFN CTRL_110 CAP_BOTTOM_110 VDD GND R8W__A44_CAP_SWITCH_BANK_CORE_O2
XR8W__A44_CAP_SWITCH_BANK_CORE_O2_54 VREFP VREFN CTRL_073 CAP_BOTTOM_073 VDD GND R8W__A44_CAP_SWITCH_BANK_CORE_O2
XR8W__A44_CAP_SWITCH_BANK_CORE_O2_10 VREFP VREFN CTRL_069 CAP_BOTTOM_069 VDD GND R8W__A44_CAP_SWITCH_BANK_CORE_O2
XR8W__A44_CAP_SWITCH_BANK_CORE_O2_33 VREFP VREFN CTRL_094 CAP_BOTTOM_094 VDD GND R8W__A44_CAP_SWITCH_BANK_CORE_O2
XR8W__A44_CAP_SWITCH_BANK_CORE_O2_55 VREFP VREFN CTRL_120 CAP_BOTTOM_120 VDD GND R8W__A44_CAP_SWITCH_BANK_CORE_O2
XR8W__A44_CAP_SWITCH_BANK_CORE_O2_11 VREFP VREFN CTRL_115 CAP_BOTTOM_115 VDD GND R8W__A44_CAP_SWITCH_BANK_CORE_O2
XR8W__A44_CAP_SWITCH_BANK_CORE_O2_44 VREFP VREFN CTRL_107 CAP_BOTTOM_107 VDD GND R8W__A44_CAP_SWITCH_BANK_CORE_O2
XR8W__A44_CAP_SWITCH_BANK_CORE_O2_22 VREFP VREFN CTRL_066 CAP_BOTTOM_066 VDD GND R8W__A44_CAP_SWITCH_BANK_CORE_O2
XR8W__A44_CAP_SWITCH_BANK_CORE_O2_45 VREFP VREFN CTRL_091 CAP_BOTTOM_091 VDD GND R8W__A44_CAP_SWITCH_BANK_CORE_O2
XR8W__A44_CAP_SWITCH_BANK_CORE_O2_23 VREFP VREFN CTRL_112 CAP_BOTTOM_112 VDD GND R8W__A44_CAP_SWITCH_BANK_CORE_O2
XR8W__A44_CAP_SWITCH_BANK_CORE_O2_34 VREFP VREFN CTRL_078 CAP_BOTTOM_078 VDD GND R8W__A44_CAP_SWITCH_BANK_CORE_O2
XR8W__A44_CAP_SWITCH_BANK_CORE_O2_56 VREFP VREFN CTRL_104 CAP_BOTTOM_104 VDD GND R8W__A44_CAP_SWITCH_BANK_CORE_O2
XR8W__A44_CAP_SWITCH_BANK_CORE_O2_12 VREFP VREFN CTRL_099 CAP_BOTTOM_099 VDD GND R8W__A44_CAP_SWITCH_BANK_CORE_O2
XR8W__A44_CAP_SWITCH_BANK_CORE_O2_35 VREFP VREFN CTRL_125 CAP_BOTTOM_125 VDD GND R8W__A44_CAP_SWITCH_BANK_CORE_O2
XR8W__A44_CAP_SWITCH_BANK_CORE_O2_47 VREFP VREFN CTRL_122 CAP_BOTTOM_122 VDD GND R8W__A44_CAP_SWITCH_BANK_CORE_O2
XR8W__A44_CAP_SWITCH_BANK_CORE_O2_57 VREFP VREFN CTRL_088 CAP_BOTTOM_088 VDD GND R8W__A44_CAP_SWITCH_BANK_CORE_O2
XR8W__A44_CAP_SWITCH_BANK_CORE_O2_46 VREFP VREFN CTRL_118 CAP_BOTTOM_118 VDD GND R8W__A44_CAP_SWITCH_BANK_CORE_O2
XR8W__A44_CAP_SWITCH_BANK_CORE_O2_13 VREFP VREFN CTRL_083 CAP_BOTTOM_083 VDD GND R8W__A44_CAP_SWITCH_BANK_CORE_O2
XR8W__A44_CAP_SWITCH_BANK_CORE_O2_25 VREFP VREFN CTRL_080 CAP_BOTTOM_080 VDD GND R8W__A44_CAP_SWITCH_BANK_CORE_O2
XR8W__A44_CAP_SWITCH_BANK_CORE_O2_36 VREFP VREFN CTRL_109 CAP_BOTTOM_109 VDD GND R8W__A44_CAP_SWITCH_BANK_CORE_O2
XR8W__A44_CAP_SWITCH_BANK_CORE_O2_58 VREFP VREFN CTRL_072 CAP_BOTTOM_072 VDD GND R8W__A44_CAP_SWITCH_BANK_CORE_O2
XR8W__A44_CAP_SWITCH_BANK_CORE_O2_24 VREFP VREFN CTRL_096 CAP_BOTTOM_096 VDD GND R8W__A44_CAP_SWITCH_BANK_CORE_O2
XR8W__A44_CAP_SWITCH_BANK_CORE_O2_14 VREFP VREFN CTRL_064 CAP_BOTTOM_064 VDD GND R8W__A44_CAP_SWITCH_BANK_CORE_O2
XR8W__A44_CAP_SWITCH_BANK_CORE_O2_37 VREFP VREFN CTRL_093 CAP_BOTTOM_093 VDD GND R8W__A44_CAP_SWITCH_BANK_CORE_O2
XR8W__A44_CAP_SWITCH_BANK_CORE_O2_59 VREFP VREFN CTRL_119 CAP_BOTTOM_119 VDD GND R8W__A44_CAP_SWITCH_BANK_CORE_O2
XR8W__A44_CAP_SWITCH_BANK_CORE_O2_15 VREFP VREFN CTRL_114 CAP_BOTTOM_114 VDD GND R8W__A44_CAP_SWITCH_BANK_CORE_O2
XR8W__A44_CAP_SWITCH_BANK_CORE_O2_48 VREFP VREFN CTRL_106 CAP_BOTTOM_106 VDD GND R8W__A44_CAP_SWITCH_BANK_CORE_O2
XR8W__A44_CAP_SWITCH_BANK_CORE_O2_26 VREFP VREFN CTRL_065 CAP_BOTTOM_065 VDD GND R8W__A44_CAP_SWITCH_BANK_CORE_O2
XR8W__A44_CAP_SWITCH_BANK_CORE_O2_49 VREFP VREFN CTRL_090 CAP_BOTTOM_090 VDD GND R8W__A44_CAP_SWITCH_BANK_CORE_O2
XR8W__A44_CAP_SWITCH_BANK_CORE_O2_27 VREFP VREFN CTRL_111 CAP_BOTTOM_111 VDD GND R8W__A44_CAP_SWITCH_BANK_CORE_O2
XR8W__A44_CAP_SWITCH_BANK_CORE_O2_38 VREFP VREFN CTRL_077 CAP_BOTTOM_077 VDD GND R8W__A44_CAP_SWITCH_BANK_CORE_O2
XR8W__A44_CAP_SWITCH_BANK_CORE_O2_0 VREFP VREFN CTRL_102 CAP_BOTTOM_102 VDD GND R8W__A44_CAP_SWITCH_BANK_CORE_O2
XR8W__A44_CAP_SWITCH_BANK_CORE_O2_16 VREFP VREFN CTRL_098 CAP_BOTTOM_098 VDD GND R8W__A44_CAP_SWITCH_BANK_CORE_O2
XR8W__A44_CAP_SWITCH_BANK_CORE_O2_39 VREFP VREFN CTRL_124 CAP_BOTTOM_124 VDD GND R8W__A44_CAP_SWITCH_BANK_CORE_O2
XR8W__A44_CAP_SWITCH_BANK_CORE_O2_1 VREFP VREFN CTRL_086 CAP_BOTTOM_086 VDD GND R8W__A44_CAP_SWITCH_BANK_CORE_O2
XR8W__A44_CAP_SWITCH_BANK_CORE_O2_17 VREFP VREFN CTRL_082 CAP_BOTTOM_082 VDD GND R8W__A44_CAP_SWITCH_BANK_CORE_O2
XR8W__A44_CAP_SWITCH_BANK_CORE_O2_28 VREFP VREFN CTRL_095 CAP_BOTTOM_095 VDD GND R8W__A44_CAP_SWITCH_BANK_CORE_O2
XR8W__A44_CAP_SWITCH_BANK_CORE_O2_29 VREFP VREFN CTRL_079 CAP_BOTTOM_079 VDD GND R8W__A44_CAP_SWITCH_BANK_CORE_O2
XR8W__A44_CAP_SWITCH_BANK_CORE_O2_2 VREFP VREFN CTRL_071 CAP_BOTTOM_071 VDD GND R8W__A44_CAP_SWITCH_BANK_CORE_O2
XR8W__A44_CAP_SWITCH_BANK_CORE_O2_18 VREFP VREFN CTRL_067 CAP_BOTTOM_067 VDD GND R8W__A44_CAP_SWITCH_BANK_CORE_O2
XR8W__A44_CAP_SWITCH_BANK_CORE_O2_3 VREFP VREFN CTRL_117 CAP_BOTTOM_117 VDD GND R8W__A44_CAP_SWITCH_BANK_CORE_O2
XR8W__A44_CAP_SWITCH_BANK_CORE_O2_19 VREFP VREFN CTRL_113 CAP_BOTTOM_113 VDD GND R8W__A44_CAP_SWITCH_BANK_CORE_O2
XR8W__A44_CAP_SWITCH_BANK_CORE_O2_5 VREFP VREFN CTRL_085 CAP_BOTTOM_085 VDD GND R8W__A44_CAP_SWITCH_BANK_CORE_O2
XR8W__A44_CAP_SWITCH_BANK_CORE_O2_4 VREFP VREFN CTRL_101 CAP_BOTTOM_101 VDD GND R8W__A44_CAP_SWITCH_BANK_CORE_O2
XR8W__A44_CAP_SWITCH_BANK_CORE_O2_6 VREFP VREFN CTRL_070 CAP_BOTTOM_070 VDD GND R8W__A44_CAP_SWITCH_BANK_CORE_O2
XR8W__A44_CAP_SWITCH_BANK_CORE_O2_7 VREFP VREFN CTRL_116 CAP_BOTTOM_116 VDD GND R8W__A44_CAP_SWITCH_BANK_CORE_O2
XR8W__A44_CAP_SWITCH_BANK_CORE_O2_8 VREFP VREFN CTRL_100 CAP_BOTTOM_100 VDD GND R8W__A44_CAP_SWITCH_BANK_CORE_O2
XR8W__A44_CAP_SWITCH_BANK_CORE_O2_9 VREFP VREFN CTRL_084 CAP_BOTTOM_084 VDD GND R8W__A44_CAP_SWITCH_BANK_CORE_O2
XR8W__A44_CAP_SWITCH_BANK_CORE_O2_60 VREFP VREFN CTRL_103 CAP_BOTTOM_103 VDD GND R8W__A44_CAP_SWITCH_BANK_CORE_O2
.ends

.subckt R8W__A44_MIM_6P855_R0 m4_n120_n120# m4_0_0#
X0 m4_0_0# m4_n120_n120# cap_mim_2f0_m4m5_noshield c_width=6.855u c_length=6.855u
.ends

.subckt R8W__A44_C1_MIM6_R0 V_BOT VTOP
XXMIM_R1_C2_R0 V_BOT VTOP R8W__A44_MIM_6P855_R0
XXMIM_R0_C2_R0 V_BOT VTOP R8W__A44_MIM_6P855_R0
XXMIM_R1_C0_R0 V_BOT VTOP R8W__A44_MIM_6P855_R0
XXMIM_R0_C0_R0 V_BOT VTOP R8W__A44_MIM_6P855_R0
XXMIM_R1_C1_R0 V_BOT VTOP R8W__A44_MIM_6P855_R0
XXMIM_R0_C1_R0 V_BOT VTOP R8W__A44_MIM_6P855_R0
.ends

.subckt R8W__A44_CAP_CORE128_M6_R1 CAP_BOTTOM_008 CAP_BOTTOM_009 CAP_BOTTOM_010 CAP_BOTTOM_011
+ CAP_BOTTOM_012 CAP_BOTTOM_013 CAP_BOTTOM_014 CAP_BOTTOM_015 CAP_BOTTOM_024 CAP_BOTTOM_025
+ CAP_BOTTOM_026 CAP_BOTTOM_027 CAP_BOTTOM_028 CAP_BOTTOM_029 CAP_BOTTOM_030 CAP_BOTTOM_031
+ CAP_BOTTOM_040 CAP_BOTTOM_041 CAP_BOTTOM_042 CAP_BOTTOM_043 CAP_BOTTOM_044 CAP_BOTTOM_045
+ CAP_BOTTOM_046 CAP_BOTTOM_047 CAP_BOTTOM_056 CAP_BOTTOM_057 CAP_BOTTOM_058 CAP_BOTTOM_059
+ CAP_BOTTOM_060 CAP_BOTTOM_061 CAP_BOTTOM_062 CAP_BOTTOM_063 CAP_BOTTOM_032 CAP_BOTTOM_033
+ CAP_BOTTOM_034 CAP_BOTTOM_035 CAP_BOTTOM_036 CAP_BOTTOM_037 CAP_BOTTOM_038 CAP_BOTTOM_039
+ CAP_BOTTOM_016 CAP_BOTTOM_017 CAP_BOTTOM_018 CAP_BOTTOM_019 CAP_BOTTOM_020 CAP_BOTTOM_021
+ CAP_BOTTOM_022 CAP_BOTTOM_023 CAP_BOTTOM_048 CAP_BOTTOM_049 CAP_BOTTOM_050 CAP_BOTTOM_051
+ CAP_BOTTOM_052 CAP_BOTTOM_053 CAP_BOTTOM_054 CAP_BOTTOM_055 CAP_BOTTOM_000 CAP_BOTTOM_001
+ CAP_BOTTOM_002 CAP_BOTTOM_003 CAP_BOTTOM_004 CAP_BOTTOM_005 CAP_BOTTOM_006 CAP_BOTTOM_007
+ CAP_BOTTOM_064 CAP_BOTTOM_065 CAP_BOTTOM_066 CAP_BOTTOM_067 CAP_BOTTOM_068 CAP_BOTTOM_069
+ CAP_BOTTOM_070 CAP_BOTTOM_071 CAP_BOTTOM_079 CAP_BOTTOM_080 CAP_BOTTOM_081 CAP_BOTTOM_082
+ CAP_BOTTOM_083 CAP_BOTTOM_084 CAP_BOTTOM_085 CAP_BOTTOM_086 CAP_BOTTOM_095 CAP_BOTTOM_096
+ CAP_BOTTOM_097 CAP_BOTTOM_098 CAP_BOTTOM_099 CAP_BOTTOM_100 CAP_BOTTOM_101 CAP_BOTTOM_102
+ CAP_BOTTOM_111 CAP_BOTTOM_112 CAP_BOTTOM_113 CAP_BOTTOM_114 CAP_BOTTOM_115 CAP_BOTTOM_116
+ CAP_BOTTOM_117 CAP_BOTTOM_118 GND CAP_BOTTOM_072 CAP_BOTTOM_073 CAP_BOTTOM_074 CAP_BOTTOM_075
+ CAP_BOTTOM_076 CAP_BOTTOM_077 CAP_BOTTOM_078 CAP_BOTTOM_103 CAP_BOTTOM_104 CAP_BOTTOM_105
+ CAP_BOTTOM_106 CAP_BOTTOM_107 CAP_BOTTOM_108 CAP_BOTTOM_109 CAP_BOTTOM_110 CAP_BOTTOM_087
+ CAP_BOTTOM_088 CAP_BOTTOM_089 CAP_BOTTOM_090 CAP_BOTTOM_091 CAP_BOTTOM_092 CAP_BOTTOM_093
+ CAP_BOTTOM_094 CAP_BOTTOM_119 CAP_BOTTOM_120 CAP_BOTTOM_121 CAP_BOTTOM_122 CAP_BOTTOM_123
+ CAP_BOTTOM_124 CAP_BOTTOM_125 CAP_BOTTOM_126 VTOP
XR8W__A44_C1_MIM6_R0_92 CAP_BOTTOM_005 VTOP R8W__A44_C1_MIM6_R0
XR8W__A44_C1_MIM6_R0_81 CAP_BOTTOM_050 VTOP R8W__A44_C1_MIM6_R0
XR8W__A44_C1_MIM6_R0_70 CAP_BOTTOM_039 VTOP R8W__A44_C1_MIM6_R0
XR8W__A44_C1_MIM6_R0_93 CAP_BOTTOM_006 VTOP R8W__A44_C1_MIM6_R0
XR8W__A44_C1_MIM6_R0_71 CAP_BOTTOM_016 VTOP R8W__A44_C1_MIM6_R0
XR8W__A44_C1_MIM6_R0_60 CAP_BOTTOM_116 VTOP R8W__A44_C1_MIM6_R0
XR8W__A44_C1_MIM6_R0_82 CAP_BOTTOM_051 VTOP R8W__A44_C1_MIM6_R0
XR8W__A44_C1_MIM6_R0_0 CAP_BOTTOM_072 VTOP R8W__A44_C1_MIM6_R0
XR8W__A44_C1_MIM6_R0_94 CAP_BOTTOM_007 VTOP R8W__A44_C1_MIM6_R0
XR8W__A44_C1_MIM6_R0_72 CAP_BOTTOM_017 VTOP R8W__A44_C1_MIM6_R0
XR8W__A44_C1_MIM6_R0_50 CAP_BOTTOM_098 VTOP R8W__A44_C1_MIM6_R0
XR8W__A44_C1_MIM6_R0_61 CAP_BOTTOM_117 VTOP R8W__A44_C1_MIM6_R0
XR8W__A44_C1_MIM6_R0_83 CAP_BOTTOM_052 VTOP R8W__A44_C1_MIM6_R0
XR8W__A44_C1_MIM6_R0_1 CAP_BOTTOM_073 VTOP R8W__A44_C1_MIM6_R0
XR8W__A44_C1_MIM6_R0_73 CAP_BOTTOM_018 VTOP R8W__A44_C1_MIM6_R0
XR8W__A44_C1_MIM6_R0_51 CAP_BOTTOM_099 VTOP R8W__A44_C1_MIM6_R0
XR8W__A44_C1_MIM6_R0_62 CAP_BOTTOM_118 VTOP R8W__A44_C1_MIM6_R0
XR8W__A44_C1_MIM6_R0_40 CAP_BOTTOM_079 VTOP R8W__A44_C1_MIM6_R0
XR8W__A44_C1_MIM6_R0_95 CAP_BOTTOM_048 VTOP R8W__A44_C1_MIM6_R0
XR8W__A44_C1_MIM6_R0_84 CAP_BOTTOM_053 VTOP R8W__A44_C1_MIM6_R0
XR8W__A44_C1_MIM6_R0_2 CAP_BOTTOM_074 VTOP R8W__A44_C1_MIM6_R0
XR8W__A44_C1_MIM6_R0_96 CAP_BOTTOM_008 VTOP R8W__A44_C1_MIM6_R0
XR8W__A44_C1_MIM6_R0_74 CAP_BOTTOM_019 VTOP R8W__A44_C1_MIM6_R0
XR8W__A44_C1_MIM6_R0_63 CAP_BOTTOM_095 VTOP R8W__A44_C1_MIM6_R0
XR8W__A44_C1_MIM6_R0_52 CAP_BOTTOM_100 VTOP R8W__A44_C1_MIM6_R0
XR8W__A44_C1_MIM6_R0_30 CAP_BOTTOM_126 VTOP R8W__A44_C1_MIM6_R0
XR8W__A44_C1_MIM6_R0_41 CAP_BOTTOM_080 VTOP R8W__A44_C1_MIM6_R0
XR8W__A44_C1_MIM6_R0_85 CAP_BOTTOM_054 VTOP R8W__A44_C1_MIM6_R0
XR8W__A44_C1_MIM6_R0_3 CAP_BOTTOM_075 VTOP R8W__A44_C1_MIM6_R0
XR8W__A44_C1_MIM6_R0_97 CAP_BOTTOM_009 VTOP R8W__A44_C1_MIM6_R0
XR8W__A44_C1_MIM6_R0_75 CAP_BOTTOM_020 VTOP R8W__A44_C1_MIM6_R0
XR8W__A44_C1_MIM6_R0_53 CAP_BOTTOM_101 VTOP R8W__A44_C1_MIM6_R0
XR8W__A44_C1_MIM6_R0_42 CAP_BOTTOM_081 VTOP R8W__A44_C1_MIM6_R0
XR8W__A44_C1_MIM6_R0_31 CAP_BOTTOM_087 VTOP R8W__A44_C1_MIM6_R0
XR8W__A44_C1_MIM6_R0_20 CAP_BOTTOM_092 VTOP R8W__A44_C1_MIM6_R0
XR8W__A44_C1_MIM6_R0_86 CAP_BOTTOM_055 VTOP R8W__A44_C1_MIM6_R0
XR8W__A44_C1_MIM6_R0_64 CAP_BOTTOM_033 VTOP R8W__A44_C1_MIM6_R0
XR8W__A44_C1_MIM6_R0_4 CAP_BOTTOM_076 VTOP R8W__A44_C1_MIM6_R0
XR8W__A44_C1_MIM6_R0_98 CAP_BOTTOM_010 VTOP R8W__A44_C1_MIM6_R0
XR8W__A44_C1_MIM6_R0_87 CAP_BOTTOM_000 VTOP R8W__A44_C1_MIM6_R0
XR8W__A44_C1_MIM6_R0_76 CAP_BOTTOM_021 VTOP R8W__A44_C1_MIM6_R0
XR8W__A44_C1_MIM6_R0_54 CAP_BOTTOM_102 VTOP R8W__A44_C1_MIM6_R0
XR8W__A44_C1_MIM6_R0_10 CAP_BOTTOM_106 VTOP R8W__A44_C1_MIM6_R0
XR8W__A44_C1_MIM6_R0_43 CAP_BOTTOM_082 VTOP R8W__A44_C1_MIM6_R0
XR8W__A44_C1_MIM6_R0_21 CAP_BOTTOM_093 VTOP R8W__A44_C1_MIM6_R0
XR8W__A44_C1_MIM6_R0_32 CAP_BOTTOM_064 VTOP R8W__A44_C1_MIM6_R0
XR8W__A44_C1_MIM6_R0_65 CAP_BOTTOM_034 VTOP R8W__A44_C1_MIM6_R0
XR8W__A44_C1_MIM6_R0_5 CAP_BOTTOM_077 VTOP R8W__A44_C1_MIM6_R0
XR8W__A44_C1_MIM6_R0_99 CAP_BOTTOM_011 VTOP R8W__A44_C1_MIM6_R0
XR8W__A44_C1_MIM6_R0_88 CAP_BOTTOM_001 VTOP R8W__A44_C1_MIM6_R0
XR8W__A44_C1_MIM6_R0_77 CAP_BOTTOM_022 VTOP R8W__A44_C1_MIM6_R0
XR8W__A44_C1_MIM6_R0_55 CAP_BOTTOM_111 VTOP R8W__A44_C1_MIM6_R0
XR8W__A44_C1_MIM6_R0_11 CAP_BOTTOM_107 VTOP R8W__A44_C1_MIM6_R0
XR8W__A44_C1_MIM6_R0_44 CAP_BOTTOM_083 VTOP R8W__A44_C1_MIM6_R0
XR8W__A44_C1_MIM6_R0_22 CAP_BOTTOM_094 VTOP R8W__A44_C1_MIM6_R0
XR8W__A44_C1_MIM6_R0_33 CAP_BOTTOM_065 VTOP R8W__A44_C1_MIM6_R0
XR8W__A44_C1_MIM6_R0_66 CAP_BOTTOM_035 VTOP R8W__A44_C1_MIM6_R0
XR8W__A44_C1_MIM6_R0_6 CAP_BOTTOM_078 VTOP R8W__A44_C1_MIM6_R0
XR8W__A44_C1_MIM6_R0_89 CAP_BOTTOM_002 VTOP R8W__A44_C1_MIM6_R0
XR8W__A44_C1_MIM6_R0_78 CAP_BOTTOM_023 VTOP R8W__A44_C1_MIM6_R0
XR8W__A44_C1_MIM6_R0_56 CAP_BOTTOM_112 VTOP R8W__A44_C1_MIM6_R0
XR8W__A44_C1_MIM6_R0_23 CAP_BOTTOM_119 VTOP R8W__A44_C1_MIM6_R0
XR8W__A44_C1_MIM6_R0_12 CAP_BOTTOM_108 VTOP R8W__A44_C1_MIM6_R0
XR8W__A44_C1_MIM6_R0_45 CAP_BOTTOM_084 VTOP R8W__A44_C1_MIM6_R0
XR8W__A44_C1_MIM6_R0_34 CAP_BOTTOM_066 VTOP R8W__A44_C1_MIM6_R0
XR8W__A44_C1_MIM6_R0_67 CAP_BOTTOM_036 VTOP R8W__A44_C1_MIM6_R0
XR8W__A44_C1_MIM6_R0_7 CAP_BOTTOM_103 VTOP R8W__A44_C1_MIM6_R0
XR8W__A44_C1_MIM6_R0_120 CAP_BOTTOM_057 VTOP R8W__A44_C1_MIM6_R0
XR8W__A44_C1_MIM6_R0_57 CAP_BOTTOM_113 VTOP R8W__A44_C1_MIM6_R0
XR8W__A44_C1_MIM6_R0_24 CAP_BOTTOM_120 VTOP R8W__A44_C1_MIM6_R0
XR8W__A44_C1_MIM6_R0_13 CAP_BOTTOM_109 VTOP R8W__A44_C1_MIM6_R0
XR8W__A44_C1_MIM6_R0_46 CAP_BOTTOM_085 VTOP R8W__A44_C1_MIM6_R0
XR8W__A44_C1_MIM6_R0_35 CAP_BOTTOM_067 VTOP R8W__A44_C1_MIM6_R0
XR8W__A44_C1_MIM6_R0_79 CAP_BOTTOM_032 VTOP R8W__A44_C1_MIM6_R0
XR8W__A44_C1_MIM6_R0_68 CAP_BOTTOM_037 VTOP R8W__A44_C1_MIM6_R0
XR8W__A44_C1_MIM6_R0_8 CAP_BOTTOM_104 VTOP R8W__A44_C1_MIM6_R0
XR8W__A44_C1_MIM6_R0_110 CAP_BOTTOM_030 VTOP R8W__A44_C1_MIM6_R0
XR8W__A44_C1_MIM6_R0_121 CAP_BOTTOM_058 VTOP R8W__A44_C1_MIM6_R0
XR8W__A44_C1_MIM6_R0_58 CAP_BOTTOM_114 VTOP R8W__A44_C1_MIM6_R0
XR8W__A44_C1_MIM6_R0_25 CAP_BOTTOM_121 VTOP R8W__A44_C1_MIM6_R0
XR8W__A44_C1_MIM6_R0_14 CAP_BOTTOM_110 VTOP R8W__A44_C1_MIM6_R0
XR8W__A44_C1_MIM6_R0_47 CAP_BOTTOM_086 VTOP R8W__A44_C1_MIM6_R0
XR8W__A44_C1_MIM6_R0_36 CAP_BOTTOM_068 VTOP R8W__A44_C1_MIM6_R0
XR8W__A44_C1_MIM6_R0_69 CAP_BOTTOM_038 VTOP R8W__A44_C1_MIM6_R0
XR8W__A44_C1_MIM6_R0_100 CAP_BOTTOM_012 VTOP R8W__A44_C1_MIM6_R0
XR8W__A44_C1_MIM6_R0_111 CAP_BOTTOM_031 VTOP R8W__A44_C1_MIM6_R0
XR8W__A44_C1_MIM6_R0_9 CAP_BOTTOM_105 VTOP R8W__A44_C1_MIM6_R0
XR8W__A44_C1_MIM6_R0_122 CAP_BOTTOM_059 VTOP R8W__A44_C1_MIM6_R0
XR8W__A44_C1_MIM6_R0_48 CAP_BOTTOM_096 VTOP R8W__A44_C1_MIM6_R0
XR8W__A44_C1_MIM6_R0_59 CAP_BOTTOM_115 VTOP R8W__A44_C1_MIM6_R0
XR8W__A44_C1_MIM6_R0_26 CAP_BOTTOM_122 VTOP R8W__A44_C1_MIM6_R0
XR8W__A44_C1_MIM6_R0_37 CAP_BOTTOM_069 VTOP R8W__A44_C1_MIM6_R0
XR8W__A44_C1_MIM6_R0_15 GND VTOP R8W__A44_C1_MIM6_R0
XR8W__A44_C1_MIM6_R0_101 CAP_BOTTOM_013 VTOP R8W__A44_C1_MIM6_R0
XR8W__A44_C1_MIM6_R0_123 CAP_BOTTOM_060 VTOP R8W__A44_C1_MIM6_R0
XR8W__A44_C1_MIM6_R0_112 CAP_BOTTOM_041 VTOP R8W__A44_C1_MIM6_R0
XR8W__A44_C1_MIM6_R0_49 CAP_BOTTOM_097 VTOP R8W__A44_C1_MIM6_R0
XR8W__A44_C1_MIM6_R0_27 CAP_BOTTOM_123 VTOP R8W__A44_C1_MIM6_R0
XR8W__A44_C1_MIM6_R0_16 CAP_BOTTOM_088 VTOP R8W__A44_C1_MIM6_R0
XR8W__A44_C1_MIM6_R0_38 CAP_BOTTOM_070 VTOP R8W__A44_C1_MIM6_R0
XR8W__A44_C1_MIM6_R0_102 CAP_BOTTOM_014 VTOP R8W__A44_C1_MIM6_R0
XR8W__A44_C1_MIM6_R0_124 CAP_BOTTOM_061 VTOP R8W__A44_C1_MIM6_R0
XR8W__A44_C1_MIM6_R0_113 CAP_BOTTOM_042 VTOP R8W__A44_C1_MIM6_R0
XR8W__A44_C1_MIM6_R0_28 CAP_BOTTOM_124 VTOP R8W__A44_C1_MIM6_R0
XR8W__A44_C1_MIM6_R0_17 CAP_BOTTOM_089 VTOP R8W__A44_C1_MIM6_R0
XR8W__A44_C1_MIM6_R0_39 CAP_BOTTOM_071 VTOP R8W__A44_C1_MIM6_R0
XR8W__A44_C1_MIM6_R0_103 CAP_BOTTOM_015 VTOP R8W__A44_C1_MIM6_R0
XR8W__A44_C1_MIM6_R0_125 CAP_BOTTOM_062 VTOP R8W__A44_C1_MIM6_R0
XR8W__A44_C1_MIM6_R0_114 CAP_BOTTOM_043 VTOP R8W__A44_C1_MIM6_R0
XR8W__A44_C1_MIM6_R0_29 CAP_BOTTOM_125 VTOP R8W__A44_C1_MIM6_R0
XR8W__A44_C1_MIM6_R0_18 CAP_BOTTOM_090 VTOP R8W__A44_C1_MIM6_R0
XR8W__A44_C1_MIM6_R0_104 CAP_BOTTOM_024 VTOP R8W__A44_C1_MIM6_R0
XR8W__A44_C1_MIM6_R0_126 CAP_BOTTOM_063 VTOP R8W__A44_C1_MIM6_R0
XR8W__A44_C1_MIM6_R0_115 CAP_BOTTOM_044 VTOP R8W__A44_C1_MIM6_R0
XR8W__A44_C1_MIM6_R0_19 CAP_BOTTOM_091 VTOP R8W__A44_C1_MIM6_R0
XR8W__A44_C1_MIM6_R0_105 CAP_BOTTOM_025 VTOP R8W__A44_C1_MIM6_R0
XR8W__A44_C1_MIM6_R0_127 CAP_BOTTOM_040 VTOP R8W__A44_C1_MIM6_R0
XR8W__A44_C1_MIM6_R0_116 CAP_BOTTOM_045 VTOP R8W__A44_C1_MIM6_R0
XR8W__A44_C1_MIM6_R0_106 CAP_BOTTOM_026 VTOP R8W__A44_C1_MIM6_R0
XR8W__A44_C1_MIM6_R0_117 CAP_BOTTOM_046 VTOP R8W__A44_C1_MIM6_R0
XR8W__A44_C1_MIM6_R0_107 CAP_BOTTOM_027 VTOP R8W__A44_C1_MIM6_R0
XR8W__A44_C1_MIM6_R0_118 CAP_BOTTOM_047 VTOP R8W__A44_C1_MIM6_R0
XR8W__A44_C1_MIM6_R0_108 CAP_BOTTOM_028 VTOP R8W__A44_C1_MIM6_R0
XR8W__A44_C1_MIM6_R0_119 CAP_BOTTOM_056 VTOP R8W__A44_C1_MIM6_R0
XR8W__A44_C1_MIM6_R0_109 CAP_BOTTOM_029 VTOP R8W__A44_C1_MIM6_R0
XR8W__A44_C1_MIM6_R0_90 CAP_BOTTOM_003 VTOP R8W__A44_C1_MIM6_R0
XR8W__A44_C1_MIM6_R0_91 CAP_BOTTOM_004 VTOP R8W__A44_C1_MIM6_R0
XR8W__A44_C1_MIM6_R0_80 CAP_BOTTOM_049 VTOP R8W__A44_C1_MIM6_R0
.ends

.subckt R8W__A44_CDAC_CAP_BANK_ASSEMBLY_R8_M6 R8W__A44_SW_BANK64_SOUTH_R8_M6_0/VREFP
+ R8W__A44_SW_BANK64_NORTH_R8_M6_0/CTRL_009 R8W__A44_SW_BANK64_NORTH_R8_M6_0/CTRL_019
+ R8W__A44_SW_BANK64_NORTH_R8_M6_0/CTRL_008 R8W__A44_SW_BANK64_NORTH_R8_M6_0/CTRL_018
+ R8W__A44_SW_BANK64_NORTH_R8_M6_0/CTRL_029 R8W__A44_SW_BANK64_NORTH_R8_M6_0/CTRL_007
+ R8W__A44_SW_BANK64_NORTH_R8_M6_0/CTRL_017 R8W__A44_SW_BANK64_NORTH_R8_M6_0/CTRL_006
+ R8W__A44_SW_BANK64_NORTH_R8_M6_0/CTRL_039 R8W__A44_SW_BANK64_NORTH_R8_M6_0/CTRL_028
+ R8W__A44_SW_BANK64_SOUTH_R8_M6_0/CTRL_069 R8W__A44_SW_BANK64_SOUTH_R8_M6_0/CTRL_068
+ R8W__A44_SW_BANK64_NORTH_R8_M6_0/CTRL_005 R8W__A44_SW_BANK64_SOUTH_R8_M6_0/CTRL_079
+ R8W__A44_SW_BANK64_NORTH_R8_M6_0/CTRL_027 R8W__A44_SW_BANK64_NORTH_R8_M6_0/CTRL_016
+ R8W__A44_SW_BANK64_NORTH_R8_M6_0/CTRL_049 R8W__A44_SW_BANK64_NORTH_R8_M6_0/CTRL_038
+ R8W__A44_SW_BANK64_NORTH_R8_M6_0/CTRL_059 R8W__A44_SW_BANK64_NORTH_R8_M6_0/CTRL_026
+ R8W__A44_SW_BANK64_NORTH_R8_M6_0/CTRL_048 R8W__A44_SW_BANK64_NORTH_R8_M6_0/CTRL_037
+ R8W__A44_SW_BANK64_SOUTH_R8_M6_0/CTRL_067 R8W__A44_SW_BANK64_SOUTH_R8_M6_0/CTRL_089
+ R8W__A44_SW_BANK64_SOUTH_R8_M6_0/CTRL_078 R8W__A44_SW_BANK64_NORTH_R8_M6_0/CTRL_004
+ R8W__A44_SW_BANK64_NORTH_R8_M6_0/CTRL_015 R8W__A44_SW_BANK64_NORTH_R8_M6_0/CTRL_036
+ R8W__A44_SW_BANK64_SOUTH_R8_M6_0/CTRL_099 R8W__A44_SW_BANK64_NORTH_R8_M6_0/CTRL_025
+ R8W__A44_SW_BANK64_NORTH_R8_M6_0/CTRL_058 R8W__A44_SW_BANK64_NORTH_R8_M6_0/CTRL_014
+ R8W__A44_SW_BANK64_NORTH_R8_M6_0/CTRL_047 R8W__A44_SW_BANK64_SOUTH_R8_M6_0/CTRL_066
+ R8W__A44_SW_BANK64_SOUTH_R8_M6_0/CTRL_088 R8W__A44_SW_BANK64_SOUTH_R8_M6_0/CTRL_077
+ R8W__A44_SW_BANK64_NORTH_R8_M6_0/CTRL_003 R8W__A44_SW_BANK64_NORTH_R8_M6_0/CTRL_013
+ R8W__A44_SW_BANK64_SOUTH_R8_M6_0/CTRL_065 R8W__A44_SW_BANK64_SOUTH_R8_M6_0/CTRL_087
+ R8W__A44_SW_BANK64_SOUTH_R8_M6_0/CTRL_076 R8W__A44_SW_BANK64_NORTH_R8_M6_0/CTRL_002
+ R8W__A44_SW_BANK64_NORTH_R8_M6_0/CTRL_035 R8W__A44_SW_BANK64_SOUTH_R8_M6_0/CTRL_098
+ R8W__A44_SW_BANK64_NORTH_R8_M6_0/CTRL_024 R8W__A44_SW_BANK64_NORTH_R8_M6_0/CTRL_057
+ R8W__A44_SW_BANK64_NORTH_R8_M6_0/CTRL_046 R8W__A44_SW_BANK64_NORTH_R8_M6_0/CTRL_001
+ R8W__A44_SW_BANK64_SOUTH_R8_M6_0/CTRL_064 R8W__A44_SW_BANK64_SOUTH_R8_M6_0/CTRL_086
+ R8W__A44_SW_BANK64_SOUTH_R8_M6_0/CTRL_075 R8W__A44_SW_BANK64_SOUTH_R8_M6_0/CTRL_097
+ R8W__A44_SW_BANK64_NORTH_R8_M6_0/CTRL_023 R8W__A44_SW_BANK64_NORTH_R8_M6_0/CTRL_056
+ R8W__A44_SW_BANK64_NORTH_R8_M6_0/CTRL_012 R8W__A44_SW_BANK64_NORTH_R8_M6_0/CTRL_045
+ R8W__A44_SW_BANK64_NORTH_R8_M6_0/CTRL_034 R8W__A44_SW_BANK64_NORTH_R8_M6_0/CTRL_055
+ R8W__A44_SW_BANK64_NORTH_R8_M6_0/CTRL_044 R8W__A44_SW_BANK64_NORTH_R8_M6_0/CTRL_022
+ R8W__A44_SW_BANK64_SOUTH_R8_M6_0/CTRL_096 R8W__A44_SW_BANK64_SOUTH_R8_M6_0/CTRL_085
+ R8W__A44_SW_BANK64_SOUTH_R8_M6_0/CTRL_074 R8W__A44_SW_BANK64_NORTH_R8_M6_0/CTRL_000
+ R8W__A44_SW_BANK64_NORTH_R8_M6_0/CTRL_033 R8W__A44_SW_BANK64_NORTH_R8_M6_0/CTRL_011
+ R8W__A44_SW_BANK64_NORTH_R8_M6_0/CTRL_032 R8W__A44_SW_BANK64_SOUTH_R8_M6_0/CTRL_095
+ R8W__A44_SW_BANK64_NORTH_R8_M6_0/CTRL_021 R8W__A44_SW_BANK64_NORTH_R8_M6_0/CTRL_054
+ R8W__A44_SW_BANK64_NORTH_R8_M6_0/CTRL_010 R8W__A44_SW_BANK64_NORTH_R8_M6_0/CTRL_043
+ R8W__A44_SW_BANK64_SOUTH_R8_M6_0/CTRL_084 R8W__A44_SW_BANK64_SOUTH_R8_M6_0/CTRL_073
+ R8W__A44_SW_BANK64_SOUTH_R8_M6_0/CTRL_094 R8W__A44_SW_BANK64_SOUTH_R8_M6_0/CTRL_083
+ R8W__A44_SW_BANK64_SOUTH_R8_M6_0/CTRL_072 R8W__A44_SW_BANK64_NORTH_R8_M6_0/CTRL_031
+ R8W__A44_SW_BANK64_NORTH_R8_M6_0/CTRL_020 R8W__A44_SW_BANK64_NORTH_R8_M6_0/CTRL_053
+ R8W__A44_SW_BANK64_NORTH_R8_M6_0/CTRL_042 R8W__A44_SW_BANK64_SOUTH_R8_M6_0/CTRL_082
+ R8W__A44_SW_BANK64_NORTH_R8_M6_0/CTRL_063 R8W__A44_SW_BANK64_NORTH_R8_M6_0/CTRL_030
+ R8W__A44_SW_BANK64_SOUTH_R8_M6_0/CTRL_071 R8W__A44_SW_BANK64_SOUTH_R8_M6_0/CTRL_093
+ R8W__A44_SW_BANK64_NORTH_R8_M6_0/CTRL_052 R8W__A44_SW_BANK64_NORTH_R8_M6_0/CTRL_041
+ R8W__A44_SW_BANK64_NORTH_R8_M6_0/CTRL_051 R8W__A44_SW_BANK64_NORTH_R8_M6_0/CTRL_040
+ R8W__A44_SW_BANK64_SOUTH_R8_M6_0/CTRL_081 R8W__A44_SW_BANK64_NORTH_R8_M6_0/CTRL_062
+ R8W__A44_SW_BANK64_SOUTH_R8_M6_0/CTRL_070 R8W__A44_SW_BANK64_SOUTH_R8_M6_0/CTRL_092
+ R8W__A44_SW_BANK64_NORTH_R8_M6_0/VREFP R8W__A44_SW_BANK64_NORTH_R8_M6_0/CTRL_050
+ R8W__A44_SW_BANK64_NORTH_R8_M6_0/CTRL_061 R8W__A44_SW_BANK64_SOUTH_R8_M6_0/CTRL_091
+ R8W__A44_SW_BANK64_SOUTH_R8_M6_0/CTRL_080 R8W__A44_SW_BANK64_SOUTH_R8_M6_0/CTRL_090
+ R8W__A44_SW_BANK64_NORTH_R8_M6_0/CTRL_060 R8W__A44_SW_BANK64_NORTH_R8_M6_0/VREFN
+ R8W__A44_SW_BANK64_SOUTH_R8_M6_0/CTRL_109 R8W__A44_SW_BANK64_SOUTH_R8_M6_0/CTRL_108
+ R8W__A44_SW_BANK64_SOUTH_R8_M6_0/CTRL_119 R8W__A44_SW_BANK64_SOUTH_R8_M6_0/CTRL_118
+ R8W__A44_SW_BANK64_SOUTH_R8_M6_0/CTRL_107 R8W__A44_SW_BANK64_SOUTH_R8_M6_0/CTRL_117
+ R8W__A44_SW_BANK64_SOUTH_R8_M6_0/CTRL_106 R8W__A44_SW_BANK64_SOUTH_R8_M6_0/CTRL_116
+ R8W__A44_SW_BANK64_SOUTH_R8_M6_0/CTRL_105 R8W__A44_SW_BANK64_NORTH_R8_M6_0/VDD R8W__A44_SW_BANK64_SOUTH_R8_M6_0/CTRL_104
+ R8W__A44_SW_BANK64_SOUTH_R8_M6_0/CTRL_126 R8W__A44_SW_BANK64_SOUTH_R8_M6_0/CTRL_115
+ R8W__A44_SW_BANK64_SOUTH_R8_M6_0/CTRL_125 R8W__A44_SW_BANK64_SOUTH_R8_M6_0/CTRL_114
+ R8W__A44_SW_BANK64_SOUTH_R8_M6_0/CTRL_103 R8W__A44_SW_BANK64_SOUTH_R8_M6_0/CTRL_113
+ R8W__A44_SW_BANK64_SOUTH_R8_M6_0/CTRL_124 R8W__A44_SW_BANK64_SOUTH_R8_M6_0/CTRL_102
+ R8W__A44_SW_BANK64_SOUTH_R8_M6_0/CTRL_112 R8W__A44_SW_BANK64_SOUTH_R8_M6_0/CTRL_101
+ R8W__A44_SW_BANK64_SOUTH_R8_M6_0/VREFN R8W__A44_SW_BANK64_SOUTH_R8_M6_0/CTRL_123
+ R8W__A44_SW_BANK64_SOUTH_R8_M6_0/CTRL_100 R8W__A44_SW_BANK64_SOUTH_R8_M6_0/CTRL_122
+ R8W__A44_SW_BANK64_SOUTH_R8_M6_0/CTRL_111 R8W__A44_SW_BANK64_SOUTH_R8_M6_0/CTRL_121
+ R8W__A44_SW_BANK64_SOUTH_R8_M6_0/CTRL_110 R8W__A44_SW_BANK64_SOUTH_R8_M6_0/VDD R8W__A44_SW_BANK64_SOUTH_R8_M6_0/CTRL_120
+ VSUBS VTOP
XR8W__A44_SW_BANK64_NORTH_R8_M6_0 R8W__A44_SW_BANK64_NORTH_R8_M6_0/CTRL_008 R8W__A44_SW_BANK64_NORTH_R8_M6_0/CTRL_024
+ R8W__A44_SW_BANK64_NORTH_R8_M6_0/CTRL_040 R8W__A44_SW_BANK64_NORTH_R8_M6_0/CTRL_056
+ R8W__A44_SW_BANK64_NORTH_R8_M6_0/CTRL_009 R8W__A44_SW_BANK64_NORTH_R8_M6_0/CTRL_025
+ R8W__A44_SW_BANK64_NORTH_R8_M6_0/CTRL_041 R8W__A44_SW_BANK64_NORTH_R8_M6_0/CTRL_057
+ R8W__A44_SW_BANK64_NORTH_R8_M6_0/CTRL_010 R8W__A44_SW_BANK64_NORTH_R8_M6_0/CTRL_026
+ R8W__A44_SW_BANK64_NORTH_R8_M6_0/CTRL_042 R8W__A44_SW_BANK64_NORTH_R8_M6_0/CTRL_058
+ R8W__A44_SW_BANK64_NORTH_R8_M6_0/CTRL_011 R8W__A44_SW_BANK64_NORTH_R8_M6_0/CTRL_027
+ R8W__A44_SW_BANK64_NORTH_R8_M6_0/CTRL_043 R8W__A44_SW_BANK64_NORTH_R8_M6_0/CTRL_059
+ R8W__A44_SW_BANK64_NORTH_R8_M6_0/CTRL_012 R8W__A44_SW_BANK64_NORTH_R8_M6_0/CTRL_028
+ R8W__A44_SW_BANK64_NORTH_R8_M6_0/CTRL_044 R8W__A44_SW_BANK64_NORTH_R8_M6_0/CTRL_060
+ R8W__A44_SW_BANK64_NORTH_R8_M6_0/CTRL_013 R8W__A44_SW_BANK64_NORTH_R8_M6_0/CTRL_029
+ R8W__A44_SW_BANK64_NORTH_R8_M6_0/CTRL_045 R8W__A44_SW_BANK64_NORTH_R8_M6_0/CTRL_061
+ R8W__A44_SW_BANK64_NORTH_R8_M6_0/CTRL_014 R8W__A44_SW_BANK64_NORTH_R8_M6_0/CTRL_030
+ R8W__A44_SW_BANK64_NORTH_R8_M6_0/CTRL_046 R8W__A44_SW_BANK64_NORTH_R8_M6_0/CTRL_062
+ R8W__A44_SW_BANK64_NORTH_R8_M6_0/CTRL_015 R8W__A44_SW_BANK64_NORTH_R8_M6_0/CTRL_031
+ R8W__A44_SW_BANK64_NORTH_R8_M6_0/CTRL_047 R8W__A44_SW_BANK64_NORTH_R8_M6_0/CTRL_063
+ R8W__A44_SW_BANK64_NORTH_R8_M6_0/CTRL_000 R8W__A44_SW_BANK64_NORTH_R8_M6_0/CTRL_016
+ R8W__A44_SW_BANK64_NORTH_R8_M6_0/CTRL_032 R8W__A44_SW_BANK64_NORTH_R8_M6_0/CTRL_048
+ R8W__A44_SW_BANK64_NORTH_R8_M6_0/CTRL_001 R8W__A44_SW_BANK64_NORTH_R8_M6_0/CTRL_017
+ R8W__A44_SW_BANK64_NORTH_R8_M6_0/CTRL_033 R8W__A44_SW_BANK64_NORTH_R8_M6_0/CTRL_049
+ R8W__A44_SW_BANK64_NORTH_R8_M6_0/CTRL_002 R8W__A44_SW_BANK64_NORTH_R8_M6_0/CTRL_018
+ R8W__A44_SW_BANK64_NORTH_R8_M6_0/CTRL_034 R8W__A44_SW_BANK64_NORTH_R8_M6_0/CTRL_050
+ R8W__A44_SW_BANK64_NORTH_R8_M6_0/CTRL_003 R8W__A44_SW_BANK64_NORTH_R8_M6_0/CTRL_019
+ R8W__A44_SW_BANK64_NORTH_R8_M6_0/CTRL_035 R8W__A44_SW_BANK64_NORTH_R8_M6_0/CTRL_051
+ R8W__A44_SW_BANK64_NORTH_R8_M6_0/CTRL_004 R8W__A44_SW_BANK64_NORTH_R8_M6_0/CTRL_020
+ R8W__A44_SW_BANK64_NORTH_R8_M6_0/CTRL_036 R8W__A44_SW_BANK64_NORTH_R8_M6_0/CTRL_052
+ R8W__A44_SW_BANK64_NORTH_R8_M6_0/CTRL_005 R8W__A44_SW_BANK64_NORTH_R8_M6_0/CTRL_021
+ R8W__A44_SW_BANK64_NORTH_R8_M6_0/CTRL_037 R8W__A44_SW_BANK64_NORTH_R8_M6_0/CTRL_053
+ R8W__A44_SW_BANK64_NORTH_R8_M6_0/CTRL_006 R8W__A44_SW_BANK64_NORTH_R8_M6_0/CTRL_022
+ R8W__A44_SW_BANK64_NORTH_R8_M6_0/CTRL_038 R8W__A44_SW_BANK64_NORTH_R8_M6_0/CTRL_054
+ R8W__A44_SW_BANK64_NORTH_R8_M6_0/CTRL_007 R8W__A44_SW_BANK64_NORTH_R8_M6_0/CTRL_023
+ R8W__A44_SW_BANK64_NORTH_R8_M6_0/CTRL_039 R8W__A44_SW_BANK64_NORTH_R8_M6_0/CTRL_055
+ R8W__A44_CAP_CORE128_M6_R1_0/CAP_BOTTOM_004 R8W__A44_CAP_CORE128_M6_R1_0/CAP_BOTTOM_002
+ R8W__A44_CAP_CORE128_M6_R1_0/CAP_BOTTOM_020 R8W__A44_CAP_CORE128_M6_R1_0/CAP_BOTTOM_001
+ R8W__A44_CAP_CORE128_M6_R1_0/CAP_BOTTOM_036 R8W__A44_CAP_CORE128_M6_R1_0/CAP_BOTTOM_018
+ R8W__A44_CAP_CORE128_M6_R1_0/CAP_BOTTOM_052 R8W__A44_CAP_CORE128_M6_R1_0/CAP_BOTTOM_032
+ R8W__A44_CAP_CORE128_M6_R1_0/CAP_BOTTOM_005 R8W__A44_CAP_CORE128_M6_R1_0/CAP_BOTTOM_034
+ R8W__A44_CAP_CORE128_M6_R1_0/CAP_BOTTOM_021 R8W__A44_CAP_CORE128_M6_R1_0/CAP_BOTTOM_017
+ R8W__A44_CAP_CORE128_M6_R1_0/CAP_BOTTOM_037 R8W__A44_CAP_CORE128_M6_R1_0/CAP_BOTTOM_050
+ R8W__A44_CAP_CORE128_M6_R1_0/CAP_BOTTOM_053 R8W__A44_CAP_CORE128_M6_R1_0/CAP_BOTTOM_016
+ R8W__A44_CAP_CORE128_M6_R1_0/CAP_BOTTOM_006 R8W__A44_CAP_CORE128_M6_R1_0/CAP_BOTTOM_003
+ R8W__A44_CAP_CORE128_M6_R1_0/CAP_BOTTOM_022 R8W__A44_CAP_CORE128_M6_R1_0/CAP_BOTTOM_033
+ R8W__A44_CAP_CORE128_M6_R1_0/CAP_BOTTOM_038 R8W__A44_CAP_CORE128_M6_R1_0/CAP_BOTTOM_019
+ R8W__A44_CAP_CORE128_M6_R1_0/CAP_BOTTOM_054 R8W__A44_CAP_CORE128_M6_R1_0/CAP_BOTTOM_048
+ R8W__A44_CAP_CORE128_M6_R1_0/CAP_BOTTOM_007 R8W__A44_CAP_CORE128_M6_R1_0/CAP_BOTTOM_035
+ R8W__A44_CAP_CORE128_M6_R1_0/CAP_BOTTOM_023 R8W__A44_CAP_CORE128_M6_R1_0/CAP_BOTTOM_049
+ R8W__A44_CAP_CORE128_M6_R1_0/CAP_BOTTOM_039 R8W__A44_CAP_CORE128_M6_R1_0/CAP_BOTTOM_051
+ R8W__A44_CAP_CORE128_M6_R1_0/CAP_BOTTOM_000 R8W__A44_CAP_CORE128_M6_R1_0/CAP_BOTTOM_012
+ R8W__A44_CAP_CORE128_M6_R1_0/CAP_BOTTOM_010 R8W__A44_CAP_CORE128_M6_R1_0/CAP_BOTTOM_028
+ R8W__A44_CAP_CORE128_M6_R1_0/CAP_BOTTOM_009 R8W__A44_CAP_CORE128_M6_R1_0/CAP_BOTTOM_044
+ R8W__A44_CAP_CORE128_M6_R1_0/CAP_BOTTOM_026 R8W__A44_CAP_CORE128_M6_R1_0/CAP_BOTTOM_060
+ R8W__A44_CAP_CORE128_M6_R1_0/CAP_BOTTOM_040 R8W__A44_CAP_CORE128_M6_R1_0/CAP_BOTTOM_013
+ R8W__A44_CAP_CORE128_M6_R1_0/CAP_BOTTOM_042 R8W__A44_CAP_CORE128_M6_R1_0/CAP_BOTTOM_025
+ R8W__A44_CAP_CORE128_M6_R1_0/CAP_BOTTOM_045 R8W__A44_CAP_CORE128_M6_R1_0/CAP_BOTTOM_058
+ R8W__A44_CAP_CORE128_M6_R1_0/CAP_BOTTOM_061 R8W__A44_CAP_CORE128_M6_R1_0/CAP_BOTTOM_024
+ R8W__A44_CAP_CORE128_M6_R1_0/CAP_BOTTOM_014 R8W__A44_CAP_CORE128_M6_R1_0/CAP_BOTTOM_011
+ R8W__A44_CAP_CORE128_M6_R1_0/CAP_BOTTOM_030 R8W__A44_CAP_CORE128_M6_R1_0/CAP_BOTTOM_041
+ R8W__A44_CAP_CORE128_M6_R1_0/CAP_BOTTOM_046 R8W__A44_CAP_CORE128_M6_R1_0/CAP_BOTTOM_027
+ R8W__A44_CAP_CORE128_M6_R1_0/CAP_BOTTOM_062 R8W__A44_CAP_CORE128_M6_R1_0/CAP_BOTTOM_056
+ R8W__A44_CAP_CORE128_M6_R1_0/CAP_BOTTOM_015 R8W__A44_CAP_CORE128_M6_R1_0/CAP_BOTTOM_043
+ R8W__A44_CAP_CORE128_M6_R1_0/CAP_BOTTOM_031 R8W__A44_CAP_CORE128_M6_R1_0/CAP_BOTTOM_057
+ R8W__A44_CAP_CORE128_M6_R1_0/CAP_BOTTOM_047 R8W__A44_CAP_CORE128_M6_R1_0/CAP_BOTTOM_059
+ R8W__A44_CAP_CORE128_M6_R1_0/CAP_BOTTOM_063 R8W__A44_CAP_CORE128_M6_R1_0/CAP_BOTTOM_008
+ R8W__A44_SW_BANK64_NORTH_R8_M6_0/VREFN R8W__A44_SW_BANK64_NORTH_R8_M6_0/VREFP R8W__A44_SW_BANK64_NORTH_R8_M6_0/VDD
+ R8W__A44_CAP_CORE128_M6_R1_0/CAP_BOTTOM_055 R8W__A44_CAP_CORE128_M6_R1_0/CAP_BOTTOM_029
+ VSUBS R8W__A44_SW_BANK64_NORTH_R8_M6
XR8W__A44_SW_BANK64_SOUTH_R8_M6_0 R8W__A44_CAP_CORE128_M6_R1_0/CAP_BOTTOM_087 R8W__A44_CAP_CORE128_M6_R1_0/CAP_BOTTOM_103
+ R8W__A44_CAP_CORE128_M6_R1_0/CAP_BOTTOM_119 R8W__A44_CAP_CORE128_M6_R1_0/CAP_BOTTOM_072
+ R8W__A44_CAP_CORE128_M6_R1_0/CAP_BOTTOM_088 R8W__A44_CAP_CORE128_M6_R1_0/CAP_BOTTOM_104
+ R8W__A44_CAP_CORE128_M6_R1_0/CAP_BOTTOM_120 R8W__A44_CAP_CORE128_M6_R1_0/CAP_BOTTOM_073
+ R8W__A44_CAP_CORE128_M6_R1_0/CAP_BOTTOM_089 R8W__A44_CAP_CORE128_M6_R1_0/CAP_BOTTOM_105
+ R8W__A44_CAP_CORE128_M6_R1_0/CAP_BOTTOM_121 R8W__A44_CAP_CORE128_M6_R1_0/CAP_BOTTOM_074
+ R8W__A44_CAP_CORE128_M6_R1_0/CAP_BOTTOM_090 R8W__A44_CAP_CORE128_M6_R1_0/CAP_BOTTOM_106
+ R8W__A44_CAP_CORE128_M6_R1_0/CAP_BOTTOM_122 R8W__A44_CAP_CORE128_M6_R1_0/CAP_BOTTOM_075
+ R8W__A44_CAP_CORE128_M6_R1_0/CAP_BOTTOM_091 R8W__A44_CAP_CORE128_M6_R1_0/CAP_BOTTOM_107
+ R8W__A44_CAP_CORE128_M6_R1_0/CAP_BOTTOM_123 R8W__A44_CAP_CORE128_M6_R1_0/CAP_BOTTOM_076
+ R8W__A44_CAP_CORE128_M6_R1_0/CAP_BOTTOM_092 R8W__A44_CAP_CORE128_M6_R1_0/CAP_BOTTOM_108
+ R8W__A44_CAP_CORE128_M6_R1_0/CAP_BOTTOM_124 R8W__A44_CAP_CORE128_M6_R1_0/CAP_BOTTOM_077
+ R8W__A44_CAP_CORE128_M6_R1_0/CAP_BOTTOM_093 R8W__A44_CAP_CORE128_M6_R1_0/CAP_BOTTOM_109
+ R8W__A44_CAP_CORE128_M6_R1_0/CAP_BOTTOM_125 R8W__A44_CAP_CORE128_M6_R1_0/CAP_BOTTOM_078
+ R8W__A44_CAP_CORE128_M6_R1_0/CAP_BOTTOM_094 R8W__A44_CAP_CORE128_M6_R1_0/CAP_BOTTOM_110
+ R8W__A44_CAP_CORE128_M6_R1_0/CAP_BOTTOM_126 R8W__A44_CAP_CORE128_M6_R1_0/CAP_BOTTOM_064
+ R8W__A44_CAP_CORE128_M6_R1_0/CAP_BOTTOM_079 R8W__A44_CAP_CORE128_M6_R1_0/CAP_BOTTOM_095
+ R8W__A44_CAP_CORE128_M6_R1_0/CAP_BOTTOM_111 R8W__A44_CAP_CORE128_M6_R1_0/CAP_BOTTOM_065
+ R8W__A44_CAP_CORE128_M6_R1_0/CAP_BOTTOM_080 R8W__A44_CAP_CORE128_M6_R1_0/CAP_BOTTOM_096
+ R8W__A44_CAP_CORE128_M6_R1_0/CAP_BOTTOM_112 R8W__A44_CAP_CORE128_M6_R1_0/CAP_BOTTOM_066
+ R8W__A44_CAP_CORE128_M6_R1_0/CAP_BOTTOM_081 R8W__A44_CAP_CORE128_M6_R1_0/CAP_BOTTOM_097
+ R8W__A44_CAP_CORE128_M6_R1_0/CAP_BOTTOM_113 R8W__A44_CAP_CORE128_M6_R1_0/CAP_BOTTOM_067
+ R8W__A44_CAP_CORE128_M6_R1_0/CAP_BOTTOM_082 R8W__A44_CAP_CORE128_M6_R1_0/CAP_BOTTOM_098
+ R8W__A44_CAP_CORE128_M6_R1_0/CAP_BOTTOM_114 R8W__A44_CAP_CORE128_M6_R1_0/CAP_BOTTOM_068
+ R8W__A44_CAP_CORE128_M6_R1_0/CAP_BOTTOM_083 R8W__A44_CAP_CORE128_M6_R1_0/CAP_BOTTOM_099
+ R8W__A44_CAP_CORE128_M6_R1_0/CAP_BOTTOM_115 R8W__A44_CAP_CORE128_M6_R1_0/CAP_BOTTOM_069
+ R8W__A44_CAP_CORE128_M6_R1_0/CAP_BOTTOM_084 R8W__A44_CAP_CORE128_M6_R1_0/CAP_BOTTOM_100
+ R8W__A44_CAP_CORE128_M6_R1_0/CAP_BOTTOM_116 R8W__A44_CAP_CORE128_M6_R1_0/CAP_BOTTOM_070
+ R8W__A44_CAP_CORE128_M6_R1_0/CAP_BOTTOM_085 R8W__A44_CAP_CORE128_M6_R1_0/CAP_BOTTOM_101
+ R8W__A44_CAP_CORE128_M6_R1_0/CAP_BOTTOM_117 R8W__A44_CAP_CORE128_M6_R1_0/CAP_BOTTOM_071
+ R8W__A44_CAP_CORE128_M6_R1_0/CAP_BOTTOM_086 R8W__A44_CAP_CORE128_M6_R1_0/CAP_BOTTOM_102
+ R8W__A44_CAP_CORE128_M6_R1_0/CAP_BOTTOM_118 R8W__A44_SW_BANK64_SOUTH_R8_M6_0/CTRL_064
+ R8W__A44_SW_BANK64_SOUTH_R8_M6_0/CTRL_068 R8W__A44_SW_BANK64_SOUTH_R8_M6_0/CTRL_066
+ R8W__A44_SW_BANK64_SOUTH_R8_M6_0/CTRL_083 R8W__A44_SW_BANK64_SOUTH_R8_M6_0/CTRL_065
+ R8W__A44_SW_BANK64_SOUTH_R8_M6_0/CTRL_099 R8W__A44_SW_BANK64_SOUTH_R8_M6_0/CTRL_081
+ R8W__A44_SW_BANK64_SOUTH_R8_M6_0/CTRL_115 R8W__A44_SW_BANK64_SOUTH_R8_M6_0/CTRL_095
+ R8W__A44_SW_BANK64_SOUTH_R8_M6_0/CTRL_069 R8W__A44_SW_BANK64_SOUTH_R8_M6_0/CTRL_097
+ R8W__A44_SW_BANK64_SOUTH_R8_M6_0/CTRL_084 R8W__A44_SW_BANK64_SOUTH_R8_M6_0/CTRL_080
+ R8W__A44_SW_BANK64_SOUTH_R8_M6_0/CTRL_100 R8W__A44_SW_BANK64_SOUTH_R8_M6_0/CTRL_113
+ R8W__A44_SW_BANK64_SOUTH_R8_M6_0/CTRL_116 R8W__A44_SW_BANK64_SOUTH_R8_M6_0/CTRL_079
+ R8W__A44_SW_BANK64_SOUTH_R8_M6_0/CTRL_070 R8W__A44_SW_BANK64_SOUTH_R8_M6_0/CTRL_067
+ R8W__A44_SW_BANK64_SOUTH_R8_M6_0/CTRL_085 R8W__A44_SW_BANK64_SOUTH_R8_M6_0/CTRL_096
+ R8W__A44_SW_BANK64_SOUTH_R8_M6_0/CTRL_101 R8W__A44_SW_BANK64_SOUTH_R8_M6_0/CTRL_082
+ R8W__A44_SW_BANK64_SOUTH_R8_M6_0/CTRL_117 R8W__A44_SW_BANK64_SOUTH_R8_M6_0/CTRL_111
+ R8W__A44_SW_BANK64_SOUTH_R8_M6_0/CTRL_071 R8W__A44_SW_BANK64_SOUTH_R8_M6_0/CTRL_098
+ R8W__A44_SW_BANK64_SOUTH_R8_M6_0/CTRL_086 R8W__A44_SW_BANK64_SOUTH_R8_M6_0/CTRL_112
+ R8W__A44_SW_BANK64_SOUTH_R8_M6_0/CTRL_102 R8W__A44_SW_BANK64_SOUTH_R8_M6_0/CTRL_114
+ R8W__A44_SW_BANK64_SOUTH_R8_M6_0/CTRL_118 R8W__A44_SW_BANK64_SOUTH_R8_M6_0/CTRL_075
+ R8W__A44_SW_BANK64_SOUTH_R8_M6_0/CTRL_087 R8W__A44_SW_BANK64_SOUTH_R8_M6_0/CTRL_091
+ R8W__A44_SW_BANK64_SOUTH_R8_M6_0/CTRL_089 R8W__A44_SW_BANK64_SOUTH_R8_M6_0/CTRL_107
+ R8W__A44_SW_BANK64_SOUTH_R8_M6_0/CTRL_088 R8W__A44_SW_BANK64_SOUTH_R8_M6_0/CTRL_123
+ R8W__A44_SW_BANK64_SOUTH_R8_M6_0/CTRL_105 R8W__A44_SW_BANK64_SOUTH_R8_M6_0/CTRL_076
+ R8W__A44_SW_BANK64_SOUTH_R8_M6_0/CTRL_119 R8W__A44_SW_BANK64_SOUTH_R8_M6_0/CTRL_092
+ R8W__A44_SW_BANK64_SOUTH_R8_M6_0/CTRL_121 R8W__A44_SW_BANK64_SOUTH_R8_M6_0/CTRL_108
+ R8W__A44_SW_BANK64_SOUTH_R8_M6_0/CTRL_104 R8W__A44_SW_BANK64_SOUTH_R8_M6_0/CTRL_124
+ R8W__A44_SW_BANK64_SOUTH_R8_M6_0/CTRL_074 R8W__A44_SW_BANK64_SOUTH_R8_M6_0/CTRL_077
+ R8W__A44_SW_BANK64_SOUTH_R8_M6_0/CTRL_103 R8W__A44_SW_BANK64_SOUTH_R8_M6_0/CTRL_093
+ R8W__A44_SW_BANK64_SOUTH_R8_M6_0/CTRL_090 R8W__A44_SW_BANK64_SOUTH_R8_M6_0/CTRL_109
+ R8W__A44_SW_BANK64_SOUTH_R8_M6_0/CTRL_120 R8W__A44_SW_BANK64_SOUTH_R8_M6_0/CTRL_125
+ R8W__A44_SW_BANK64_SOUTH_R8_M6_0/CTRL_106 R8W__A44_SW_BANK64_SOUTH_R8_M6_0/CTRL_078
+ R8W__A44_SW_BANK64_SOUTH_R8_M6_0/CTRL_072 R8W__A44_SW_BANK64_SOUTH_R8_M6_0/CTRL_094
+ R8W__A44_SW_BANK64_SOUTH_R8_M6_0/CTRL_122 R8W__A44_SW_BANK64_SOUTH_R8_M6_0/CTRL_110
+ R8W__A44_SW_BANK64_SOUTH_R8_M6_0/CTRL_073 R8W__A44_SW_BANK64_SOUTH_R8_M6_0/CTRL_126
+ R8W__A44_SW_BANK64_SOUTH_R8_M6_0/VREFN R8W__A44_SW_BANK64_SOUTH_R8_M6_0/VREFP R8W__A44_SW_BANK64_SOUTH_R8_M6_0/VDD
+ VSUBS R8W__A44_SW_BANK64_SOUTH_R8_M6
XR8W__A44_CAP_CORE128_M6_R1_0 R8W__A44_CAP_CORE128_M6_R1_0/CAP_BOTTOM_008 R8W__A44_CAP_CORE128_M6_R1_0/CAP_BOTTOM_009
+ R8W__A44_CAP_CORE128_M6_R1_0/CAP_BOTTOM_010 R8W__A44_CAP_CORE128_M6_R1_0/CAP_BOTTOM_011
+ R8W__A44_CAP_CORE128_M6_R1_0/CAP_BOTTOM_012 R8W__A44_CAP_CORE128_M6_R1_0/CAP_BOTTOM_013
+ R8W__A44_CAP_CORE128_M6_R1_0/CAP_BOTTOM_014 R8W__A44_CAP_CORE128_M6_R1_0/CAP_BOTTOM_015
+ R8W__A44_CAP_CORE128_M6_R1_0/CAP_BOTTOM_024 R8W__A44_CAP_CORE128_M6_R1_0/CAP_BOTTOM_025
+ R8W__A44_CAP_CORE128_M6_R1_0/CAP_BOTTOM_026 R8W__A44_CAP_CORE128_M6_R1_0/CAP_BOTTOM_027
+ R8W__A44_CAP_CORE128_M6_R1_0/CAP_BOTTOM_028 R8W__A44_CAP_CORE128_M6_R1_0/CAP_BOTTOM_029
+ R8W__A44_CAP_CORE128_M6_R1_0/CAP_BOTTOM_030 R8W__A44_CAP_CORE128_M6_R1_0/CAP_BOTTOM_031
+ R8W__A44_CAP_CORE128_M6_R1_0/CAP_BOTTOM_040 R8W__A44_CAP_CORE128_M6_R1_0/CAP_BOTTOM_041
+ R8W__A44_CAP_CORE128_M6_R1_0/CAP_BOTTOM_042 R8W__A44_CAP_CORE128_M6_R1_0/CAP_BOTTOM_043
+ R8W__A44_CAP_CORE128_M6_R1_0/CAP_BOTTOM_044 R8W__A44_CAP_CORE128_M6_R1_0/CAP_BOTTOM_045
+ R8W__A44_CAP_CORE128_M6_R1_0/CAP_BOTTOM_046 R8W__A44_CAP_CORE128_M6_R1_0/CAP_BOTTOM_047
+ R8W__A44_CAP_CORE128_M6_R1_0/CAP_BOTTOM_056 R8W__A44_CAP_CORE128_M6_R1_0/CAP_BOTTOM_057
+ R8W__A44_CAP_CORE128_M6_R1_0/CAP_BOTTOM_058 R8W__A44_CAP_CORE128_M6_R1_0/CAP_BOTTOM_059
+ R8W__A44_CAP_CORE128_M6_R1_0/CAP_BOTTOM_060 R8W__A44_CAP_CORE128_M6_R1_0/CAP_BOTTOM_061
+ R8W__A44_CAP_CORE128_M6_R1_0/CAP_BOTTOM_062 R8W__A44_CAP_CORE128_M6_R1_0/CAP_BOTTOM_063
+ R8W__A44_CAP_CORE128_M6_R1_0/CAP_BOTTOM_032 R8W__A44_CAP_CORE128_M6_R1_0/CAP_BOTTOM_033
+ R8W__A44_CAP_CORE128_M6_R1_0/CAP_BOTTOM_034 R8W__A44_CAP_CORE128_M6_R1_0/CAP_BOTTOM_035
+ R8W__A44_CAP_CORE128_M6_R1_0/CAP_BOTTOM_036 R8W__A44_CAP_CORE128_M6_R1_0/CAP_BOTTOM_037
+ R8W__A44_CAP_CORE128_M6_R1_0/CAP_BOTTOM_038 R8W__A44_CAP_CORE128_M6_R1_0/CAP_BOTTOM_039
+ R8W__A44_CAP_CORE128_M6_R1_0/CAP_BOTTOM_016 R8W__A44_CAP_CORE128_M6_R1_0/CAP_BOTTOM_017
+ R8W__A44_CAP_CORE128_M6_R1_0/CAP_BOTTOM_018 R8W__A44_CAP_CORE128_M6_R1_0/CAP_BOTTOM_019
+ R8W__A44_CAP_CORE128_M6_R1_0/CAP_BOTTOM_020 R8W__A44_CAP_CORE128_M6_R1_0/CAP_BOTTOM_021
+ R8W__A44_CAP_CORE128_M6_R1_0/CAP_BOTTOM_022 R8W__A44_CAP_CORE128_M6_R1_0/CAP_BOTTOM_023
+ R8W__A44_CAP_CORE128_M6_R1_0/CAP_BOTTOM_048 R8W__A44_CAP_CORE128_M6_R1_0/CAP_BOTTOM_049
+ R8W__A44_CAP_CORE128_M6_R1_0/CAP_BOTTOM_050 R8W__A44_CAP_CORE128_M6_R1_0/CAP_BOTTOM_051
+ R8W__A44_CAP_CORE128_M6_R1_0/CAP_BOTTOM_052 R8W__A44_CAP_CORE128_M6_R1_0/CAP_BOTTOM_053
+ R8W__A44_CAP_CORE128_M6_R1_0/CAP_BOTTOM_054 R8W__A44_CAP_CORE128_M6_R1_0/CAP_BOTTOM_055
+ R8W__A44_CAP_CORE128_M6_R1_0/CAP_BOTTOM_000 R8W__A44_CAP_CORE128_M6_R1_0/CAP_BOTTOM_001
+ R8W__A44_CAP_CORE128_M6_R1_0/CAP_BOTTOM_002 R8W__A44_CAP_CORE128_M6_R1_0/CAP_BOTTOM_003
+ R8W__A44_CAP_CORE128_M6_R1_0/CAP_BOTTOM_004 R8W__A44_CAP_CORE128_M6_R1_0/CAP_BOTTOM_005
+ R8W__A44_CAP_CORE128_M6_R1_0/CAP_BOTTOM_006 R8W__A44_CAP_CORE128_M6_R1_0/CAP_BOTTOM_007
+ R8W__A44_CAP_CORE128_M6_R1_0/CAP_BOTTOM_064 R8W__A44_CAP_CORE128_M6_R1_0/CAP_BOTTOM_065
+ R8W__A44_CAP_CORE128_M6_R1_0/CAP_BOTTOM_066 R8W__A44_CAP_CORE128_M6_R1_0/CAP_BOTTOM_067
+ R8W__A44_CAP_CORE128_M6_R1_0/CAP_BOTTOM_068 R8W__A44_CAP_CORE128_M6_R1_0/CAP_BOTTOM_069
+ R8W__A44_CAP_CORE128_M6_R1_0/CAP_BOTTOM_070 R8W__A44_CAP_CORE128_M6_R1_0/CAP_BOTTOM_071
+ R8W__A44_CAP_CORE128_M6_R1_0/CAP_BOTTOM_079 R8W__A44_CAP_CORE128_M6_R1_0/CAP_BOTTOM_080
+ R8W__A44_CAP_CORE128_M6_R1_0/CAP_BOTTOM_081 R8W__A44_CAP_CORE128_M6_R1_0/CAP_BOTTOM_082
+ R8W__A44_CAP_CORE128_M6_R1_0/CAP_BOTTOM_083 R8W__A44_CAP_CORE128_M6_R1_0/CAP_BOTTOM_084
+ R8W__A44_CAP_CORE128_M6_R1_0/CAP_BOTTOM_085 R8W__A44_CAP_CORE128_M6_R1_0/CAP_BOTTOM_086
+ R8W__A44_CAP_CORE128_M6_R1_0/CAP_BOTTOM_095 R8W__A44_CAP_CORE128_M6_R1_0/CAP_BOTTOM_096
+ R8W__A44_CAP_CORE128_M6_R1_0/CAP_BOTTOM_097 R8W__A44_CAP_CORE128_M6_R1_0/CAP_BOTTOM_098
+ R8W__A44_CAP_CORE128_M6_R1_0/CAP_BOTTOM_099 R8W__A44_CAP_CORE128_M6_R1_0/CAP_BOTTOM_100
+ R8W__A44_CAP_CORE128_M6_R1_0/CAP_BOTTOM_101 R8W__A44_CAP_CORE128_M6_R1_0/CAP_BOTTOM_102
+ R8W__A44_CAP_CORE128_M6_R1_0/CAP_BOTTOM_111 R8W__A44_CAP_CORE128_M6_R1_0/CAP_BOTTOM_112
+ R8W__A44_CAP_CORE128_M6_R1_0/CAP_BOTTOM_113 R8W__A44_CAP_CORE128_M6_R1_0/CAP_BOTTOM_114
+ R8W__A44_CAP_CORE128_M6_R1_0/CAP_BOTTOM_115 R8W__A44_CAP_CORE128_M6_R1_0/CAP_BOTTOM_116
+ R8W__A44_CAP_CORE128_M6_R1_0/CAP_BOTTOM_117 R8W__A44_CAP_CORE128_M6_R1_0/CAP_BOTTOM_118
+ VSUBS R8W__A44_CAP_CORE128_M6_R1_0/CAP_BOTTOM_072 R8W__A44_CAP_CORE128_M6_R1_0/CAP_BOTTOM_073
+ R8W__A44_CAP_CORE128_M6_R1_0/CAP_BOTTOM_074 R8W__A44_CAP_CORE128_M6_R1_0/CAP_BOTTOM_075
+ R8W__A44_CAP_CORE128_M6_R1_0/CAP_BOTTOM_076 R8W__A44_CAP_CORE128_M6_R1_0/CAP_BOTTOM_077
+ R8W__A44_CAP_CORE128_M6_R1_0/CAP_BOTTOM_078 R8W__A44_CAP_CORE128_M6_R1_0/CAP_BOTTOM_103
+ R8W__A44_CAP_CORE128_M6_R1_0/CAP_BOTTOM_104 R8W__A44_CAP_CORE128_M6_R1_0/CAP_BOTTOM_105
+ R8W__A44_CAP_CORE128_M6_R1_0/CAP_BOTTOM_106 R8W__A44_CAP_CORE128_M6_R1_0/CAP_BOTTOM_107
+ R8W__A44_CAP_CORE128_M6_R1_0/CAP_BOTTOM_108 R8W__A44_CAP_CORE128_M6_R1_0/CAP_BOTTOM_109
+ R8W__A44_CAP_CORE128_M6_R1_0/CAP_BOTTOM_110 R8W__A44_CAP_CORE128_M6_R1_0/CAP_BOTTOM_087
+ R8W__A44_CAP_CORE128_M6_R1_0/CAP_BOTTOM_088 R8W__A44_CAP_CORE128_M6_R1_0/CAP_BOTTOM_089
+ R8W__A44_CAP_CORE128_M6_R1_0/CAP_BOTTOM_090 R8W__A44_CAP_CORE128_M6_R1_0/CAP_BOTTOM_091
+ R8W__A44_CAP_CORE128_M6_R1_0/CAP_BOTTOM_092 R8W__A44_CAP_CORE128_M6_R1_0/CAP_BOTTOM_093
+ R8W__A44_CAP_CORE128_M6_R1_0/CAP_BOTTOM_094 R8W__A44_CAP_CORE128_M6_R1_0/CAP_BOTTOM_119
+ R8W__A44_CAP_CORE128_M6_R1_0/CAP_BOTTOM_120 R8W__A44_CAP_CORE128_M6_R1_0/CAP_BOTTOM_121
+ R8W__A44_CAP_CORE128_M6_R1_0/CAP_BOTTOM_122 R8W__A44_CAP_CORE128_M6_R1_0/CAP_BOTTOM_123
+ R8W__A44_CAP_CORE128_M6_R1_0/CAP_BOTTOM_124 R8W__A44_CAP_CORE128_M6_R1_0/CAP_BOTTOM_125
+ R8W__A44_CAP_CORE128_M6_R1_0/CAP_BOTTOM_126 VTOP R8W__A44_CAP_CORE128_M6_R1
.ends

.subckt R8W__pfet_03v3_FKHA32 w_n1018_n310# a_588_n132# a_76_n224# a_524_n224# a_140_n132#
+ a_748_n224# a_n84_n132# a_n372_n224# a_n532_n132# a_n820_n224# a_n932_n118# a_n148_n224#
+ a_364_n132# a_n308_n132# a_n596_n224# a_812_n132# a_n756_n132# a_300_n224#
X0 a_364_n132# a_300_n224# a_140_n132# w_n1018_n310# pfet_03v3 ad=0.6552p pd=2.4u as=0.6552p ps=2.4u w=1.56u l=0.28u
X1 a_140_n132# a_76_n224# a_n84_n132# w_n1018_n310# pfet_03v3 ad=0.6552p pd=2.4u as=0.6552p ps=2.4u w=1.56u l=0.28u
X2 a_812_n132# a_748_n224# a_588_n132# w_n1018_n310# pfet_03v3 ad=0.9269p pd=4.32u as=0.6552p ps=2.4u w=1.56u l=0.28u
X3 a_588_n132# a_524_n224# a_364_n132# w_n1018_n310# pfet_03v3 ad=0.6552p pd=2.4u as=0.6552p ps=2.4u w=1.56u l=0.28u
X4 a_n756_n132# a_n820_n224# a_n932_n118# w_n1018_n310# pfet_03v3 ad=0.6552p pd=2.4u as=0.9269p ps=4.32u w=1.56u l=0.28u
X5 a_n84_n132# a_n148_n224# a_n308_n132# w_n1018_n310# pfet_03v3 ad=0.6552p pd=2.4u as=0.6552p ps=2.4u w=1.56u l=0.28u
X6 a_n532_n132# a_n596_n224# a_n756_n132# w_n1018_n310# pfet_03v3 ad=0.6552p pd=2.4u as=0.6552p ps=2.4u w=1.56u l=0.28u
X7 a_n308_n132# a_n372_n224# a_n532_n132# w_n1018_n310# pfet_03v3 ad=0.6552p pd=2.4u as=0.6552p ps=2.4u w=1.56u l=0.28u
.ends

.subckt R8W__pfet_03v3_X2N4NU a_588_n132# a_76_n224# a_524_n224# w_n794_n310# a_140_n132#
+ a_n84_n132# a_n372_n224# a_n532_n132# a_n148_n224# a_364_n132# a_n308_n132# a_n596_n224#
+ a_300_n224# a_n708_n118#
X0 a_364_n132# a_300_n224# a_140_n132# w_n794_n310# pfet_03v3 ad=0.6552p pd=2.4u as=0.6552p ps=2.4u w=1.56u l=0.28u
X1 a_140_n132# a_76_n224# a_n84_n132# w_n794_n310# pfet_03v3 ad=0.6552p pd=2.4u as=0.6552p ps=2.4u w=1.56u l=0.28u
X2 a_588_n132# a_524_n224# a_364_n132# w_n794_n310# pfet_03v3 ad=0.9269p pd=4.32u as=0.6552p ps=2.4u w=1.56u l=0.28u
X3 a_n84_n132# a_n148_n224# a_n308_n132# w_n794_n310# pfet_03v3 ad=0.6552p pd=2.4u as=0.6552p ps=2.4u w=1.56u l=0.28u
X4 a_n532_n132# a_n596_n224# a_n708_n118# w_n794_n310# pfet_03v3 ad=0.6552p pd=2.4u as=0.9269p ps=4.32u w=1.56u l=0.28u
X5 a_n308_n132# a_n372_n224# a_n532_n132# w_n794_n310# pfet_03v3 ad=0.6552p pd=2.4u as=0.6552p ps=2.4u w=1.56u l=0.28u
.ends

.subckt R8W__nfet_03v3_GE79XY a_n532_n102# a_748_74# a_364_n102# a_n308_n102# a_524_74#
+ a_812_n102# a_n756_n102# a_300_74# a_588_n102# a_n932_n96# a_76_74# a_n148_74# a_n596_74#
+ a_140_n102# a_n84_n102# a_n372_74# a_n820_74# VSUBS
X0 a_140_n102# a_76_74# a_n84_n102# VSUBS nfet_03v3 ad=0.3276p pd=1.62u as=0.3276p ps=1.62u w=0.78u l=0.28u
X1 a_812_n102# a_748_74# a_588_n102# VSUBS nfet_03v3 ad=0.4641p pd=2.76u as=0.3276p ps=1.62u w=0.78u l=0.28u
X2 a_588_n102# a_524_74# a_364_n102# VSUBS nfet_03v3 ad=0.3276p pd=1.62u as=0.3276p ps=1.62u w=0.78u l=0.28u
X3 a_n756_n102# a_n820_74# a_n932_n96# VSUBS nfet_03v3 ad=0.3276p pd=1.62u as=0.4641p ps=2.76u w=0.78u l=0.28u
X4 a_n84_n102# a_n148_74# a_n308_n102# VSUBS nfet_03v3 ad=0.3276p pd=1.62u as=0.3276p ps=1.62u w=0.78u l=0.28u
X5 a_n532_n102# a_n596_74# a_n756_n102# VSUBS nfet_03v3 ad=0.3276p pd=1.62u as=0.3276p ps=1.62u w=0.78u l=0.28u
X6 a_n308_n102# a_n372_74# a_n532_n102# VSUBS nfet_03v3 ad=0.3276p pd=1.62u as=0.3276p ps=1.62u w=0.78u l=0.28u
X7 a_364_n102# a_300_74# a_140_n102# VSUBS nfet_03v3 ad=0.3276p pd=1.62u as=0.3276p ps=1.62u w=0.78u l=0.28u
.ends

.subckt R8W__nfet_03v3_9HSG6M a_n532_n102# a_364_n102# a_n308_n102# a_524_74# a_300_74#
+ a_588_n102# a_n708_n96# a_76_74# a_n148_74# a_n596_74# a_140_n102# a_n84_n102# a_n372_74#
+ VSUBS
X0 a_140_n102# a_76_74# a_n84_n102# VSUBS nfet_03v3 ad=0.3276p pd=1.62u as=0.3276p ps=1.62u w=0.78u l=0.28u
X1 a_588_n102# a_524_74# a_364_n102# VSUBS nfet_03v3 ad=0.4641p pd=2.76u as=0.3276p ps=1.62u w=0.78u l=0.28u
X2 a_n84_n102# a_n148_74# a_n308_n102# VSUBS nfet_03v3 ad=0.3276p pd=1.62u as=0.3276p ps=1.62u w=0.78u l=0.28u
X3 a_n532_n102# a_n596_74# a_n708_n96# VSUBS nfet_03v3 ad=0.3276p pd=1.62u as=0.4641p ps=2.76u w=0.78u l=0.28u
X4 a_n308_n102# a_n372_74# a_n532_n102# VSUBS nfet_03v3 ad=0.3276p pd=1.62u as=0.3276p ps=1.62u w=0.78u l=0.28u
X5 a_364_n102# a_300_74# a_140_n102# VSUBS nfet_03v3 ad=0.3276p pd=1.62u as=0.3276p ps=1.62u w=0.78u l=0.28u
.ends

.subckt R8W__A44_TGDRV_PCLK_ROW_W_R1 CLKS P_CLK VDD GND
XPCLK_P_X8_W_R0 VDD P_CLK net5 net5 P_CLK net5 VDD net5 VDD net5 VDD net5 VDD P_CLK
+ net5 VDD P_CLK net5 R8W__pfet_03v3_FKHA32
XPCLK_P_X2_X4_W_R0 VDD net4 CLKS VDD VDD net5 net4 net5 net4 net4 VDD net4 CLKS VDD
+ R8W__pfet_03v3_X2N4NU
XPCLK_N_X8_W_R0 GND net5 GND P_CLK net5 GND P_CLK net5 P_CLK GND net5 net5 net5 P_CLK
+ GND net5 net5 GND R8W__nfet_03v3_GE79XY
XPCLK_N_X2_X4_W_R0 net5 net4 GND CLKS CLKS GND GND net4 net4 net4 GND net5 net4 GND
+ R8W__nfet_03v3_9HSG6M
.ends

.subckt R8W__pfet_03v3_PUCBRS a_n596_152# a_n372_152# a_140_n180# a_n84_n180# a_76_152#
+ a_n148_152# a_n532_n180# a_972_152# a_n980_n180# a_748_152# a_524_152# a_n1044_152#
+ a_364_n180# a_300_152# a_n820_152# a_n308_n180# a_n1156_n166# a_812_n180# a_n756_n180#
+ w_n1242_n310# a_588_n180# a_1036_n180#
X0 a_364_n180# a_300_152# a_140_n180# w_n1242_n310# pfet_03v3 ad=0.6552p pd=2.4u as=0.6552p ps=2.4u w=1.56u l=0.28u
X1 a_140_n180# a_76_152# a_n84_n180# w_n1242_n310# pfet_03v3 ad=0.6552p pd=2.4u as=0.6552p ps=2.4u w=1.56u l=0.28u
X2 a_812_n180# a_748_152# a_588_n180# w_n1242_n310# pfet_03v3 ad=0.6552p pd=2.4u as=0.6552p ps=2.4u w=1.56u l=0.28u
X3 a_n980_n180# a_n1044_152# a_n1156_n166# w_n1242_n310# pfet_03v3 ad=0.6552p pd=2.4u as=0.9269p ps=4.32u w=1.56u l=0.28u
X4 a_588_n180# a_524_152# a_364_n180# w_n1242_n310# pfet_03v3 ad=0.6552p pd=2.4u as=0.6552p ps=2.4u w=1.56u l=0.28u
X5 a_n756_n180# a_n820_152# a_n980_n180# w_n1242_n310# pfet_03v3 ad=0.6552p pd=2.4u as=0.6552p ps=2.4u w=1.56u l=0.28u
X6 a_1036_n180# a_972_152# a_812_n180# w_n1242_n310# pfet_03v3 ad=0.9269p pd=4.32u as=0.6552p ps=2.4u w=1.56u l=0.28u
X7 a_n84_n180# a_n148_152# a_n308_n180# w_n1242_n310# pfet_03v3 ad=0.6552p pd=2.4u as=0.6552p ps=2.4u w=1.56u l=0.28u
X8 a_n532_n180# a_n596_152# a_n756_n180# w_n1242_n310# pfet_03v3 ad=0.6552p pd=2.4u as=0.6552p ps=2.4u w=1.56u l=0.28u
X9 a_n308_n180# a_n372_152# a_n532_n180# w_n1242_n310# pfet_03v3 ad=0.6552p pd=2.4u as=0.6552p ps=2.4u w=1.56u l=0.28u
.ends

.subckt R8W__nfet_03v3_YTQ48T a_n532_n54# a_748_n146# a_n372_n146# a_n308_n54# a_n820_n146#
+ a_588_n54# a_364_n54# a_n1044_n146# a_n148_n146# a_140_n54# a_n596_n146# a_300_n146#
+ a_1036_n54# a_812_n54# a_76_n146# a_524_n146# a_972_n146# a_n1156_n48# a_n84_n54#
+ a_n980_n54# a_n756_n54# VSUBS
X0 a_n532_n54# a_n596_n146# a_n756_n54# VSUBS nfet_03v3 ad=0.3276p pd=1.62u as=0.3276p ps=1.62u w=0.78u l=0.28u
X1 a_140_n54# a_76_n146# a_n84_n54# VSUBS nfet_03v3 ad=0.3276p pd=1.62u as=0.3276p ps=1.62u w=0.78u l=0.28u
X2 a_588_n54# a_524_n146# a_364_n54# VSUBS nfet_03v3 ad=0.3276p pd=1.62u as=0.3276p ps=1.62u w=0.78u l=0.28u
X3 a_n980_n54# a_n1044_n146# a_n1156_n48# VSUBS nfet_03v3 ad=0.3276p pd=1.62u as=0.4641p ps=2.76u w=0.78u l=0.28u
X4 a_n308_n54# a_n372_n146# a_n532_n54# VSUBS nfet_03v3 ad=0.3276p pd=1.62u as=0.3276p ps=1.62u w=0.78u l=0.28u
X5 a_1036_n54# a_972_n146# a_812_n54# VSUBS nfet_03v3 ad=0.4641p pd=2.76u as=0.3276p ps=1.62u w=0.78u l=0.28u
X6 a_364_n54# a_300_n146# a_140_n54# VSUBS nfet_03v3 ad=0.3276p pd=1.62u as=0.3276p ps=1.62u w=0.78u l=0.28u
X7 a_n756_n54# a_n820_n146# a_n980_n54# VSUBS nfet_03v3 ad=0.3276p pd=1.62u as=0.3276p ps=1.62u w=0.78u l=0.28u
X8 a_n84_n54# a_n148_n146# a_n308_n54# VSUBS nfet_03v3 ad=0.3276p pd=1.62u as=0.3276p ps=1.62u w=0.78u l=0.28u
X9 a_812_n54# a_748_n146# a_588_n54# VSUBS nfet_03v3 ad=0.3276p pd=1.62u as=0.3276p ps=1.62u w=0.78u l=0.28u
.ends

.subckt R8W__pfet_03v3_TTAYZ7 a_n420_n180# w_n682_n310# a_252_n180# a_n196_n180# a_n596_n166#
+ a_188_152# a_476_n180# a_28_n180# a_n484_152# a_n260_152# a_n36_152# a_412_152#
X0 a_n196_n180# a_n260_152# a_n420_n180# w_n682_n310# pfet_03v3 ad=0.6552p pd=2.4u as=0.6552p ps=2.4u w=1.56u l=0.28u
X1 a_28_n180# a_n36_152# a_n196_n180# w_n682_n310# pfet_03v3 ad=0.6552p pd=2.4u as=0.6552p ps=2.4u w=1.56u l=0.28u
X2 a_476_n180# a_412_152# a_252_n180# w_n682_n310# pfet_03v3 ad=0.9269p pd=4.32u as=0.6552p ps=2.4u w=1.56u l=0.28u
X3 a_252_n180# a_188_152# a_28_n180# w_n682_n310# pfet_03v3 ad=0.6552p pd=2.4u as=0.6552p ps=2.4u w=1.56u l=0.28u
X4 a_n420_n180# a_n484_152# a_n596_n166# w_n682_n310# pfet_03v3 ad=0.6552p pd=2.4u as=0.9269p ps=4.32u w=1.56u l=0.28u
.ends

.subckt R8W__nfet_03v3_YTZ44F a_28_n54# a_n596_n48# a_n196_n54# a_n36_n146# a_n484_n146#
+ a_n420_n54# a_412_n146# a_476_n54# a_188_n146# a_252_n54# a_n260_n146# VSUBS
X0 a_n420_n54# a_n484_n146# a_n596_n48# VSUBS nfet_03v3 ad=0.3276p pd=1.62u as=0.4641p ps=2.76u w=0.78u l=0.28u
X1 a_476_n54# a_412_n146# a_252_n54# VSUBS nfet_03v3 ad=0.4641p pd=2.76u as=0.3276p ps=1.62u w=0.78u l=0.28u
X2 a_n196_n54# a_n260_n146# a_n420_n54# VSUBS nfet_03v3 ad=0.3276p pd=1.62u as=0.3276p ps=1.62u w=0.78u l=0.28u
X3 a_252_n54# a_188_n146# a_28_n54# VSUBS nfet_03v3 ad=0.3276p pd=1.62u as=0.3276p ps=1.62u w=0.78u l=0.28u
X4 a_28_n54# a_n36_n146# a_n196_n54# VSUBS nfet_03v3 ad=0.3276p pd=1.62u as=0.3276p ps=1.62u w=0.78u l=0.28u
.ends

.subckt R8W__A44_TGDRV_NCLK_ROW_W_R1 N_CLK CLKS VDD GND
XNCLK_P_X4_X6_W_R0 net3 net3 VDD N_CLK net3 net3 N_CLK net2 N_CLK net2 net2 net3 net3
+ net2 net3 VDD VDD net3 VDD VDD VDD VDD R8W__pfet_03v3_PUCBRS
XNCLK_N_X4_X6_W_R0 N_CLK net2 net3 GND net3 GND net3 net3 net3 GND net3 net2 GND net3
+ net3 net2 net2 GND N_CLK N_CLK GND GND R8W__nfet_03v3_YTQ48T
XNCLK_P_X2_X3_W_R0 VDD VDD net1 net2 net2 CLKS VDD VDD net1 net1 net1 CLKS R8W__pfet_03v3_TTAYZ7
XNCLK_N_X2_X3_W_R0 GND net2 net2 net1 net1 GND CLKS GND CLKS net1 net1 GND R8W__nfet_03v3_YTZ44F
.ends

.subckt R8W__A44_TGCLK_DRIVER_UDRV_W_R1 CLKS N_CLK P_CLK VDD GND
XPCLK_ROW_W_R0 CLKS P_CLK VDD GND R8W__A44_TGDRV_PCLK_ROW_W_R1
XNCLK_ROW_W_R0 N_CLK CLKS VDD GND R8W__A44_TGDRV_NCLK_ROW_W_R1
.ends

.subckt R8W__pfet_03v3_C2L3T7 a_28_1592# a_n36_n1452# a_n36_n2928# a_n148_1653# a_n148_n1299#
+ a_n148_177# a_n36_24# a_28_n1360# w_n234_n3014# a_28_116# a_28_n2836# a_n36_1500#
+ a_n148_n2775#
X0 a_28_1592# a_n36_1500# a_n148_1653# w_n234_n3014# pfet_03v3 ad=3.69235p pd=13.64u as=3.69235p ps=13.64u w=6.22u l=0.28u
X1 a_28_n2836# a_n36_n2928# a_n148_n2775# w_n234_n3014# pfet_03v3 ad=3.69235p pd=13.64u as=3.69235p ps=13.64u w=6.22u l=0.28u
X2 a_28_n1360# a_n36_n1452# a_n148_n1299# w_n234_n3014# pfet_03v3 ad=3.69235p pd=13.64u as=3.69235p ps=13.64u w=6.22u l=0.28u
X3 a_28_116# a_n36_24# a_n148_177# w_n234_n3014# pfet_03v3 ad=3.69235p pd=13.64u as=3.69235p ps=13.64u w=6.22u l=0.28u
.ends

.subckt R8W__nfet_03v3_SD8HJT a_n148_n1514# a_n148_98# a_28_n738# a_n148_n708# a_n36_n902#
+ a_28_68# a_28_874# a_n36_n96# a_n36_1516# a_n36_710# a_28_n1544# a_n148_904# VSUBS
X0 a_28_874# a_n36_1516# a_n148_904# VSUBS nfet_03v3 ad=1.8465p pd=7.42u as=1.8465p ps=7.42u w=3.11u l=0.28u
X1 a_28_68# a_n36_710# a_n148_98# VSUBS nfet_03v3 ad=1.8465p pd=7.42u as=1.8465p ps=7.42u w=3.11u l=0.28u
X2 a_28_n738# a_n36_n96# a_n148_n708# VSUBS nfet_03v3 ad=1.8465p pd=7.42u as=1.8465p ps=7.42u w=3.11u l=0.28u
X3 a_28_n1544# a_n36_n902# a_n148_n1514# VSUBS nfet_03v3 ad=1.8465p pd=7.42u as=1.8465p ps=7.42u w=3.11u l=0.28u
.ends

.subckt R8W__A44_TG8_CORE_W_R2 VDD GND VOUT VIN N_CLK P_CLK
XXTG_TRANS_PMOS_M4_0_R0 VOUT P_CLK P_CLK VIN VIN VIN P_CLK VOUT VDD VOUT VOUT P_CLK
+ VIN R8W__pfet_03v3_C2L3T7
XXTG_TRANS_NMOS_M4_0_R0 VIN VIN VOUT VIN N_CLK VOUT VOUT N_CLK N_CLK N_CLK VOUT VIN
+ GND R8W__nfet_03v3_SD8HJT
XXTG_TRANS_PMOS_M4_1_R0 VOUT P_CLK P_CLK VIN VIN VIN P_CLK VOUT VDD VOUT VOUT P_CLK
+ VIN R8W__pfet_03v3_C2L3T7
XXTG_TRANS_NMOS_M4_1_R0 VIN VIN VOUT VIN N_CLK VOUT VOUT N_CLK N_CLK N_CLK VOUT VIN
+ GND R8W__nfet_03v3_SD8HJT
.ends

.subckt R8W__A44_TG8_SLICE_UDRV_W_R1 VOUT VDD GND CLKS VIN
XXTG_UDRV_W_R0 CLKS XTG_UDRV_W_R0/N_CLK XTG_UDRV_W_R0/P_CLK VDD GND R8W__A44_TGCLK_DRIVER_UDRV_W_R1
XXTG_FIXED_CORE_W_R0 VDD GND VOUT VIN XTG_UDRV_W_R0/N_CLK XTG_UDRV_W_R0/P_CLK R8W__A44_TG8_CORE_W_R2
.ends

.subckt R8W__nfet_03v3_6LX9QF a_n148_n585# a_n36_618# a_28_n646# VSUBS
X0 a_28_n646# a_n36_618# a_n148_n585# VSUBS nfet_03v3 ad=3.69235p pd=13.64u as=3.69235p ps=13.64u w=6.22u l=0.28u
.ends

.subckt R8W__pfet_03v3_GXTH48 a_n148_n422# a_n36_n559# a_28_n467# w_n234_n645#
X0 a_28_n467# a_n36_n559# a_n148_n422# w_n234_n645# pfet_03v3 ad=2.77275p pd=10.54u as=2.77275p ps=10.54u w=4.67u l=0.28u
.ends

.subckt R8W__nfet_03v3_WHE5HU a_n148_n236# a_n36_230# a_28_n258# VSUBS
X0 a_28_n258# a_n36_230# a_n148_n236# VSUBS nfet_03v3 ad=1.3897p pd=5.88u as=1.3897p ps=5.88u w=2.34u l=0.28u
.ends

.subckt R8W__pfet_03v3_8RS7KV w_n234_n1422# a_n36_n1336# a_n148_n1121# a_28_n1244#
X0 a_28_n1244# a_n36_n1336# a_n148_n1121# w_n234_n1422# pfet_03v3 ad=7.38405p pd=26.08u as=7.38405p ps=26.08u w=12.44u l=0.28u
.ends

.subckt R8W__A44_DCTRL_BIT_DRIVER_R4 VDD GND CTRL_IN CTRL_OUT
XXDCTRL_INV2_NMOS_R0 GND MID CTRL_OUT GND R8W__nfet_03v3_6LX9QF
XXDCTRL_INV1_PMOS_R0 VDD CTRL_IN MID VDD R8W__pfet_03v3_GXTH48
XXDCTRL_INV1_NMOS_R0 GND CTRL_IN MID GND R8W__nfet_03v3_WHE5HU
XXDCTRL_INV2_PMOS_R0 VDD MID VDD CTRL_OUT R8W__pfet_03v3_8RS7KV
.ends

.subckt R8W__A44_DCTRL_STRIP_W_R2 VDD CTRL_OUT[1] CTRL_OUT[2] CTRL_OUT[3] CTRL_OUT[4]
+ CTRL_OUT[5] CTRL_OUT[6] CTRL_OUT[7] CTRL_IN[1] CTRL_IN[2] CTRL_IN[3] CTRL_IN[4]
+ CTRL_IN[5] CTRL_IN[6] CTRL_IN[7] GND
XXDCTRL_CH2_R0 VDD GND CTRL_IN[2] CTRL_OUT[2] R8W__A44_DCTRL_BIT_DRIVER_R4
XXDCTRL_CH5_R0 VDD GND CTRL_IN[5] CTRL_OUT[5] R8W__A44_DCTRL_BIT_DRIVER_R4
XXDCTRL_CH3_R0 VDD GND CTRL_IN[3] CTRL_OUT[3] R8W__A44_DCTRL_BIT_DRIVER_R4
XXDCTRL_CH6_R0 VDD GND CTRL_IN[6] CTRL_OUT[6] R8W__A44_DCTRL_BIT_DRIVER_R4
XXDCTRL_CH1_R0 VDD GND CTRL_IN[1] CTRL_OUT[1] R8W__A44_DCTRL_BIT_DRIVER_R4
XXDCTRL_CH4_R0 VDD GND CTRL_IN[4] CTRL_OUT[4] R8W__A44_DCTRL_BIT_DRIVER_R4
XXDCTRL_CH7_R0 VDD GND CTRL_IN[7] CTRL_OUT[7] R8W__A44_DCTRL_BIT_DRIVER_R4
.ends

.subckt A44_CDAC_UNIT_W_R8_M6 R8W__A44_DCTRL_STRIP_W_R2_0/VDD R8W__A44_DCTRL_STRIP_W_R2_0/CTRL_IN[4]
+ R8W__A44_TG8_SLICE_UDRV_W_R1_0/CLKS R8W__A44_DCTRL_STRIP_W_R2_0/CTRL_IN[7] R8W__A44_TG8_SLICE_UDRV_W_R1_0/VOUT
+ R8W__A44_DCTRL_STRIP_W_R2_0/CTRL_IN[5] R8W__A44_DCTRL_STRIP_W_R2_0/CTRL_IN[2] R8W__A44_DCTRL_STRIP_W_R2_0/CTRL_IN[6]
+ R8W__A44_CDAC_CAP_BANK_ASSEMBLY_R8_M6_0/R8W__A44_SW_BANK64_SOUTH_R8_M6_0/VREFN R8W__A44_TG8_SLICE_UDRV_W_R1_0/VIN
+ R8W__A44_DCTRL_STRIP_W_R2_0/CTRL_IN[3] R8W__A44_CDAC_CAP_BANK_ASSEMBLY_R8_M6_0/R8W__A44_SW_BANK64_SOUTH_R8_M6_0/VREFP
+ R8W__A44_DCTRL_STRIP_W_R2_0/CTRL_IN[1] VSUBS
XR8W__A44_CDAC_CAP_BANK_ASSEMBLY_R8_M6_0 R8W__A44_CDAC_CAP_BANK_ASSEMBLY_R8_M6_0/R8W__A44_SW_BANK64_SOUTH_R8_M6_0/VREFP
+ R8W__A44_DCTRL_STRIP_W_R2_0/CTRL_OUT[5] R8W__A44_DCTRL_STRIP_W_R2_0/CTRL_OUT[7]
+ R8W__A44_DCTRL_STRIP_W_R2_0/CTRL_OUT[7] R8W__A44_DCTRL_STRIP_W_R2_0/CTRL_OUT[5]
+ R8W__A44_DCTRL_STRIP_W_R2_0/CTRL_OUT[7] R8W__A44_DCTRL_STRIP_W_R2_0/CTRL_OUT[6]
+ R8W__A44_DCTRL_STRIP_W_R2_0/CTRL_OUT[7] R8W__A44_DCTRL_STRIP_W_R2_0/CTRL_OUT[7]
+ R8W__A44_DCTRL_STRIP_W_R2_0/CTRL_OUT[7] R8W__A44_DCTRL_STRIP_W_R2_0/CTRL_OUT[6]
+ R8W__A44_DCTRL_STRIP_W_R2_0/CTRL_OUT[7] R8W__A44_DCTRL_STRIP_W_R2_0/CTRL_OUT[5]
+ R8W__A44_DCTRL_STRIP_W_R2_0/CTRL_OUT[4] R8W__A44_DCTRL_STRIP_W_R2_0/CTRL_OUT[7]
+ R8W__A44_DCTRL_STRIP_W_R2_0/CTRL_OUT[7] R8W__A44_DCTRL_STRIP_W_R2_0/CTRL_OUT[6]
+ R8W__A44_DCTRL_STRIP_W_R2_0/CTRL_OUT[6] R8W__A44_DCTRL_STRIP_W_R2_0/CTRL_OUT[6]
+ R8W__A44_DCTRL_STRIP_W_R2_0/CTRL_OUT[5] R8W__A44_DCTRL_STRIP_W_R2_0/CTRL_OUT[2]
+ R8W__A44_DCTRL_STRIP_W_R2_0/CTRL_OUT[7] R8W__A44_DCTRL_STRIP_W_R2_0/CTRL_OUT[7]
+ R8W__A44_DCTRL_STRIP_W_R2_0/CTRL_OUT[7] R8W__A44_DCTRL_STRIP_W_R2_0/CTRL_OUT[7]
+ R8W__A44_DCTRL_STRIP_W_R2_0/CTRL_OUT[7] R8W__A44_DCTRL_STRIP_W_R2_0/CTRL_OUT[7]
+ R8W__A44_DCTRL_STRIP_W_R2_0/CTRL_OUT[6] R8W__A44_DCTRL_STRIP_W_R2_0/CTRL_OUT[5]
+ R8W__A44_DCTRL_STRIP_W_R2_0/CTRL_OUT[7] R8W__A44_DCTRL_STRIP_W_R2_0/CTRL_OUT[7]
+ R8W__A44_DCTRL_STRIP_W_R2_0/CTRL_OUT[7] R8W__A44_DCTRL_STRIP_W_R2_0/CTRL_OUT[7]
+ R8W__A44_DCTRL_STRIP_W_R2_0/CTRL_OUT[7] R8W__A44_DCTRL_STRIP_W_R2_0/CTRL_OUT[6]
+ R8W__A44_DCTRL_STRIP_W_R2_0/CTRL_OUT[6] R8W__A44_DCTRL_STRIP_W_R2_0/CTRL_OUT[6]
+ R8W__A44_DCTRL_STRIP_W_R2_0/CTRL_OUT[6] R8W__A44_DCTRL_STRIP_W_R2_0/CTRL_OUT[5]
+ R8W__A44_DCTRL_STRIP_W_R2_0/CTRL_OUT[7] R8W__A44_DCTRL_STRIP_W_R2_0/CTRL_OUT[7]
+ R8W__A44_DCTRL_STRIP_W_R2_0/CTRL_OUT[7] R8W__A44_DCTRL_STRIP_W_R2_0/CTRL_OUT[7]
+ R8W__A44_DCTRL_STRIP_W_R2_0/CTRL_OUT[7] R8W__A44_DCTRL_STRIP_W_R2_0/CTRL_OUT[6]
+ R8W__A44_DCTRL_STRIP_W_R2_0/CTRL_OUT[6] R8W__A44_DCTRL_STRIP_W_R2_0/CTRL_OUT[6]
+ R8W__A44_DCTRL_STRIP_W_R2_0/CTRL_OUT[6] R8W__A44_DCTRL_STRIP_W_R2_0/CTRL_OUT[3]
+ R8W__A44_DCTRL_STRIP_W_R2_0/CTRL_OUT[5] R8W__A44_DCTRL_STRIP_W_R2_0/CTRL_OUT[4]
+ R8W__A44_DCTRL_STRIP_W_R2_0/CTRL_OUT[4] R8W__A44_DCTRL_STRIP_W_R2_0/CTRL_OUT[7]
+ R8W__A44_DCTRL_STRIP_W_R2_0/CTRL_OUT[7] R8W__A44_DCTRL_STRIP_W_R2_0/CTRL_OUT[7]
+ R8W__A44_DCTRL_STRIP_W_R2_0/CTRL_OUT[7] R8W__A44_DCTRL_STRIP_W_R2_0/CTRL_OUT[7]
+ R8W__A44_DCTRL_STRIP_W_R2_0/CTRL_OUT[6] R8W__A44_DCTRL_STRIP_W_R2_0/CTRL_OUT[1]
+ R8W__A44_DCTRL_STRIP_W_R2_0/CTRL_OUT[3] R8W__A44_DCTRL_STRIP_W_R2_0/CTRL_OUT[5]
+ R8W__A44_DCTRL_STRIP_W_R2_0/CTRL_OUT[4] R8W__A44_DCTRL_STRIP_W_R2_0/CTRL_OUT[7]
+ R8W__A44_DCTRL_STRIP_W_R2_0/CTRL_OUT[7] R8W__A44_DCTRL_STRIP_W_R2_0/CTRL_OUT[7]
+ R8W__A44_DCTRL_STRIP_W_R2_0/CTRL_OUT[7] R8W__A44_DCTRL_STRIP_W_R2_0/CTRL_OUT[6]
+ R8W__A44_DCTRL_STRIP_W_R2_0/CTRL_OUT[5] R8W__A44_DCTRL_STRIP_W_R2_0/CTRL_OUT[7]
+ R8W__A44_DCTRL_STRIP_W_R2_0/CTRL_OUT[7] R8W__A44_DCTRL_STRIP_W_R2_0/CTRL_OUT[7]
+ R8W__A44_DCTRL_STRIP_W_R2_0/CTRL_OUT[7] R8W__A44_DCTRL_STRIP_W_R2_0/CTRL_OUT[7]
+ R8W__A44_DCTRL_STRIP_W_R2_0/CTRL_OUT[6] R8W__A44_DCTRL_STRIP_W_R2_0/CTRL_OUT[6]
+ R8W__A44_DCTRL_STRIP_W_R2_0/CTRL_OUT[5] R8W__A44_DCTRL_STRIP_W_R2_0/CTRL_OUT[7]
+ R8W__A44_DCTRL_STRIP_W_R2_0/CTRL_OUT[7] R8W__A44_DCTRL_STRIP_W_R2_0/CTRL_OUT[7]
+ R8W__A44_DCTRL_STRIP_W_R2_0/CTRL_OUT[6] R8W__A44_DCTRL_STRIP_W_R2_0/CTRL_OUT[6]
+ R8W__A44_DCTRL_STRIP_W_R2_0/CTRL_OUT[6] R8W__A44_DCTRL_STRIP_W_R2_0/CTRL_OUT[3]
+ R8W__A44_DCTRL_STRIP_W_R2_0/CTRL_OUT[5] R8W__A44_DCTRL_STRIP_W_R2_0/CTRL_OUT[4]
+ R8W__A44_DCTRL_STRIP_W_R2_0/CTRL_OUT[7] R8W__A44_DCTRL_STRIP_W_R2_0/CTRL_OUT[7]
+ R8W__A44_DCTRL_STRIP_W_R2_0/CTRL_OUT[7] R8W__A44_DCTRL_STRIP_W_R2_0/CTRL_OUT[7]
+ R8W__A44_DCTRL_STRIP_W_R2_0/CTRL_OUT[4] R8W__A44_DCTRL_STRIP_W_R2_0/CTRL_OUT[4]
+ R8W__A44_DCTRL_STRIP_W_R2_0/CTRL_OUT[7] R8W__A44_DCTRL_STRIP_W_R2_0/CTRL_OUT[7]
+ R8W__A44_DCTRL_STRIP_W_R2_0/CTRL_OUT[6] R8W__A44_DCTRL_STRIP_W_R2_0/CTRL_OUT[6]
+ R8W__A44_CDAC_CAP_BANK_ASSEMBLY_R8_M6_0/R8W__A44_SW_BANK64_SOUTH_R8_M6_0/VREFP R8W__A44_DCTRL_STRIP_W_R2_0/CTRL_OUT[7]
+ R8W__A44_DCTRL_STRIP_W_R2_0/CTRL_OUT[6] R8W__A44_DCTRL_STRIP_W_R2_0/CTRL_OUT[7]
+ R8W__A44_DCTRL_STRIP_W_R2_0/CTRL_OUT[6] R8W__A44_DCTRL_STRIP_W_R2_0/CTRL_OUT[5]
+ R8W__A44_DCTRL_STRIP_W_R2_0/CTRL_OUT[7] R8W__A44_CDAC_CAP_BANK_ASSEMBLY_R8_M6_0/R8W__A44_SW_BANK64_SOUTH_R8_M6_0/VREFN
+ R8W__A44_DCTRL_STRIP_W_R2_0/CTRL_OUT[7] R8W__A44_DCTRL_STRIP_W_R2_0/CTRL_OUT[5]
+ R8W__A44_DCTRL_STRIP_W_R2_0/CTRL_OUT[6] R8W__A44_DCTRL_STRIP_W_R2_0/CTRL_OUT[7]
+ R8W__A44_DCTRL_STRIP_W_R2_0/CTRL_OUT[7] R8W__A44_DCTRL_STRIP_W_R2_0/CTRL_OUT[5]
+ R8W__A44_DCTRL_STRIP_W_R2_0/CTRL_OUT[6] R8W__A44_DCTRL_STRIP_W_R2_0/CTRL_OUT[7]
+ R8W__A44_DCTRL_STRIP_W_R2_0/CTRL_OUT[7] R8W__A44_DCTRL_STRIP_W_R2_0/VDD R8W__A44_DCTRL_STRIP_W_R2_0/CTRL_OUT[5]
+ R8W__A44_DCTRL_STRIP_W_R2_0/CTRL_OUT[7] R8W__A44_DCTRL_STRIP_W_R2_0/CTRL_OUT[6]
+ R8W__A44_DCTRL_STRIP_W_R2_0/CTRL_OUT[3] R8W__A44_DCTRL_STRIP_W_R2_0/CTRL_OUT[7]
+ R8W__A44_DCTRL_STRIP_W_R2_0/CTRL_OUT[7] R8W__A44_DCTRL_STRIP_W_R2_0/CTRL_OUT[5]
+ R8W__A44_DCTRL_STRIP_W_R2_0/CTRL_OUT[7] R8W__A44_DCTRL_STRIP_W_R2_0/CTRL_OUT[6]
+ R8W__A44_DCTRL_STRIP_W_R2_0/CTRL_OUT[7] R8W__A44_DCTRL_STRIP_W_R2_0/CTRL_OUT[7]
+ R8W__A44_CDAC_CAP_BANK_ASSEMBLY_R8_M6_0/R8W__A44_SW_BANK64_SOUTH_R8_M6_0/VREFN R8W__A44_DCTRL_STRIP_W_R2_0/CTRL_OUT[6]
+ R8W__A44_DCTRL_STRIP_W_R2_0/CTRL_OUT[2] R8W__A44_DCTRL_STRIP_W_R2_0/CTRL_OUT[7]
+ R8W__A44_DCTRL_STRIP_W_R2_0/CTRL_OUT[6] R8W__A44_DCTRL_STRIP_W_R2_0/CTRL_OUT[4]
+ R8W__A44_DCTRL_STRIP_W_R2_0/CTRL_OUT[6] R8W__A44_DCTRL_STRIP_W_R2_0/VDD R8W__A44_DCTRL_STRIP_W_R2_0/CTRL_OUT[7]
+ VSUBS R8W__A44_TG8_SLICE_UDRV_W_R1_0/VOUT R8W__A44_CDAC_CAP_BANK_ASSEMBLY_R8_M6
XR8W__A44_TG8_SLICE_UDRV_W_R1_0 R8W__A44_TG8_SLICE_UDRV_W_R1_0/VOUT R8W__A44_DCTRL_STRIP_W_R2_0/VDD
+ VSUBS R8W__A44_TG8_SLICE_UDRV_W_R1_0/CLKS R8W__A44_TG8_SLICE_UDRV_W_R1_0/VIN R8W__A44_TG8_SLICE_UDRV_W_R1
XR8W__A44_DCTRL_STRIP_W_R2_0 R8W__A44_DCTRL_STRIP_W_R2_0/VDD R8W__A44_DCTRL_STRIP_W_R2_0/CTRL_OUT[1]
+ R8W__A44_DCTRL_STRIP_W_R2_0/CTRL_OUT[2] R8W__A44_DCTRL_STRIP_W_R2_0/CTRL_OUT[3]
+ R8W__A44_DCTRL_STRIP_W_R2_0/CTRL_OUT[4] R8W__A44_DCTRL_STRIP_W_R2_0/CTRL_OUT[5]
+ R8W__A44_DCTRL_STRIP_W_R2_0/CTRL_OUT[6] R8W__A44_DCTRL_STRIP_W_R2_0/CTRL_OUT[7]
+ R8W__A44_DCTRL_STRIP_W_R2_0/CTRL_IN[1] R8W__A44_DCTRL_STRIP_W_R2_0/CTRL_IN[2] R8W__A44_DCTRL_STRIP_W_R2_0/CTRL_IN[3]
+ R8W__A44_DCTRL_STRIP_W_R2_0/CTRL_IN[4] R8W__A44_DCTRL_STRIP_W_R2_0/CTRL_IN[5] R8W__A44_DCTRL_STRIP_W_R2_0/CTRL_IN[6]
+ R8W__A44_DCTRL_STRIP_W_R2_0/CTRL_IN[7] VSUBS R8W__A44_DCTRL_STRIP_W_R2
.ends

.subckt A44_CDAC_UNIT_W_R7 A44_CDAC_UNIT_W_R8_M6_0/R8W__A44_TG8_SLICE_UDRV_W_R1_0/CLKS
+ A44_CDAC_UNIT_W_R8_M6_0/R8W__A44_TG8_SLICE_UDRV_W_R1_0/VOUT A44_CDAC_UNIT_W_R8_M6_0/R8W__A44_CDAC_CAP_BANK_ASSEMBLY_R8_M6_0/R8W__A44_SW_BANK64_SOUTH_R8_M6_0/VREFN
+ A44_CDAC_UNIT_W_R8_M6_0/R8W__A44_DCTRL_STRIP_W_R2_0/CTRL_IN[6] A44_CDAC_UNIT_W_R8_M6_0/R8W__A44_DCTRL_STRIP_W_R2_0/VDD
+ A44_CDAC_UNIT_W_R8_M6_0/R8W__A44_DCTRL_STRIP_W_R2_0/CTRL_IN[2] A44_CDAC_UNIT_W_R8_M6_0/R8W__A44_CDAC_CAP_BANK_ASSEMBLY_R8_M6_0/R8W__A44_SW_BANK64_SOUTH_R8_M6_0/VREFP
+ A44_CDAC_UNIT_W_R8_M6_0/R8W__A44_DCTRL_STRIP_W_R2_0/CTRL_IN[3] A44_CDAC_UNIT_W_R8_M6_0/R8W__A44_DCTRL_STRIP_W_R2_0/CTRL_IN[1]
+ A44_CDAC_UNIT_W_R8_M6_0/R8W__A44_DCTRL_STRIP_W_R2_0/CTRL_IN[4] A44_CDAC_UNIT_W_R8_M6_0/R8W__A44_TG8_SLICE_UDRV_W_R1_0/VIN
+ A44_CDAC_UNIT_W_R8_M6_0/R8W__A44_DCTRL_STRIP_W_R2_0/CTRL_IN[7] A44_CDAC_UNIT_W_R8_M6_0/R8W__A44_DCTRL_STRIP_W_R2_0/CTRL_IN[5]
+ VSUBS
XA44_CDAC_UNIT_W_R8_M6_0 A44_CDAC_UNIT_W_R8_M6_0/R8W__A44_DCTRL_STRIP_W_R2_0/VDD A44_CDAC_UNIT_W_R8_M6_0/R8W__A44_DCTRL_STRIP_W_R2_0/CTRL_IN[4]
+ A44_CDAC_UNIT_W_R8_M6_0/R8W__A44_TG8_SLICE_UDRV_W_R1_0/CLKS A44_CDAC_UNIT_W_R8_M6_0/R8W__A44_DCTRL_STRIP_W_R2_0/CTRL_IN[7]
+ A44_CDAC_UNIT_W_R8_M6_0/R8W__A44_TG8_SLICE_UDRV_W_R1_0/VOUT A44_CDAC_UNIT_W_R8_M6_0/R8W__A44_DCTRL_STRIP_W_R2_0/CTRL_IN[5]
+ A44_CDAC_UNIT_W_R8_M6_0/R8W__A44_DCTRL_STRIP_W_R2_0/CTRL_IN[2] A44_CDAC_UNIT_W_R8_M6_0/R8W__A44_DCTRL_STRIP_W_R2_0/CTRL_IN[6]
+ A44_CDAC_UNIT_W_R8_M6_0/R8W__A44_CDAC_CAP_BANK_ASSEMBLY_R8_M6_0/R8W__A44_SW_BANK64_SOUTH_R8_M6_0/VREFN
+ A44_CDAC_UNIT_W_R8_M6_0/R8W__A44_TG8_SLICE_UDRV_W_R1_0/VIN A44_CDAC_UNIT_W_R8_M6_0/R8W__A44_DCTRL_STRIP_W_R2_0/CTRL_IN[3]
+ A44_CDAC_UNIT_W_R8_M6_0/R8W__A44_CDAC_CAP_BANK_ASSEMBLY_R8_M6_0/R8W__A44_SW_BANK64_SOUTH_R8_M6_0/VREFP
+ A44_CDAC_UNIT_W_R8_M6_0/R8W__A44_DCTRL_STRIP_W_R2_0/CTRL_IN[1] VSUBS A44_CDAC_UNIT_W_R8_M6
.ends

.subckt A44_CLKS_BUFFER_R1 PAD_CLK VDD GND CLKS_CORE
X0 GND PAD_CLK INTER_PAD GND nfet_03v3 ad=0.4641p pd=2.76u as=0.4641p ps=2.76u w=0.78u l=0.28u
X1 VDD PAD_CLK INTER_PAD VDD pfet_03v3 ad=0.9269p pd=4.32u as=0.9269p ps=4.32u w=1.56u l=0.28u
X2 VDD INTER_PAD CLKS_CORE VDD pfet_03v3 ad=3.69235p pd=13.64u as=3.69235p ps=13.64u w=6.22u l=0.28u
X3 GND INTER_PAD CLKS_CORE GND nfet_03v3 ad=1.8465p pd=7.42u as=1.8465p ps=7.42u w=3.11u l=0.28u
.ends

.subckt A44_COMP_PEX_ECO1_SD_REQUIRED_G6_FULL_R9 CLK VINP VINN DCMPP DCMPN VDD GND
X0 LP CLK VDD VDD pfet_03v3 ad=3.61565p pd=13.38u as=2.5578p ps=6.93u w=6.09u l=0.28u
X1 XP VINP net1 GND nfet_03v3 ad=8.0489p pd=28.32u as=5.6952p ps=14.4u w=13.56u l=0.28u
X2 net1 VINN XN GND nfet_03v3 ad=5.6952p pd=14.4u as=8.0489p ps=28.32u w=13.56u l=0.28u
X3 net1 VINP XP GND nfet_03v3 ad=0.6552p pd=2.4u as=0.6552p ps=2.4u w=1.56u l=0.28u
X4 XN VINN net1 GND nfet_03v3 ad=8.0489p pd=28.32u as=5.6952p ps=14.4u w=13.56u l=0.28u
X5 net1 VINP XP GND nfet_03v3 ad=5.6952p pd=14.4u as=8.0489p ps=28.32u w=13.56u l=0.28u
X6 LP LN VDD VDD pfet_03v3 ad=0.6552p pd=2.4u as=0.6552p ps=2.4u w=1.56u l=0.28u
X7 net1 CLK GND GND nfet_03v3 ad=0.6552p pd=2.4u as=0.6552p ps=2.4u w=1.56u l=0.28u
X8 net1 VINN XN GND nfet_03v3 ad=5.6952p pd=14.4u as=8.0489p ps=28.32u w=13.56u l=0.28u
X9 DCMPP LP GND GND nfet_03v3 ad=0.4641p pd=2.76u as=0.3276p ps=1.62u w=0.78u l=0.28u
X10 XN LP LN GND nfet_03v3 ad=0.60015p pd=3.22u as=0.60015p ps=3.22u w=1.01u l=0.28u
X11 XP VINP net1 GND nfet_03v3 ad=8.0489p pd=28.32u as=5.6952p ps=14.4u w=13.56u l=0.28u
X12 net1 VINP XP GND nfet_03v3 ad=5.6952p pd=14.4u as=8.0489p ps=28.32u w=13.56u l=0.28u
X13 net1 VINN XN GND nfet_03v3 ad=5.6952p pd=14.4u as=8.0489p ps=28.32u w=13.56u l=0.28u
X14 VDD CLK XP VDD pfet_03v3 ad=0.3276p pd=1.62u as=0.4641p ps=2.76u w=0.78u l=0.28u
X15 LN CLK VDD VDD pfet_03v3 ad=0.6552p pd=2.4u as=0.92625p ps=4.32u w=1.56u l=0.28u
X16 net1 VINP XP GND nfet_03v3 ad=5.6952p pd=14.4u as=8.0489p ps=28.32u w=13.56u l=0.28u
X17 GND LN DCMPN GND nfet_03v3 ad=0.3276p pd=1.62u as=0.4641p ps=2.76u w=0.78u l=0.28u
X18 VDD LN LP VDD pfet_03v3 ad=0.3276p pd=1.62u as=0.3276p ps=1.62u w=0.78u l=0.28u
X19 XP VINP net1 GND nfet_03v3 ad=0.6552p pd=2.4u as=0.6552p ps=2.4u w=1.56u l=0.28u
X20 VDD CLK LN VDD pfet_03v3 ad=0.92625p pd=4.32u as=0.6552p ps=2.4u w=1.56u l=0.28u
X21 VDD CLK XN VDD pfet_03v3 ad=0.3276p pd=1.62u as=0.4641p ps=2.76u w=0.78u l=0.28u
X22 VDD CLK LP VDD pfet_03v3 ad=0.4641p pd=2.76u as=0.3276p ps=1.62u w=0.78u l=0.28u
X23 XP LN LP GND nfet_03v3 ad=0.6552p pd=2.4u as=0.9269p ps=4.32u w=1.56u l=0.28u
X24 net1 VINN XN GND nfet_03v3 ad=5.6952p pd=14.4u as=8.0489p ps=28.32u w=13.56u l=0.28u
X25 XP LN LP GND nfet_03v3 ad=0.60015p pd=3.22u as=0.60015p ps=3.22u w=1.01u l=0.28u
X26 GND CLK net1 GND nfet_03v3 ad=0.6552p pd=2.4u as=0.6552p ps=2.4u w=1.56u l=0.28u
X27 LN LP XN GND nfet_03v3 ad=0.60015p pd=3.22u as=0.60015p ps=3.22u w=1.01u l=0.28u
X28 VDD LP DCMPP VDD pfet_03v3 ad=0.9828p pd=3.18u as=1.38905p ps=5.88u w=2.34u l=0.28u
X29 XN CLK VDD VDD pfet_03v3 ad=0.4641p pd=2.76u as=0.3276p ps=1.62u w=0.78u l=0.28u
X30 LN LP XN GND nfet_03v3 ad=0.9269p pd=4.32u as=0.6552p ps=2.4u w=1.56u l=0.28u
X31 XN VINN net1 GND nfet_03v3 ad=8.0489p pd=28.32u as=5.6952p ps=14.4u w=13.56u l=0.28u
X32 LP CLK VDD VDD pfet_03v3 ad=0.3276p pd=1.62u as=0.4641p ps=2.76u w=0.78u l=0.28u
X33 LN LP VDD VDD pfet_03v3 ad=0.3276p pd=1.62u as=0.3276p ps=1.62u w=0.78u l=0.28u
X34 XP CLK VDD VDD pfet_03v3 ad=0.4641p pd=2.76u as=0.3276p ps=1.62u w=0.78u l=0.28u
X35 net1 VINP XP GND nfet_03v3 ad=0.6552p pd=2.4u as=0.6552p ps=2.4u w=1.56u l=0.28u
X36 XN LP LN GND nfet_03v3 ad=0.6552p pd=2.4u as=0.9269p ps=4.32u w=1.56u l=0.28u
X37 GND CLK net1 GND nfet_03v3 ad=0.6552p pd=2.4u as=0.6552p ps=2.4u w=1.56u l=0.28u
X38 XP VINP net1 GND nfet_03v3 ad=8.0489p pd=28.32u as=5.6952p ps=14.4u w=13.56u l=0.28u
X39 net1 CLK GND GND nfet_03v3 ad=0.6552p pd=2.4u as=0.6552p ps=2.4u w=1.56u l=0.28u
X40 LP LN XP GND nfet_03v3 ad=0.9269p pd=4.32u as=0.6552p ps=2.4u w=1.56u l=0.28u
X41 XN VINN net1 GND nfet_03v3 ad=8.0489p pd=28.32u as=5.6952p ps=14.4u w=13.56u l=0.28u
X42 VDD CLK LP VDD pfet_03v3 ad=2.5578p pd=6.93u as=3.61565p ps=13.38u w=6.09u l=0.28u
X43 net1 CLK GND GND nfet_03v3 ad=0.6552p pd=2.4u as=0.6552p ps=2.4u w=1.56u l=0.28u
X44 net1 VINN XN GND nfet_03v3 ad=0.6552p pd=2.4u as=0.6552p ps=2.4u w=1.56u l=0.28u
X45 XN VINN net1 GND nfet_03v3 ad=8.0489p pd=28.32u as=5.6952p ps=14.4u w=13.56u l=0.28u
X46 DCMPN LN VDD VDD pfet_03v3 ad=1.38905p pd=5.88u as=0.9828p ps=3.18u w=2.34u l=0.28u
X47 VDD CLK LP VDD pfet_03v3 ad=0.92625p pd=4.32u as=0.6552p ps=2.4u w=1.56u l=0.28u
X48 LP LN XP GND nfet_03v3 ad=0.60015p pd=3.22u as=0.60015p ps=3.22u w=1.01u l=0.28u
X49 XN VINN net1 GND nfet_03v3 ad=0.6552p pd=2.4u as=0.6552p ps=2.4u w=1.56u l=0.28u
X50 XP VINP net1 GND nfet_03v3 ad=8.0489p pd=28.32u as=5.6952p ps=14.4u w=13.56u l=0.28u
X51 net1 VINP XP GND nfet_03v3 ad=5.6952p pd=14.4u as=8.0489p ps=28.32u w=13.56u l=0.28u
X52 XN LP LN GND nfet_03v3 ad=0.6552p pd=2.4u as=0.9269p ps=4.32u w=1.56u l=0.28u
X53 GND CLK net1 GND nfet_03v3 ad=0.6552p pd=2.4u as=0.6552p ps=2.4u w=1.56u l=0.28u
X54 net1 VINP XP GND nfet_03v3 ad=5.6952p pd=14.4u as=8.0489p ps=28.32u w=13.56u l=0.28u
X55 DCMPP LP VDD VDD pfet_03v3 ad=1.38905p pd=5.88u as=0.9828p ps=3.18u w=2.34u l=0.28u
X56 LN CLK VDD VDD pfet_03v3 ad=3.61565p pd=13.38u as=2.5578p ps=6.93u w=6.09u l=0.28u
X57 VDD LN LP VDD pfet_03v3 ad=0.6552p pd=2.4u as=0.6552p ps=2.4u w=1.56u l=0.28u
X58 VDD LP LN VDD pfet_03v3 ad=0.3276p pd=1.62u as=0.3276p ps=1.62u w=0.78u l=0.28u
X59 XP VINP net1 GND nfet_03v3 ad=8.0489p pd=28.32u as=5.6952p ps=14.4u w=13.56u l=0.28u
X60 XN VINN net1 GND nfet_03v3 ad=8.0489p pd=28.32u as=5.6952p ps=14.4u w=13.56u l=0.28u
X61 net1 VINN XN GND nfet_03v3 ad=5.6952p pd=14.4u as=8.0489p ps=28.32u w=13.56u l=0.28u
X62 net1 VINN XN GND nfet_03v3 ad=0.6552p pd=2.4u as=0.6552p ps=2.4u w=1.56u l=0.28u
X63 VDD LN DCMPN VDD pfet_03v3 ad=0.9828p pd=3.18u as=1.38905p ps=5.88u w=2.34u l=0.28u
X64 LP CLK VDD VDD pfet_03v3 ad=0.6552p pd=2.4u as=0.92625p ps=4.32u w=1.56u l=0.28u
X65 LP LN VDD VDD pfet_03v3 ad=0.3276p pd=1.62u as=0.3276p ps=1.62u w=0.78u l=0.28u
X66 LP LN XP GND nfet_03v3 ad=0.9269p pd=4.32u as=0.6552p ps=2.4u w=1.56u l=0.28u
X67 net1 CLK GND GND nfet_03v3 ad=0.6552p pd=2.4u as=0.6552p ps=2.4u w=1.56u l=0.28u
X68 net1 VINP XP GND nfet_03v3 ad=5.6952p pd=14.4u as=8.0489p ps=28.32u w=13.56u l=0.28u
X69 LN LP VDD VDD pfet_03v3 ad=0.6552p pd=2.4u as=0.6552p ps=2.4u w=1.56u l=0.28u
X70 GND LP DCMPP GND nfet_03v3 ad=0.3276p pd=1.62u as=0.4641p ps=2.76u w=0.78u l=0.28u
X71 XN VINN net1 GND nfet_03v3 ad=8.0489p pd=28.32u as=5.6952p ps=14.4u w=13.56u l=0.28u
X72 net1 VINN XN GND nfet_03v3 ad=5.6952p pd=14.4u as=8.0489p ps=28.32u w=13.56u l=0.28u
X73 VDD CLK LN VDD pfet_03v3 ad=0.4641p pd=2.76u as=0.3276p ps=1.62u w=0.78u l=0.28u
X74 LN CLK VDD VDD pfet_03v3 ad=0.3276p pd=1.62u as=0.4641p ps=2.76u w=0.78u l=0.28u
X75 LN LP XN GND nfet_03v3 ad=0.9269p pd=4.32u as=0.6552p ps=2.4u w=1.56u l=0.28u
X76 XN VINN net1 GND nfet_03v3 ad=8.0489p pd=28.32u as=5.6952p ps=14.4u w=13.56u l=0.28u
X77 XN VINN net1 GND nfet_03v3 ad=8.0489p pd=28.32u as=5.6952p ps=14.4u w=13.56u l=0.28u
X78 XP VINP net1 GND nfet_03v3 ad=0.6552p pd=2.4u as=0.6552p ps=2.4u w=1.56u l=0.28u
X79 net1 VINP XP GND nfet_03v3 ad=5.6952p pd=14.4u as=8.0489p ps=28.32u w=13.56u l=0.28u
X80 VDD CLK LN VDD pfet_03v3 ad=2.5578p pd=6.93u as=3.61565p ps=13.38u w=6.09u l=0.28u
X81 net1 VINP XP GND nfet_03v3 ad=5.6952p pd=14.4u as=8.0489p ps=28.32u w=13.56u l=0.28u
X82 XP VINP net1 GND nfet_03v3 ad=8.0489p pd=28.32u as=5.6952p ps=14.4u w=13.56u l=0.28u
X83 XP LN LP GND nfet_03v3 ad=0.6552p pd=2.4u as=0.9269p ps=4.32u w=1.56u l=0.28u
X84 GND CLK net1 GND nfet_03v3 ad=0.6552p pd=2.4u as=0.6552p ps=2.4u w=1.56u l=0.28u
X85 XP VINP net1 GND nfet_03v3 ad=8.0489p pd=28.32u as=5.6952p ps=14.4u w=13.56u l=0.28u
X86 VDD LP LN VDD pfet_03v3 ad=0.6552p pd=2.4u as=0.6552p ps=2.4u w=1.56u l=0.28u
X87 XN VINN net1 GND nfet_03v3 ad=0.6552p pd=2.4u as=0.6552p ps=2.4u w=1.56u l=0.28u
X88 net1 VINN XN GND nfet_03v3 ad=5.6952p pd=14.4u as=8.0489p ps=28.32u w=13.56u l=0.28u
X89 XP VINP net1 GND nfet_03v3 ad=8.0489p pd=28.32u as=5.6952p ps=14.4u w=13.56u l=0.28u
X90 net1 VINN XN GND nfet_03v3 ad=5.6952p pd=14.4u as=8.0489p ps=28.32u w=13.56u l=0.28u
X91 DCMPN LN GND GND nfet_03v3 ad=0.4641p pd=2.76u as=0.3276p ps=1.62u w=0.78u l=0.28u
.ends

.subckt A44_SAR_ADC_CORE_1000_R3_DUMMY_FILL_REPAIR VINP VINN VDD GND VREFP VREFN DOUT[7]
+ DOUT[6] DOUT[5] DOUT[4] DOUT[3] DOUT[2] DOUT[1] DOUT[0] CLKS
XXSAR DCTRLN[1] DCTRLN[2] DCTRLN[3] DCTRLN[4] DCTRLN[5] DCTRLN[6] DCTRLN[7] DCTRLP[1]
+ DCTRLP[2] DCTRLP[3] DCTRLP[4] DCTRLP[5] DCTRLP[6] DCTRLP[7] CLKS_CORE CMPCK DCMPN
+ DCMPP DOUT[0] DOUT[1] DOUT[2] DOUT[3] DOUT[4] DOUT[5] DOUT[6] DOUT[7] VDD GND SAR_LOGIC_ACTUAL_RTL_SS
XXCDAC_N VDD DCTRLN[7] VFON DCTRLN[1] DCTRLN[6] DCTRLN[3] DCTRLN[5] VREFP DCTRLN[2]
+ DCTRLN[4] CLKS_CORE VREFN VINN GND A44_CDAC_UNIT_E_R7
XXCDAC_P CLKS_CORE VFOP VREFN DCTRLP[6] VDD DCTRLP[2] VREFP DCTRLP[3] DCTRLP[1] DCTRLP[4]
+ VINP DCTRLP[7] DCTRLP[5] GND A44_CDAC_UNIT_W_R7
XXCLKS_BUFFER CLKS VDD GND CLKS_CORE A44_CLKS_BUFFER_R1
XXCOMP CMPCK VFOP VFON DCMPP DCMPN VDD GND A44_COMP_PEX_ECO1_SD_REQUIRED_G6_FULL_R9
.ends

.subckt gf180mcu_fd_sc_mcu7t5v0__tieh Z VDD VSS VNW VPW
X0 Z a_125_24# VDD VNW pfet_05v0 ad=0.5368p pd=3.32u as=0.5368p ps=3.32u w=1.22u l=0.5u
X1 a_125_24# a_125_24# VSS VPW nfet_05v0 ad=0.3608p pd=2.52u as=0.3608p ps=2.52u w=0.82u l=0.6u
.ends

.subckt A44_A GND VDD CLKS_PU CLKS_PD CLKS DOUT_CS[7] DOUT_SL[7] DOUT_IE[7] DOUT_OE[7]
+ DOUT_PU[7] DOUT_PD[7] DOUT_OUT[7] DOUT_PDRV0[7] DOUT_PDRV1[7] DOUT_IN[7] DOUT_CS[6]
+ DOUT_SL[6] DOUT_IE[6] DOUT_OE[6] DOUT_PU[6] DOUT_PD[6] DOUT_OUT[6] DOUT_PDRV0[6]
+ DOUT_PDRV1[6] DOUT_IN[6] DOUT_CS[5] DOUT_SL[5] DOUT_IE[5] DOUT_OE[5] DOUT_PU[5]
+ DOUT_PD[5] DOUT_OUT[5] DOUT_PDRV0[5] DOUT_PDRV1[5] DOUT_IN[5] DOUT_CS[4] DOUT_SL[4]
+ DOUT_IE[4] DOUT_OE[4] DOUT_PU[4] DOUT_PD[4] DOUT_OUT[4] DOUT_PDRV0[4] DOUT_PDRV1[4]
+ DOUT_IN[4] DOUT_CS[3] DOUT_SL[3] DOUT_IE[3] DOUT_OE[3] DOUT_PU[3] DOUT_PD[3] DOUT_OUT[3]
+ DOUT_PDRV0[3] DOUT_PDRV1[3] DOUT_IN[3] DOUT_CS[2] DOUT_SL[2] DOUT_IE[2] DOUT_OE[2]
+ DOUT_PU[2] DOUT_PD[2] DOUT_OUT[2] DOUT_PDRV0[2] DOUT_PDRV1[2] DOUT_IN[2] DOUT_CS[1]
+ DOUT_SL[1] DOUT_IE[1] DOUT_OE[1] DOUT_PU[1] DOUT_PD[1] DOUT_OUT[1] DOUT_PDRV0[1]
+ DOUT_PDRV1[1] DOUT_IN[1] DOUT_CS[0] DOUT_SL[0] DOUT_IE[0] DOUT_OE[0] DOUT_PU[0]
+ DOUT_PD[0] DOUT_OUT[0] DOUT_PDRV0[0] DOUT_PDRV1[0] DOUT_IN[0] VREFN VINN VINP VREFP
XXTIE_DOUT_PDRV0_7 DOUT_PDRV0[7] VDD GND VDD GND gf180mcu_fd_sc_mcu7t5v0__tiel
XXTIE_DOUT_CS_0 DOUT_CS[0] VDD GND VDD GND gf180mcu_fd_sc_mcu7t5v0__tiel
XXTIE_DOUT_CS_1 DOUT_CS[1] VDD GND VDD GND gf180mcu_fd_sc_mcu7t5v0__tiel
XXTIE_DOUT_CS_2 DOUT_CS[2] VDD GND VDD GND gf180mcu_fd_sc_mcu7t5v0__tiel
XXTIE_DOUT_CS_3 DOUT_CS[3] VDD GND VDD GND gf180mcu_fd_sc_mcu7t5v0__tiel
XXTIE_DOUT_CS_4 DOUT_CS[4] VDD GND VDD GND gf180mcu_fd_sc_mcu7t5v0__tiel
XXTIE_DOUT_CS_5 DOUT_CS[5] VDD GND VDD GND gf180mcu_fd_sc_mcu7t5v0__tiel
XXTIE_DOUT_CS_6 DOUT_CS[6] VDD GND VDD GND gf180mcu_fd_sc_mcu7t5v0__tiel
XXTIE_DOUT_CS_7 DOUT_CS[7] VDD GND VDD GND gf180mcu_fd_sc_mcu7t5v0__tiel
XXTIE_DOUT_PDRV1_0 DOUT_PDRV1[0] VDD GND VDD GND gf180mcu_fd_sc_mcu7t5v0__tiel
XXTIE_DOUT_PDRV1_1 DOUT_PDRV1[1] VDD GND VDD GND gf180mcu_fd_sc_mcu7t5v0__tiel
XXTIE_DOUT_SL_0 DOUT_SL[0] VDD GND VDD GND gf180mcu_fd_sc_mcu7t5v0__tiel
XXTIE_DOUT_PDRV1_2 DOUT_PDRV1[2] VDD GND VDD GND gf180mcu_fd_sc_mcu7t5v0__tiel
XXTIE_CLKS_PD CLKS_PD VDD GND VDD GND gf180mcu_fd_sc_mcu7t5v0__tiel
XXTIE_DOUT_SL_1 DOUT_SL[1] VDD GND VDD GND gf180mcu_fd_sc_mcu7t5v0__tiel
XXTIE_DOUT_PDRV1_3 DOUT_PDRV1[3] VDD GND VDD GND gf180mcu_fd_sc_mcu7t5v0__tiel
XXTIE_DOUT_SL_2 DOUT_SL[2] VDD GND VDD GND gf180mcu_fd_sc_mcu7t5v0__tiel
XXTIE_DOUT_PDRV1_4 DOUT_PDRV1[4] VDD GND VDD GND gf180mcu_fd_sc_mcu7t5v0__tiel
XXTIE_DOUT_PU_0 DOUT_PU[0] VDD GND VDD GND gf180mcu_fd_sc_mcu7t5v0__tiel
XXCORE VINP VINN VDD GND VREFP VREFN DOUT_OUT[7] DOUT_OUT[6] DOUT_OUT[5] DOUT_OUT[4]
+ DOUT_OUT[3] DOUT_OUT[2] DOUT_OUT[1] DOUT_OUT[0] CLKS A44_SAR_ADC_CORE_1000_R3_DUMMY_FILL_REPAIR
XXTIE_DOUT_SL_3 DOUT_SL[3] VDD GND VDD GND gf180mcu_fd_sc_mcu7t5v0__tiel
XXTIE_DOUT_PDRV1_5 DOUT_PDRV1[5] VDD GND VDD GND gf180mcu_fd_sc_mcu7t5v0__tiel
XXTIE_DOUT_PU_1 DOUT_PU[1] VDD GND VDD GND gf180mcu_fd_sc_mcu7t5v0__tiel
XXTIE_DOUT_SL_4 DOUT_SL[4] VDD GND VDD GND gf180mcu_fd_sc_mcu7t5v0__tiel
XXTIE_DOUT_PDRV1_6 DOUT_PDRV1[6] VDD GND VDD GND gf180mcu_fd_sc_mcu7t5v0__tiel
XXTIE_DOUT_SL_5 DOUT_SL[5] VDD GND VDD GND gf180mcu_fd_sc_mcu7t5v0__tiel
XXTIE_DOUT_PU_2 DOUT_PU[2] VDD GND VDD GND gf180mcu_fd_sc_mcu7t5v0__tiel
XXTIE_DOUT_PDRV1_7 DOUT_PDRV1[7] VDD GND VDD GND gf180mcu_fd_sc_mcu7t5v0__tiel
XXTIE_DOUT_SL_6 DOUT_SL[6] VDD GND VDD GND gf180mcu_fd_sc_mcu7t5v0__tiel
XXTIE_DOUT_PU_3 DOUT_PU[3] VDD GND VDD GND gf180mcu_fd_sc_mcu7t5v0__tiel
XXTIE_DOUT_SL_7 DOUT_SL[7] VDD GND VDD GND gf180mcu_fd_sc_mcu7t5v0__tiel
XXTIE_DOUT_PU_4 DOUT_PU[4] VDD GND VDD GND gf180mcu_fd_sc_mcu7t5v0__tiel
XXTIE_DOUT_PU_5 DOUT_PU[5] VDD GND VDD GND gf180mcu_fd_sc_mcu7t5v0__tiel
XXTIE_DOUT_PU_6 DOUT_PU[6] VDD GND VDD GND gf180mcu_fd_sc_mcu7t5v0__tiel
XXTIE_DOUT_PU_7 DOUT_PU[7] VDD GND VDD GND gf180mcu_fd_sc_mcu7t5v0__tiel
XXTIE_DOUT_PD_0 DOUT_PD[0] VDD GND VDD GND gf180mcu_fd_sc_mcu7t5v0__tiel
XXTIE_DOUT_PD_1 DOUT_PD[1] VDD GND VDD GND gf180mcu_fd_sc_mcu7t5v0__tiel
XXTIE_DOUT_PD_2 DOUT_PD[2] VDD GND VDD GND gf180mcu_fd_sc_mcu7t5v0__tiel
XXTIE_DOUT_IE_0 DOUT_IE[0] VDD GND VDD GND gf180mcu_fd_sc_mcu7t5v0__tiel
XXTIE_DOUT_PD_3 DOUT_PD[3] VDD GND VDD GND gf180mcu_fd_sc_mcu7t5v0__tiel
XXTIE_DOUT_IE_1 DOUT_IE[1] VDD GND VDD GND gf180mcu_fd_sc_mcu7t5v0__tiel
XXTIE_DOUT_PD_4 DOUT_PD[4] VDD GND VDD GND gf180mcu_fd_sc_mcu7t5v0__tiel
XXTIE_DOUT_OE_0 DOUT_OE[0] VDD GND VDD GND gf180mcu_fd_sc_mcu7t5v0__tieh
XXTIE_DOUT_PD_5 DOUT_PD[5] VDD GND VDD GND gf180mcu_fd_sc_mcu7t5v0__tiel
XXTIE_DOUT_IE_2 DOUT_IE[2] VDD GND VDD GND gf180mcu_fd_sc_mcu7t5v0__tiel
XXTIE_DOUT_OE_1 DOUT_OE[1] VDD GND VDD GND gf180mcu_fd_sc_mcu7t5v0__tieh
XXTIE_CLKS_PU CLKS_PU VDD GND VDD GND gf180mcu_fd_sc_mcu7t5v0__tiel
XXTIE_DOUT_IE_3 DOUT_IE[3] VDD GND VDD GND gf180mcu_fd_sc_mcu7t5v0__tiel
XXTIE_DOUT_PDRV0_0 DOUT_PDRV0[0] VDD GND VDD GND gf180mcu_fd_sc_mcu7t5v0__tiel
XXTIE_DOUT_PD_6 DOUT_PD[6] VDD GND VDD GND gf180mcu_fd_sc_mcu7t5v0__tiel
XXTIE_DOUT_OE_2 DOUT_OE[2] VDD GND VDD GND gf180mcu_fd_sc_mcu7t5v0__tieh
XXTIE_DOUT_PDRV0_1 DOUT_PDRV0[1] VDD GND VDD GND gf180mcu_fd_sc_mcu7t5v0__tiel
XXTIE_DOUT_PD_7 DOUT_PD[7] VDD GND VDD GND gf180mcu_fd_sc_mcu7t5v0__tiel
XXTIE_DOUT_IE_4 DOUT_IE[4] VDD GND VDD GND gf180mcu_fd_sc_mcu7t5v0__tiel
XXTIE_DOUT_OE_3 DOUT_OE[3] VDD GND VDD GND gf180mcu_fd_sc_mcu7t5v0__tieh
XXTIE_DOUT_IE_5 DOUT_IE[5] VDD GND VDD GND gf180mcu_fd_sc_mcu7t5v0__tiel
XXTIE_DOUT_OE_4 DOUT_OE[4] VDD GND VDD GND gf180mcu_fd_sc_mcu7t5v0__tieh
XXTIE_DOUT_PDRV0_2 DOUT_PDRV0[2] VDD GND VDD GND gf180mcu_fd_sc_mcu7t5v0__tiel
XXTIE_DOUT_IE_6 DOUT_IE[6] VDD GND VDD GND gf180mcu_fd_sc_mcu7t5v0__tiel
XXTIE_DOUT_PDRV0_3 DOUT_PDRV0[3] VDD GND VDD GND gf180mcu_fd_sc_mcu7t5v0__tiel
XXTIE_DOUT_OE_5 DOUT_OE[5] VDD GND VDD GND gf180mcu_fd_sc_mcu7t5v0__tieh
XXTIE_DOUT_IE_7 DOUT_IE[7] VDD GND VDD GND gf180mcu_fd_sc_mcu7t5v0__tiel
XXTIE_DOUT_OE_6 DOUT_OE[6] VDD GND VDD GND gf180mcu_fd_sc_mcu7t5v0__tieh
XXTIE_DOUT_PDRV0_4 DOUT_PDRV0[4] VDD GND VDD GND gf180mcu_fd_sc_mcu7t5v0__tiel
XXTIE_DOUT_PDRV0_5 DOUT_PDRV0[5] VDD GND VDD GND gf180mcu_fd_sc_mcu7t5v0__tiel
XXTIE_DOUT_OE_7 DOUT_OE[7] VDD GND VDD GND gf180mcu_fd_sc_mcu7t5v0__tieh
XXTIE_DOUT_PDRV0_6 DOUT_PDRV0[6] VDD GND VDD GND gf180mcu_fd_sc_mcu7t5v0__tiel
.ends
